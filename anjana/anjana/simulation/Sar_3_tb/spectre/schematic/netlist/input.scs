// Design: NS_SAR_test/Sar_3_tb
simulator lang=spectre
global 0
parameters Vdd=1 M=13 N=1024 CYCLES_PER_SAMPLE=4 SAMPLE_FREQ=51M Avin=.5 OFFSET=.5 - 0.0625 CLK_FREQ=SAMPLE_FREQ*CYCLES_PER_SAMPLE t_stop=1.1*N/SAMPLE_FREQ SignalFreq=M*SAMPLE_FREQ/N

// NS_SAR_test/Sar_3_tb/schematic
I1 (Vin CLK D\<4\> D\<3\> D\<2\> D\<1\> D\<0\> EOC) ns_sar_model Vref=1 N=3 Vth=0.5 OSR=4 Vhigh=1
V1 (CLK 0) vsource type=pulse val0=0 val1=1 period=1/CLK_FREQ delay=1n rise=10p fall=10p width=0.5/CLK_FREQ
V3 (VREF 0) vsource dc=Vdd type=dc
V0 (Vin 0) vsource dc=OFFSET type=sine ampl=Avin freq=SignalFreq
I2 (EOC 0 0 0 0 0 D\<4\> D\<3\> D\<2\> D\<1\> D\<0\>) adc_csv_logger vth=0.5 filename="/home/user23/NS_SAR_ADC/simulation/adc_output.csv"
simulatorOptions options temp=27
tran tran stop=t_stop errpreset=moderate
ahdl_include "/home/user23/NS_SAR_ADC/libraries/NS_SAR_test/NS_SAR_V1/veriloga/veriloga.va"
ahdl_include "/home/user23/NS_SAR_ADC/libraries/NS_SAR_test/data_logger/veriloga/veriloga.va"
