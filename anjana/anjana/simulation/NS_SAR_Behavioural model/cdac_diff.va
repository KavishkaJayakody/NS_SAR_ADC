// ---------------------------------------------------------------------------
// cdac_diff.va  --  PLACEHOLDER differential CDAC (replace with the real core)
//
// The whole array is modelled as ONE capacitor per side whose bottom plate is
// driven to the weighted code voltage.  That is exactly equivalent to a binary
// array for charge purposes, and -- critically -- it keeps topp/topn as REAL
// FLOATING NODES, so the FIR's charge-sharing summation behaves correctly.
//
// Do NOT replace this with a behavioural residue equation.  If topp/topn are
// driven by a voltage source, A_CS collapses and the notch disappears.
//
// Bottom-plate sampling:
//   phi_s high : top plates -> vcm through a switch, bottom plates -> vin
//   phi_s low  : bottom plates -> vcm +/- d/2,  top plates float
//
// Resulting differential residue:   V(topp,topn) = d - vin_diff
// so cmp_out = 1 (topp > topn) means the DAC trial is too large.  This matches
// sar_logic's default cmp_pol = 1.
// ---------------------------------------------------------------------------
`include "constants.vams"
`include "disciplines.vams"

module cdac_diff(topp, topn, vinp, vinn, vcm, dac_code, phi_s, prn_bit);
    inout  topp, topn;
    input  vinp, vinn, vcm, phi_s, prn_bit;
    input  [8:0] dac_code;
    electrical topp, topn, vinp, vinn, vcm, phi_s, prn_bit;
    electrical [8:0] dac_code;

    parameter real    cdac  = 1.0p   from (0:inf); // total cap per side
    parameter integer nb    = 9      from [2:9];
    parameter real    vref  = 1.0    from (0:inf); // differential full scale
    parameter real    vdith = 0.0    from [0:inf); // dither, e.g. vref/64
    parameter real    ron_s = 100.0  from (0:inf); // sampling switch
    parameter real    roff  = 1.0e12 from (0:inf);
    parameter real    vth   = 0.55;
    parameter real    ttran = 20.0p  from (0:inf);

    electrical botp, botn;
    integer i, code;
    real d, dith, gs, sfrac, vbp, vbn;

    analog begin
        code = 0;
        for (i = 0; i < nb; i = i + 1)
            code = code + ((V(dac_code[i]) > vth) ? (1 << i) : 0);

        sfrac = code / pow(2.0, nb) - 0.5;          // -0.5 .. +0.5
        dith  = (V(prn_bit) > vth) ? vdith : -vdith;
        d     = vref * sfrac + dith;                // differential DAC output

        vbp = (V(phi_s) > vth) ? V(vinp) : V(vcm) + 0.5 * d;
        vbn = (V(phi_s) > vth) ? V(vinn) : V(vcm) - 0.5 * d;

        V(botp) <+ vbp;
        V(botn) <+ vbn;

        // the array
        I(topp, botp) <+ cdac * ddt(V(topp, botp));
        I(topn, botn) <+ cdac * ddt(V(topn, botn));

        // top-plate sampling switches
        gs = (V(phi_s) > vth) ? 1.0/ron_s : 1.0/roff;
        I(topp, vcm) <+ transition(gs, 0.0, ttran, ttran) * V(topp, vcm);
        I(topn, vcm) <+ transition(gs, 0.0, ttran, ttran) * V(topn, vcm);
    end
endmodule
