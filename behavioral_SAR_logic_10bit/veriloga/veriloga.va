// VerilogA for FYP_22, behavioral_SAR_logic_10bit, veriloga

`include "constants.vams"
`include "disciplines.vams"

// Logic Levels from your code
`define LOGIC_Vinput 1.8
`define LOGIC_Vref   0.0
`define LOGIC_gnd    1.8
`define LOGIC_sample 1.8
`define LOGIC_hold   0.0
`define HIGH         1.8
`define LOW          0.0

module behavioral_SAR_logic_10bit(CLK, COMP, B0, B1, B2, B3, B4, B5, B6, B7, B8, B9, CPC, CP0, CP1, CP2, CP3, CP4, CP5, CP6, CP7, CP8, CP9, CNC, CN0, CN1, CN2, CN3, CN4, CN5, CN6, CN7, CN8, CN9, SP, SN);
    input CLK, COMP;
    output B0, B1, B2, B3, B4, B5, B6, B7, B8, B9;
    output CPC, CP0, CP1, CP2, CP3, CP4, CP5, CP6, CP7, CP8, CP9;
    output CNC, CN0, CN1, CN2, CN3, CN4, CN5, CN6, CN7, CN8, CN9;
    output SP, SN;

    electrical CLK, COMP, B0, B1, B2, B3, B4, B5, B6, B7, B8, B9, CPC, CP0, CP1, CP2, CP3, CP4, CP5, CP6, CP7, CP8, CP9, CNC, CN0, CN1, CN2, CN3, CN4, CN5, CN6, CN7, CN8, CN9, SP, SN;

    // Registers (Manual definitions for all 10 bits)
    real regp0, regp1, regp2, regp3, regp4, regp5, regp6, regp7, regp8, regp9;
    real regn0, regn1, regn2, regn3, regn4, regn5, regn6, regn7, regn8, regn9;
    real dat0, dat1, dat2, dat3, dat4, dat5, dat6, dat7, dat8, dat9;
    real out0, out1, out2, out3, out4, out5, out6, out7, out8, out9;
    real regpc, regnc, regps, regns;
    real prev_p, prev_n;

    parameter real Vth = 0.5;
    parameter real td = 100p;
    parameter real tr = 100p;

    integer state;

    // Manual State Definitions
    parameter SAMPLE   = 0;
    parameter SET_BIT9 = 1;  parameter CHK_BIT9 = 2;
    parameter SET_BIT8 = 3;  parameter CHK_BIT8 = 4;
    parameter SET_BIT7 = 5;  parameter CHK_BIT7 = 6;
    parameter SET_BIT6 = 7;  parameter CHK_BIT6 = 8;
    parameter SET_BIT5 = 9;  parameter CHK_BIT5 = 10;
    parameter SET_BIT4 = 11; parameter CHK_BIT4 = 12;
    parameter SET_BIT3 = 13; parameter CHK_BIT3 = 14;
    parameter SET_BIT2 = 15; parameter CHK_BIT2 = 16;
    parameter SET_BIT1 = 17; parameter CHK_BIT1 = 18;
    parameter SET_BIT0 = 19; parameter CHK_BIT0 = 20;
    parameter DONE     = 21;

    analog begin
        @(initial_step) begin
            state = SAMPLE;
            regp9=0; regp8=0; regp7=0; regp6=0; regp5=0; regp4=0; regp3=0; regp2=0; regp1=0; regp0=0;
            regn9=0; regn8=0; regn7=0; regn6=0; regn5=0; regn4=0; regn3=0; regn2=0; regn1=0; regn0=0;
            dat9=0; dat8=0; dat7=0; dat6=0; dat5=0; dat4=0; dat3=0; dat2=0; dat1=0; dat0=0;
            out9=0; out8=0; out7=0; out6=0; out5=0; out4=0; out3=0; out2=0; out1=0; out0=0;
            regpc=0; regnc=0; regps=0; regns=0; prev_p=0; prev_n=0;
        end

        // --- RISING EDGE: Trial Phase ---
        @(cross(V(CLK) - 0.5, +1)) begin
            if (state == SAMPLE) begin
                regps = `LOGIC_sample; regns = `LOGIC_sample;
                regpc = `LOGIC_Vinput; regnc = `LOGIC_Vinput;
                regp9=`LOGIC_Vinput; regp8=`LOGIC_Vinput; regp7=`LOGIC_Vinput; regp6=`LOGIC_Vinput; regp5=`LOGIC_Vinput;
                regp4=`LOGIC_Vinput; regp3=`LOGIC_Vinput; regp2=`LOGIC_Vinput; regp1=`LOGIC_Vinput; regp0=`LOGIC_Vinput;
                regn9=`LOGIC_Vinput; regn8=`LOGIC_Vinput; regn7=`LOGIC_Vinput; regn6=`LOGIC_Vinput; regn5=`LOGIC_Vinput;
                regn4=`LOGIC_Vinput; regn3=`LOGIC_Vinput; regn2=`LOGIC_Vinput; regn1=`LOGIC_Vinput; regn0=`LOGIC_Vinput;
                state = SET_BIT9;
            end
            else if (state == SET_BIT9) begin
                regps = `LOGIC_hold; regns = `LOGIC_hold;
                regp9 = `LOGIC_Vref; regnc = `LOGIC_Vref; regpc = `LOGIC_gnd;
                regp8=`LOGIC_gnd; regp7=`LOGIC_gnd; regp6=`LOGIC_gnd; regp5=`LOGIC_gnd; regp4=`LOGIC_gnd;
                regp3=`LOGIC_gnd; regp2=`LOGIC_gnd; regp1=`LOGIC_gnd; regp0=`LOGIC_gnd;
                regn9=`LOGIC_gnd; regn8=`LOGIC_Vref; regn7=`LOGIC_Vref; regn6=`LOGIC_Vref; regn5=`LOGIC_Vref;
                regn4=`LOGIC_Vref; regn3=`LOGIC_Vref; regn2=`LOGIC_Vref; regn1=`LOGIC_Vref; regn0=`LOGIC_Vref;
                state = CHK_BIT9;
            end
            else if (state == SET_BIT8) begin regp9=prev_p; regn9=prev_n; regp8=`LOGIC_Vref; regn8=`LOGIC_gnd; state=CHK_BIT8; end
            else if (state == SET_BIT7) begin regp8=prev_p; regn8=prev_n; regp7=`LOGIC_Vref; regn7=`LOGIC_gnd; state=CHK_BIT7; end
            else if (state == SET_BIT6) begin regp7=prev_p; regn7=prev_n; regp6=`LOGIC_Vref; regn6=`LOGIC_gnd; state=CHK_BIT6; end
            else if (state == SET_BIT5) begin regp6=prev_p; regn6=prev_n; regp5=`LOGIC_Vref; regn5=`LOGIC_gnd; state=CHK_BIT5; end
            else if (state == SET_BIT4) begin regp5=prev_p; regn5=prev_n; regp4=`LOGIC_Vref; regn4=`LOGIC_gnd; state=CHK_BIT4; end
            else if (state == SET_BIT3) begin regp4=prev_p; regn4=prev_n; regp3=`LOGIC_Vref; regn3=`LOGIC_gnd; state=CHK_BIT3; end
            else if (state == SET_BIT2) begin regp3=prev_p; regn3=prev_n; regp2=`LOGIC_Vref; regn2=`LOGIC_gnd; state=CHK_BIT2; end
            else if (state == SET_BIT1) begin regp2=prev_p; regn2=prev_n; regp1=`LOGIC_Vref; regn1=`LOGIC_gnd; state=CHK_BIT1; end
            else if (state == SET_BIT0) begin regp1=prev_p; regn1=prev_n; regp0=`LOGIC_Vref; regn0=`LOGIC_gnd; state=CHK_BIT0; end
            else if (state == DONE) begin
                regp0 = prev_p; regn0 = prev_n;
                out9=dat9; out8=dat8; out7=dat7; out6=dat6; out5=dat5; out4=dat4; out3=dat3; out2=dat2; out1=dat1; out0=dat0;
                state = SAMPLE;
            end
        end

        // --- FALLING EDGE: Decision Phase ---
        @(cross(V(CLK) - 0.5, -1)) begin
            if (state == CHK_BIT9) begin
                if (V(COMP) > Vth) begin dat9=`HIGH; prev_p=`LOGIC_Vref; prev_n=`LOGIC_gnd; end
                else               begin dat9=`LOW;  prev_p=`LOGIC_gnd;  prev_n=`LOGIC_Vref; end
                state = SET_BIT8;
            end
            else if (state == CHK_BIT8) begin
                if (V(COMP) > Vth) begin dat8=`HIGH; prev_p=`LOGIC_Vref; prev_n=`LOGIC_gnd; end
                else               begin dat8=`LOW;  prev_p=`LOGIC_gnd;  prev_n=`LOGIC_Vref; end
                state = SET_BIT7;
            end
            else if (state == CHK_BIT7) begin
                if (V(COMP) > Vth) begin dat7=`HIGH; prev_p=`LOGIC_Vref; prev_n=`LOGIC_gnd; end
                else               begin dat7=`LOW;  prev_p=`LOGIC_gnd;  prev_n=`LOGIC_Vref; end
                state = SET_BIT6;
            end
            else if (state == CHK_BIT6) begin
                if (V(COMP) > Vth) begin dat6=`HIGH; prev_p=`LOGIC_Vref; prev_n=`LOGIC_gnd; end
                else               begin dat6=`LOW;  prev_p=`LOGIC_gnd;  prev_n=`LOGIC_Vref; end
                state = SET_BIT5;
            end
            else if (state == CHK_BIT5) begin
                if (V(COMP) > Vth) begin dat5=`HIGH; prev_p=`LOGIC_Vref; prev_n=`LOGIC_gnd; end
                else               begin dat5=`LOW;  prev_p=`LOGIC_gnd;  prev_n=`LOGIC_Vref; end
                state = SET_BIT4;
            end
            else if (state == CHK_BIT4) begin
                if (V(COMP) > Vth) begin dat4=`HIGH; prev_p=`LOGIC_Vref; prev_n=`LOGIC_gnd; end
                else               begin dat4=`LOW;  prev_p=`LOGIC_gnd;  prev_n=`LOGIC_Vref; end
                state = SET_BIT3;
            end
            else if (state == CHK_BIT3) begin
                if (V(COMP) > Vth) begin dat3=`HIGH; prev_p=`LOGIC_Vref; prev_n=`LOGIC_gnd; end
                else               begin dat3=`LOW;  prev_p=`LOGIC_gnd;  prev_n=`LOGIC_Vref; end
                state = SET_BIT2;
            end
            else if (state == CHK_BIT2) begin
                if (V(COMP) > Vth) begin dat2=`HIGH; prev_p=`LOGIC_Vref; prev_n=`LOGIC_gnd; end
                else               begin dat2=`LOW;  prev_p=`LOGIC_gnd;  prev_n=`LOGIC_Vref; end
                state = SET_BIT1;
            end
            else if (state == CHK_BIT1) begin
                if (V(COMP) > Vth) begin dat1=`HIGH; prev_p=`LOGIC_Vref; prev_n=`LOGIC_gnd; end
                else               begin dat1=`LOW;  prev_p=`LOGIC_gnd;  prev_n=`LOGIC_Vref; end
                state = SET_BIT0;
            end
            else if (state == CHK_BIT0) begin
                if (V(COMP) > Vth) begin dat0=`HIGH; prev_p=`LOGIC_Vref; prev_n=`LOGIC_gnd; end
                else               begin dat0=`LOW;  prev_p=`LOGIC_gnd;  prev_n=`LOGIC_Vref; end
                state = DONE;
            end
        end

        // Output Drive
        V(B9) <+ transition(out9, td, tr); V(B8) <+ transition(out8, td, tr); V(B7) <+ transition(out7, td, tr); V(B6) <+ transition(out6, td, tr); V(B5) <+ transition(out5, td, tr);
        V(B4) <+ transition(out4, td, tr); V(B3) <+ transition(out3, td, tr); V(B2) <+ transition(out2, td, tr); V(B1) <+ transition(out1, td, tr); V(B0) <+ transition(out0, td, tr);

        V(CP9) <+ transition(regp9, td, tr); V(CP8) <+ transition(regp8, td, tr); V(CP7) <+ transition(regp7, td, tr); V(CP6) <+ transition(regp6, td, tr); V(CP5) <+ transition(regp5, td, tr);
        V(CP4) <+ transition(regp4, td, tr); V(CP3) <+ transition(regp3, td, tr); V(CP2) <+ transition(regp2, td, tr); V(CP1) <+ transition(regp1, td, tr); V(CP0) <+ transition(regp0, td, tr);

        V(CN9) <+ transition(regn9, td, tr); V(CN8) <+ transition(regn8, td, tr); V(CN7) <+ transition(regn7, td, tr); V(CN6) <+ transition(regn6, td, tr); V(CN5) <+ transition(regn5, td, tr);
        V(CN4) <+ transition(regn4, td, tr); V(CN3) <+ transition(regn3, td, tr); V(CN2) <+ transition(regn2, td, tr); V(CN1) <+ transition(regn1, td, tr); V(CN0) <+ transition(regn0, td, tr);

        V(CPC) <+ transition(regpc, td, tr); V(CNC) <+ transition(regnc, td, tr);
        V(SP)  <+ transition(regps, td, tr); V(SN)  <+ transition(regns, td, tr);
    end
endmodule
