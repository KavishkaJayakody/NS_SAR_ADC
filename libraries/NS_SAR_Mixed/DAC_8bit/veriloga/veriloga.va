// VerilogA for NS_SAR_Mixed, DAC_8bit, veriloga

`include "constants.vams"
`include "disciplines.vams"

module DAC_8bit (B7, B6, B5, B4, B3, B2, B1, B0, VOUT, VREF_P, VREF_N);
    input B7, B6, B5, B4, B3, B2, B1, B0;
    input VREF_P,VREF_N;
    output VOUT;

    electrical B7, B6, B5, B4, B3, B2, B1, B0;
    electrical VREF_P, VREF_N, VGND, VOUT;

    parameter real Vth = 0.9; // Logic threshold
    parameter real trise = 100p;
    parameter real tfall = 100p;

    real result;
    real full_scale;
	real voffset;
    real lsb;

    analog begin

        result = 0;
        if (V(B7) > Vth) result = result + 128;
        if (V(B6) > Vth) result = result + 64;
        if (V(B5) > Vth) result = result + 32;
        if (V(B4) > Vth) result = result + 16;
        if (V(B3) > Vth) result = result + 8;
        if (V(B2) > Vth) result = result + 4;
        if (V(B1) > Vth) result = result + 2;
        if (V(B0) > Vth) result = result + 1;

        // Calculate the output voltage based on VREF and VGND
        // Formula: VOUT = VGND + (Bit_Value / 1024) * (VREF - VGND)
        full_scale = 2*(V(VREF_P) - V(VREF_N));
		voffset = V(VREF_P) - V(VREF_N);
        lsb = full_scale / 256.0;

        V(VOUT) <+ transition((result * lsb)-voffset, 0, trise, tfall);
    end
endmodule
