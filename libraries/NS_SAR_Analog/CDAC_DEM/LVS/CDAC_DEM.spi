* +++++++++++++++++++++++++++++++++++++++++++++++++++++ *
* CDL Netlist:                                          *
*                                                       *
* Cell Name  : CDAC_DEM                                 *
* Netlisted  : Fri Aug 28 13:56:16 2026                 *
* PVS Version: 16.10-p006 Thu Jul 27 18:05:02 PDT 2017 *
* +++++++++++++++++++++++++++++++++++++++++++++++++++++ *
*.LDD
*.DEVTMPLT 0 R(res_generic_m1) met1_res met1(P) met1(N)
*.DEVTMPLT 1 R(res_generic_m2) met2_res met2(P) met2(N)
*.DEVTMPLT 2 R(res_generic_m3) met3_res met3(P) met3(N)
*.DEVTMPLT 3 R(res_generic_m4) met4_res met4(P) met4(N)
*.DEVTMPLT 4 R(res_generic_m5) met5_res met5(P) met5(N)
*.DEVTMPLT 5 D(diode_pd2nw_05v5) diode_pd2nw_05v5_rec psd(PLUS) nwell(MINUS)
*.DEVTMPLT 6 D(diode_pd2nw_05v5_hvt) diode_pd2nw_05v5_hvt_rec psd(PLUS) nwell(MINUS)
*.DEVTMPLT 7 D(diode_pd2nw_05v5_lvt) diode_pd2nw_05v5_lvt_rec psd(PLUS) nwell(MINUS)
*.DEVTMPLT 8 D(diode_pd2nw_11v0) diode_pd2nw_11v0_rec psd(PLUS) nwell(MINUS)
*.DEVTMPLT 9 D(diode_pw2nd_05v5) diode_pw2nd_05v5_rec pwell_all(PLUS) nsd(MINUS)
*.DEVTMPLT 10 D(diode_pw2nd_05v5_lvt) diode_pw2nd_05v5_lvt_rec pwell_all(PLUS) nsd(MINUS)
*.DEVTMPLT 11 D(diode_pw2nd_05v5_nvt) diode_pw2nd_05v5_nvt_rec pwell_all(PLUS) nsd(MINUS)
*.DEVTMPLT 12 D(diode_pw2nd_11v0) diode_pw2nd_11v0_rec pwell_all(PLUS) nsd(MINUS)
*.DEVTMPLT 0 R(RES_GENERIC_ND) diff_res np_term(P) np_term(N)
*.DEVTMPLT 1 R(RES_GENERIC_PD) diff_res pp_term(P) pp_term(N)
*.DEVTMPLT 15 MN(nfet_01v8) nfet_01v8_rec nSourceDrain(D) nfet(G) nSourceDrain(S) pwell_all(B)
*.DEVTMPLT 16 MP(pfet_01v8) pfet_01v8_rec pSourceDrain(D) pfet(G) pSourceDrain(S) nwell(B)
*.DEVTMPLT 17 MP(pfet_01v8_lvt) lvtpfet_01v8_rec pSourceDrain(D) lvtpfet(G) pSourceDrain(S) nwell(B)
*.DEVTMPLT 18 MN(nfet_01v8_lvt) lvtnfet_01v8_rec nSourceDrain(D) lvtnfet(G) nSourceDrain(S) pwell_all(B)
*.DEVTMPLT 19 MP(pfet_01v8_hvt) hvtpfet_01v8_rec pSourceDrain(D) hvtpfet(G) pSourceDrain(S) nwell(B)
*.DEVTMPLT 20 MN(nfet_03v3_nvt) HV_ngate_3v3 HV_source_drain(D) HV_FET_gate(G) HV_source_drain(S) pwell_all(B)
*.DEVTMPLT 21 MN(nfet_05v0_nvt) HV_ngate_5v0 HV_source_drain(D) HV_FET_gate(G) HV_source_drain(S) pwell_all(B)
*.DEVTMPLT 22 MN(nfet_g5v0d10v5) HV_ngate_5v10v HV_source_drain(D) HV_FET_gate(G) HV_source_drain(S) pwell_all(B)
*.DEVTMPLT 23 MP(pfet_g5v0d10v5) HV_pgate_5v10v HV_source_drain(D) HV_FET_gate(G) HV_source_drain(S) nwell(B)
*.DEVTMPLT 24 MN(nfet_20v0) nfet_v20_rec nfet_v20_drain(D) nfet_v20_gate(G) nfet_v20_source(S) pwell_all(B)
*.DEVTMPLT 25 MN(nfet_20v0_zvt) nfet_v20_zvt_rec nfet_v20_drain(D) nfet_v20_gate(G) nfet_v20_source(S) pwell_all(B)
*.DEVTMPLT 26 MP(pfet_20v0) pfet_v20_rec pfet_v20_drain(D) pfet_v20_gate(G) pfet_v20_source(S) nwell(B)
*.DEVTMPLT 27 Q(npn_05v5) npn_rec npnC(C) npnB(B) npnE(E) pwell_all(BN)
*.DEVTMPLT 28 Q(npn_11v0) hvnpn_rec npnC(C) npnB(B) hvnpnE(E) pwell_all(BN)
*.DEVTMPLT 29 Q(pnp_05v5) pnp_rec pnpC(C) pnpB(B) pnpE(E) pwell_all(BN)
*.DEVTMPLT 30 R(res_high_po_0p35) res_high_po_0p35_rec prec_resistor_term(PLUS) prec_resistor_term(MINUS) pwell_all(B)
*.DEVTMPLT 31 R(res_high_po_0p69) res_high_po_0p69_rec prec_resistor_term(PLUS) prec_resistor_term(MINUS) pwell_all(B)
*.DEVTMPLT 32 R(res_high_po_1p41) res_high_po_1p41_rec prec_resistor_term(PLUS) prec_resistor_term(MINUS) pwell_all(B)
*.DEVTMPLT 33 R(res_high_po_2p85) res_high_po_2p85_rec prec_resistor_term(PLUS) prec_resistor_term(MINUS) pwell_all(B)
*.DEVTMPLT 34 R(res_high_po_5p73) res_high_po_5p73_rec prec_resistor_term(PLUS) prec_resistor_term(MINUS) pwell_all(B)
*.DEVTMPLT 35 R(res_xhigh_po_0p35) res_xhigh_po_0p35_rec prec_resistor_term(PLUS) prec_resistor_term(MINUS) pwell_all(B)
*.DEVTMPLT 36 R(res_xhigh_po_0p69) res_xhigh_po_0p69_rec prec_resistor_term(PLUS) prec_resistor_term(MINUS) pwell_all(B)
*.DEVTMPLT 37 R(res_xhigh_po_1p41) res_xhigh_po_1p41_rec prec_resistor_term(PLUS) prec_resistor_term(MINUS) pwell_all(B)
*.DEVTMPLT 38 R(res_xhigh_po_2p85) res_xhigh_po_2p85_rec prec_resistor_term(PLUS) prec_resistor_term(MINUS) pwell_all(B)
*.DEVTMPLT 39 R(res_xhigh_po_5p73) res_xhigh_po_5p73_rec prec_resistor_term(PLUS) prec_resistor_term(MINUS) pwell_all(B)
*.DEVTMPLT 40 C(cap_mim_m3__base) capacitor top_plate(PLUS) bottom_plate(MINUS)

* +++++++++++++++++++++++++++++++++++++++++++++++++++++ *
* Sub cell: CDAC_DEM                                    *
* +++++++++++++++++++++++++++++++++++++++++++++++++++++ *
.subckt CDAC_DEM SAMPLE TOP_PLATE VDD! VIN VREF_N VREF_P VREF_SEL_1<0> VREF_SEL_1<1> VREF_SEL_2 VREF_SEL_4<0>
+ VREF_SEL_4<1> VREF_SEL_4<2> VREF_SEL_4<3> VREF_SEL_4<4> VREF_SEL_4<5> VREF_SEL_4<6> VREF_SEL_8<0> VREF_SEL_8<10> VREF_SEL_8<11> VREF_SEL_8<12>
+ VREF_SEL_8<13> VREF_SEL_8<14> VREF_SEL_8<15> VREF_SEL_8<16> VREF_SEL_8<17> VREF_SEL_8<18> VREF_SEL_8<19> VREF_SEL_8<1> VREF_SEL_8<20> VREF_SEL_8<21>
+ VREF_SEL_8<22> VREF_SEL_8<23> VREF_SEL_8<24> VREF_SEL_8<25> VREF_SEL_8<26> VREF_SEL_8<27> VREF_SEL_8<2> VREF_SEL_8<3> VREF_SEL_8<4> VREF_SEL_8<5>
+ VREF_SEL_8<6> VREF_SEL_8<7> VREF_SEL_8<8> VREF_SEL_8<9> VSS!
** N=32847 EP=45 FDC=6036
M0 852 SAMPLE VSS! VSS! nfet_01v8 L=1.5e-07 W=7.6e-07 $X=2360 $Y=13010 $dt=15
M1 853 SAMPLE VSS! VSS! nfet_01v8 L=1.5e-07 W=7.6e-07 $X=2360 $Y=21290 $dt=15
M2 854 SAMPLE VSS! VSS! nfet_01v8 L=1.5e-07 W=7.6e-07 $X=2360 $Y=29570 $dt=15
M3 855 SAMPLE VSS! VSS! nfet_01v8 L=1.5e-07 W=7.6e-07 $X=2360 $Y=37850 $dt=15
M4 856 SAMPLE VSS! VSS! nfet_01v8 L=1.5e-07 W=7.6e-07 $X=2360 $Y=46130 $dt=15
M5 857 SAMPLE VSS! VSS! nfet_01v8 L=1.5e-07 W=7.6e-07 $X=2360 $Y=54410 $dt=15
M6 858 SAMPLE VSS! VSS! nfet_01v8 L=1.5e-07 W=7.6e-07 $X=2360 $Y=62690 $dt=15
M7 859 SAMPLE VSS! VSS! nfet_01v8 L=1.5e-07 W=7.6e-07 $X=2360 $Y=70970 $dt=15
M8 860 SAMPLE VSS! VSS! nfet_01v8 L=1.5e-07 W=7.6e-07 $X=2360 $Y=79250 $dt=15
M9 861 SAMPLE VSS! VSS! nfet_01v8 L=1.5e-07 W=7.6e-07 $X=2360 $Y=87530 $dt=15
M10 862 SAMPLE VSS! VSS! nfet_01v8 L=1.5e-07 W=7.6e-07 $X=2360 $Y=95810 $dt=15
M11 863 SAMPLE VSS! VSS! nfet_01v8 L=1.5e-07 W=7.6e-07 $X=2360 $Y=104090 $dt=15
M12 864 SAMPLE VSS! VSS! nfet_01v8 L=1.5e-07 W=7.6e-07 $X=2360 $Y=112370 $dt=15
M13 865 SAMPLE VSS! VSS! nfet_01v8 L=1.5e-07 W=7.6e-07 $X=2360 $Y=120650 $dt=15
M14 866 SAMPLE VSS! VSS! nfet_01v8 L=1.5e-07 W=7.6e-07 $X=2360 $Y=128930 $dt=15
M15 867 SAMPLE VSS! VSS! nfet_01v8 L=1.5e-07 W=7.6e-07 $X=2360 $Y=137210 $dt=15
M16 868 SAMPLE VSS! VSS! nfet_01v8 L=1.5e-07 W=7.6e-07 $X=2360 $Y=145490 $dt=15
M17 869 SAMPLE VSS! VSS! nfet_01v8 L=1.5e-07 W=7.6e-07 $X=2360 $Y=153770 $dt=15
M18 870 SAMPLE VSS! VSS! nfet_01v8 L=1.5e-07 W=7.6e-07 $X=2360 $Y=162050 $dt=15
M19 720 SAMPLE VSS! VSS! nfet_01v8 L=1.5e-07 W=7.6e-07 $X=2400 $Y=11070 $dt=15
M20 722 SAMPLE VSS! VSS! nfet_01v8 L=1.5e-07 W=7.6e-07 $X=2400 $Y=19350 $dt=15
M21 724 SAMPLE VSS! VSS! nfet_01v8 L=1.5e-07 W=7.6e-07 $X=2400 $Y=27630 $dt=15
M22 726 SAMPLE VSS! VSS! nfet_01v8 L=1.5e-07 W=7.6e-07 $X=2400 $Y=35910 $dt=15
M23 728 SAMPLE VSS! VSS! nfet_01v8 L=1.5e-07 W=7.6e-07 $X=2400 $Y=44190 $dt=15
M24 730 SAMPLE VSS! VSS! nfet_01v8 L=1.5e-07 W=7.6e-07 $X=2400 $Y=52470 $dt=15
M25 732 SAMPLE VSS! VSS! nfet_01v8 L=1.5e-07 W=7.6e-07 $X=2400 $Y=60750 $dt=15
M26 734 SAMPLE VSS! VSS! nfet_01v8 L=1.5e-07 W=7.6e-07 $X=2400 $Y=69030 $dt=15
M27 736 SAMPLE VSS! VSS! nfet_01v8 L=1.5e-07 W=7.6e-07 $X=2400 $Y=77310 $dt=15
M28 738 SAMPLE VSS! VSS! nfet_01v8 L=1.5e-07 W=7.6e-07 $X=2400 $Y=85590 $dt=15
M29 740 SAMPLE VSS! VSS! nfet_01v8 L=1.5e-07 W=7.6e-07 $X=2400 $Y=93870 $dt=15
M30 742 SAMPLE VSS! VSS! nfet_01v8 L=1.5e-07 W=7.6e-07 $X=2400 $Y=102150 $dt=15
M31 744 SAMPLE VSS! VSS! nfet_01v8 L=1.5e-07 W=7.6e-07 $X=2400 $Y=110430 $dt=15
M32 746 SAMPLE VSS! VSS! nfet_01v8 L=1.5e-07 W=7.6e-07 $X=2400 $Y=118710 $dt=15
M33 748 SAMPLE VSS! VSS! nfet_01v8 L=1.5e-07 W=7.6e-07 $X=2400 $Y=126990 $dt=15
M34 750 SAMPLE VSS! VSS! nfet_01v8 L=1.5e-07 W=7.6e-07 $X=2400 $Y=135270 $dt=15
M35 752 SAMPLE VSS! VSS! nfet_01v8 L=1.5e-07 W=7.6e-07 $X=2400 $Y=143550 $dt=15
M36 754 SAMPLE VSS! VSS! nfet_01v8 L=1.5e-07 W=7.6e-07 $X=2400 $Y=151830 $dt=15
M37 756 SAMPLE VSS! VSS! nfet_01v8 L=1.5e-07 W=7.6e-07 $X=2400 $Y=160110 $dt=15
M38 VSS! VREF_SEL_8<13> 720 VSS! nfet_01v8 L=1.5e-07 W=7.6e-07 $X=2870 $Y=11070 $dt=15
M39 VSS! VREF_SEL_8<12> 722 VSS! nfet_01v8 L=1.5e-07 W=7.6e-07 $X=2870 $Y=19350 $dt=15
M40 VSS! VREF_SEL_8<11> 724 VSS! nfet_01v8 L=1.5e-07 W=7.6e-07 $X=2870 $Y=27630 $dt=15
M41 VSS! VREF_SEL_8<10> 726 VSS! nfet_01v8 L=1.5e-07 W=7.6e-07 $X=2870 $Y=35910 $dt=15
M42 VSS! VREF_SEL_8<9> 728 VSS! nfet_01v8 L=1.5e-07 W=7.6e-07 $X=2870 $Y=44190 $dt=15
M43 VSS! VREF_SEL_8<8> 730 VSS! nfet_01v8 L=1.5e-07 W=7.6e-07 $X=2870 $Y=52470 $dt=15
M44 VSS! VREF_SEL_8<7> 732 VSS! nfet_01v8 L=1.5e-07 W=7.6e-07 $X=2870 $Y=60750 $dt=15
M45 VSS! VREF_SEL_4<3> 734 VSS! nfet_01v8 L=1.5e-07 W=7.6e-07 $X=2870 $Y=69030 $dt=15
M46 VSS! VREF_SEL_4<2> 736 VSS! nfet_01v8 L=1.5e-07 W=7.6e-07 $X=2870 $Y=77310 $dt=15
M47 VSS! VREF_SEL_1<0> 738 VSS! nfet_01v8 L=1.5e-07 W=7.6e-07 $X=2870 $Y=85590 $dt=15
M48 VSS! VREF_SEL_4<1> 740 VSS! nfet_01v8 L=1.5e-07 W=7.6e-07 $X=2870 $Y=93870 $dt=15
M49 VSS! VREF_SEL_4<0> 742 VSS! nfet_01v8 L=1.5e-07 W=7.6e-07 $X=2870 $Y=102150 $dt=15
M50 VSS! VREF_SEL_8<6> 744 VSS! nfet_01v8 L=1.5e-07 W=7.6e-07 $X=2870 $Y=110430 $dt=15
M51 VSS! VREF_SEL_8<5> 746 VSS! nfet_01v8 L=1.5e-07 W=7.6e-07 $X=2870 $Y=118710 $dt=15
M52 VSS! VREF_SEL_8<4> 748 VSS! nfet_01v8 L=1.5e-07 W=7.6e-07 $X=2870 $Y=126990 $dt=15
M53 VSS! VREF_SEL_8<3> 750 VSS! nfet_01v8 L=1.5e-07 W=7.6e-07 $X=2870 $Y=135270 $dt=15
M54 VSS! VREF_SEL_8<2> 752 VSS! nfet_01v8 L=1.5e-07 W=7.6e-07 $X=2870 $Y=143550 $dt=15
M55 VSS! VREF_SEL_8<1> 754 VSS! nfet_01v8 L=1.5e-07 W=7.6e-07 $X=2870 $Y=151830 $dt=15
M56 VSS! VREF_SEL_8<0> 756 VSS! nfet_01v8 L=1.5e-07 W=7.6e-07 $X=2870 $Y=160110 $dt=15
M57 948 852 833 VSS! nfet_01v8 L=1.5e-07 W=4.25e-07 $X=3740 $Y=13010 $dt=15
M58 949 853 834 VSS! nfet_01v8 L=1.5e-07 W=4.25e-07 $X=3740 $Y=21290 $dt=15
M59 950 854 835 VSS! nfet_01v8 L=1.5e-07 W=4.25e-07 $X=3740 $Y=29570 $dt=15
M60 951 855 836 VSS! nfet_01v8 L=1.5e-07 W=4.25e-07 $X=3740 $Y=37850 $dt=15
M61 952 856 837 VSS! nfet_01v8 L=1.5e-07 W=4.25e-07 $X=3740 $Y=46130 $dt=15
M62 953 857 838 VSS! nfet_01v8 L=1.5e-07 W=4.25e-07 $X=3740 $Y=54410 $dt=15
M63 954 858 839 VSS! nfet_01v8 L=1.5e-07 W=4.25e-07 $X=3740 $Y=62690 $dt=15
M64 955 859 840 VSS! nfet_01v8 L=1.5e-07 W=4.25e-07 $X=3740 $Y=70970 $dt=15
M65 956 860 841 VSS! nfet_01v8 L=1.5e-07 W=4.25e-07 $X=3740 $Y=79250 $dt=15
M66 957 861 842 VSS! nfet_01v8 L=1.5e-07 W=4.25e-07 $X=3740 $Y=87530 $dt=15
M67 958 862 843 VSS! nfet_01v8 L=1.5e-07 W=4.25e-07 $X=3740 $Y=95810 $dt=15
M68 959 863 844 VSS! nfet_01v8 L=1.5e-07 W=4.25e-07 $X=3740 $Y=104090 $dt=15
M69 960 864 845 VSS! nfet_01v8 L=1.5e-07 W=4.25e-07 $X=3740 $Y=112370 $dt=15
M70 961 865 846 VSS! nfet_01v8 L=1.5e-07 W=4.25e-07 $X=3740 $Y=120650 $dt=15
M71 962 866 847 VSS! nfet_01v8 L=1.5e-07 W=4.25e-07 $X=3740 $Y=128930 $dt=15
M72 963 867 848 VSS! nfet_01v8 L=1.5e-07 W=4.25e-07 $X=3740 $Y=137210 $dt=15
M73 964 868 849 VSS! nfet_01v8 L=1.5e-07 W=4.25e-07 $X=3740 $Y=145490 $dt=15
M74 965 869 850 VSS! nfet_01v8 L=1.5e-07 W=4.25e-07 $X=3740 $Y=153770 $dt=15
M75 966 870 851 VSS! nfet_01v8 L=1.5e-07 W=4.25e-07 $X=3740 $Y=162050 $dt=15
M76 VSS! VREF_SEL_8<13> 948 VSS! nfet_01v8 L=1.5e-07 W=4.25e-07 $X=4170 $Y=13010 $dt=15
M77 VSS! VREF_SEL_8<12> 949 VSS! nfet_01v8 L=1.5e-07 W=4.25e-07 $X=4170 $Y=21290 $dt=15
M78 VSS! VREF_SEL_8<11> 950 VSS! nfet_01v8 L=1.5e-07 W=4.25e-07 $X=4170 $Y=29570 $dt=15
M79 VSS! VREF_SEL_8<10> 951 VSS! nfet_01v8 L=1.5e-07 W=4.25e-07 $X=4170 $Y=37850 $dt=15
M80 VSS! VREF_SEL_8<9> 952 VSS! nfet_01v8 L=1.5e-07 W=4.25e-07 $X=4170 $Y=46130 $dt=15
M81 VSS! VREF_SEL_8<8> 953 VSS! nfet_01v8 L=1.5e-07 W=4.25e-07 $X=4170 $Y=54410 $dt=15
M82 VSS! VREF_SEL_8<7> 954 VSS! nfet_01v8 L=1.5e-07 W=4.25e-07 $X=4170 $Y=62690 $dt=15
M83 VSS! VREF_SEL_4<3> 955 VSS! nfet_01v8 L=1.5e-07 W=4.25e-07 $X=4170 $Y=70970 $dt=15
M84 VSS! VREF_SEL_4<2> 956 VSS! nfet_01v8 L=1.5e-07 W=4.25e-07 $X=4170 $Y=79250 $dt=15
M85 VSS! VREF_SEL_1<0> 957 VSS! nfet_01v8 L=1.5e-07 W=4.25e-07 $X=4170 $Y=87530 $dt=15
M86 VSS! VREF_SEL_4<1> 958 VSS! nfet_01v8 L=1.5e-07 W=4.25e-07 $X=4170 $Y=95810 $dt=15
M87 VSS! VREF_SEL_4<0> 959 VSS! nfet_01v8 L=1.5e-07 W=4.25e-07 $X=4170 $Y=104090 $dt=15
M88 VSS! VREF_SEL_8<6> 960 VSS! nfet_01v8 L=1.5e-07 W=4.25e-07 $X=4170 $Y=112370 $dt=15
M89 VSS! VREF_SEL_8<5> 961 VSS! nfet_01v8 L=1.5e-07 W=4.25e-07 $X=4170 $Y=120650 $dt=15
M90 VSS! VREF_SEL_8<4> 962 VSS! nfet_01v8 L=1.5e-07 W=4.25e-07 $X=4170 $Y=128930 $dt=15
M91 VSS! VREF_SEL_8<3> 963 VSS! nfet_01v8 L=1.5e-07 W=4.25e-07 $X=4170 $Y=137210 $dt=15
M92 VSS! VREF_SEL_8<2> 964 VSS! nfet_01v8 L=1.5e-07 W=4.25e-07 $X=4170 $Y=145490 $dt=15
M93 VSS! VREF_SEL_8<1> 965 VSS! nfet_01v8 L=1.5e-07 W=4.25e-07 $X=4170 $Y=153770 $dt=15
M94 VSS! VREF_SEL_8<0> 966 VSS! nfet_01v8 L=1.5e-07 W=4.25e-07 $X=4170 $Y=162050 $dt=15
M95 929 SAMPLE 814 VSS! nfet_01v8 L=1.5e-07 W=4.25e-07 $X=4200 $Y=11405 $dt=15
M96 930 SAMPLE 815 VSS! nfet_01v8 L=1.5e-07 W=4.25e-07 $X=4200 $Y=19685 $dt=15
M97 931 SAMPLE 816 VSS! nfet_01v8 L=1.5e-07 W=4.25e-07 $X=4200 $Y=27965 $dt=15
M98 932 SAMPLE 817 VSS! nfet_01v8 L=1.5e-07 W=4.25e-07 $X=4200 $Y=36245 $dt=15
M99 933 SAMPLE 818 VSS! nfet_01v8 L=1.5e-07 W=4.25e-07 $X=4200 $Y=44525 $dt=15
M100 934 SAMPLE 819 VSS! nfet_01v8 L=1.5e-07 W=4.25e-07 $X=4200 $Y=52805 $dt=15
M101 935 SAMPLE 820 VSS! nfet_01v8 L=1.5e-07 W=4.25e-07 $X=4200 $Y=61085 $dt=15
M102 936 SAMPLE 821 VSS! nfet_01v8 L=1.5e-07 W=4.25e-07 $X=4200 $Y=69365 $dt=15
M103 937 SAMPLE 822 VSS! nfet_01v8 L=1.5e-07 W=4.25e-07 $X=4200 $Y=77645 $dt=15
M104 938 SAMPLE 823 VSS! nfet_01v8 L=1.5e-07 W=4.25e-07 $X=4200 $Y=85925 $dt=15
M105 939 SAMPLE 824 VSS! nfet_01v8 L=1.5e-07 W=4.25e-07 $X=4200 $Y=94205 $dt=15
M106 940 SAMPLE 825 VSS! nfet_01v8 L=1.5e-07 W=4.25e-07 $X=4200 $Y=102485 $dt=15
M107 941 SAMPLE 826 VSS! nfet_01v8 L=1.5e-07 W=4.25e-07 $X=4200 $Y=110765 $dt=15
M108 942 SAMPLE 827 VSS! nfet_01v8 L=1.5e-07 W=4.25e-07 $X=4200 $Y=119045 $dt=15
M109 943 SAMPLE 828 VSS! nfet_01v8 L=1.5e-07 W=4.25e-07 $X=4200 $Y=127325 $dt=15
M110 944 SAMPLE 829 VSS! nfet_01v8 L=1.5e-07 W=4.25e-07 $X=4200 $Y=135605 $dt=15
M111 945 SAMPLE 830 VSS! nfet_01v8 L=1.5e-07 W=4.25e-07 $X=4200 $Y=143885 $dt=15
M112 946 SAMPLE 831 VSS! nfet_01v8 L=1.5e-07 W=4.25e-07 $X=4200 $Y=152165 $dt=15
M113 947 SAMPLE 832 VSS! nfet_01v8 L=1.5e-07 W=4.25e-07 $X=4200 $Y=160445 $dt=15
M114 VSS! VREF_SEL_8<13> 929 VSS! nfet_01v8 L=1.5e-07 W=4.25e-07 $X=4630 $Y=11405 $dt=15
M115 VSS! VREF_SEL_8<12> 930 VSS! nfet_01v8 L=1.5e-07 W=4.25e-07 $X=4630 $Y=19685 $dt=15
M116 VSS! VREF_SEL_8<11> 931 VSS! nfet_01v8 L=1.5e-07 W=4.25e-07 $X=4630 $Y=27965 $dt=15
M117 VSS! VREF_SEL_8<10> 932 VSS! nfet_01v8 L=1.5e-07 W=4.25e-07 $X=4630 $Y=36245 $dt=15
M118 VSS! VREF_SEL_8<9> 933 VSS! nfet_01v8 L=1.5e-07 W=4.25e-07 $X=4630 $Y=44525 $dt=15
M119 VSS! VREF_SEL_8<8> 934 VSS! nfet_01v8 L=1.5e-07 W=4.25e-07 $X=4630 $Y=52805 $dt=15
M120 VSS! VREF_SEL_8<7> 935 VSS! nfet_01v8 L=1.5e-07 W=4.25e-07 $X=4630 $Y=61085 $dt=15
M121 VSS! VREF_SEL_4<3> 936 VSS! nfet_01v8 L=1.5e-07 W=4.25e-07 $X=4630 $Y=69365 $dt=15
M122 VSS! VREF_SEL_4<2> 937 VSS! nfet_01v8 L=1.5e-07 W=4.25e-07 $X=4630 $Y=77645 $dt=15
M123 VSS! VREF_SEL_1<0> 938 VSS! nfet_01v8 L=1.5e-07 W=4.25e-07 $X=4630 $Y=85925 $dt=15
M124 VSS! VREF_SEL_4<1> 939 VSS! nfet_01v8 L=1.5e-07 W=4.25e-07 $X=4630 $Y=94205 $dt=15
M125 VSS! VREF_SEL_4<0> 940 VSS! nfet_01v8 L=1.5e-07 W=4.25e-07 $X=4630 $Y=102485 $dt=15
M126 VSS! VREF_SEL_8<6> 941 VSS! nfet_01v8 L=1.5e-07 W=4.25e-07 $X=4630 $Y=110765 $dt=15
M127 VSS! VREF_SEL_8<5> 942 VSS! nfet_01v8 L=1.5e-07 W=4.25e-07 $X=4630 $Y=119045 $dt=15
M128 VSS! VREF_SEL_8<4> 943 VSS! nfet_01v8 L=1.5e-07 W=4.25e-07 $X=4630 $Y=127325 $dt=15
M129 VSS! VREF_SEL_8<3> 944 VSS! nfet_01v8 L=1.5e-07 W=4.25e-07 $X=4630 $Y=135605 $dt=15
M130 VSS! VREF_SEL_8<2> 945 VSS! nfet_01v8 L=1.5e-07 W=4.25e-07 $X=4630 $Y=143885 $dt=15
M131 VSS! VREF_SEL_8<1> 946 VSS! nfet_01v8 L=1.5e-07 W=4.25e-07 $X=4630 $Y=152165 $dt=15
M132 VSS! VREF_SEL_8<0> 947 VSS! nfet_01v8 L=1.5e-07 W=4.25e-07 $X=4630 $Y=160445 $dt=15
M133 719 833 VSS! VSS! nfet_01v8 L=1.5e-07 W=7.6e-07 $X=4660 $Y=13010 $dt=15
M134 721 834 VSS! VSS! nfet_01v8 L=1.5e-07 W=7.6e-07 $X=4660 $Y=21290 $dt=15
M135 723 835 VSS! VSS! nfet_01v8 L=1.5e-07 W=7.6e-07 $X=4660 $Y=29570 $dt=15
M136 725 836 VSS! VSS! nfet_01v8 L=1.5e-07 W=7.6e-07 $X=4660 $Y=37850 $dt=15
M137 727 837 VSS! VSS! nfet_01v8 L=1.5e-07 W=7.6e-07 $X=4660 $Y=46130 $dt=15
M138 729 838 VSS! VSS! nfet_01v8 L=1.5e-07 W=7.6e-07 $X=4660 $Y=54410 $dt=15
M139 731 839 VSS! VSS! nfet_01v8 L=1.5e-07 W=7.6e-07 $X=4660 $Y=62690 $dt=15
M140 733 840 VSS! VSS! nfet_01v8 L=1.5e-07 W=7.6e-07 $X=4660 $Y=70970 $dt=15
M141 735 841 VSS! VSS! nfet_01v8 L=1.5e-07 W=7.6e-07 $X=4660 $Y=79250 $dt=15
M142 737 842 VSS! VSS! nfet_01v8 L=1.5e-07 W=7.6e-07 $X=4660 $Y=87530 $dt=15
M143 739 843 VSS! VSS! nfet_01v8 L=1.5e-07 W=7.6e-07 $X=4660 $Y=95810 $dt=15
M144 741 844 VSS! VSS! nfet_01v8 L=1.5e-07 W=7.6e-07 $X=4660 $Y=104090 $dt=15
M145 743 845 VSS! VSS! nfet_01v8 L=1.5e-07 W=7.6e-07 $X=4660 $Y=112370 $dt=15
M146 745 846 VSS! VSS! nfet_01v8 L=1.5e-07 W=7.6e-07 $X=4660 $Y=120650 $dt=15
M147 747 847 VSS! VSS! nfet_01v8 L=1.5e-07 W=7.6e-07 $X=4660 $Y=128930 $dt=15
M148 749 848 VSS! VSS! nfet_01v8 L=1.5e-07 W=7.6e-07 $X=4660 $Y=137210 $dt=15
M149 751 849 VSS! VSS! nfet_01v8 L=1.5e-07 W=7.6e-07 $X=4660 $Y=145490 $dt=15
M150 753 850 VSS! VSS! nfet_01v8 L=1.5e-07 W=7.6e-07 $X=4660 $Y=153770 $dt=15
M151 755 851 VSS! VSS! nfet_01v8 L=1.5e-07 W=7.6e-07 $X=4660 $Y=162050 $dt=15
M152 681 814 VSS! VSS! nfet_01v8 L=1.5e-07 W=7.6e-07 $X=5120 $Y=11070 $dt=15
M153 682 815 VSS! VSS! nfet_01v8 L=1.5e-07 W=7.6e-07 $X=5120 $Y=19350 $dt=15
M154 683 816 VSS! VSS! nfet_01v8 L=1.5e-07 W=7.6e-07 $X=5120 $Y=27630 $dt=15
M155 684 817 VSS! VSS! nfet_01v8 L=1.5e-07 W=7.6e-07 $X=5120 $Y=35910 $dt=15
M156 685 818 VSS! VSS! nfet_01v8 L=1.5e-07 W=7.6e-07 $X=5120 $Y=44190 $dt=15
M157 686 819 VSS! VSS! nfet_01v8 L=1.5e-07 W=7.6e-07 $X=5120 $Y=52470 $dt=15
M158 687 820 VSS! VSS! nfet_01v8 L=1.5e-07 W=7.6e-07 $X=5120 $Y=60750 $dt=15
M159 688 821 VSS! VSS! nfet_01v8 L=1.5e-07 W=7.6e-07 $X=5120 $Y=69030 $dt=15
M160 689 822 VSS! VSS! nfet_01v8 L=1.5e-07 W=7.6e-07 $X=5120 $Y=77310 $dt=15
M161 690 823 VSS! VSS! nfet_01v8 L=1.5e-07 W=7.6e-07 $X=5120 $Y=85590 $dt=15
M162 691 824 VSS! VSS! nfet_01v8 L=1.5e-07 W=7.6e-07 $X=5120 $Y=93870 $dt=15
M163 692 825 VSS! VSS! nfet_01v8 L=1.5e-07 W=7.6e-07 $X=5120 $Y=102150 $dt=15
M164 693 826 VSS! VSS! nfet_01v8 L=1.5e-07 W=7.6e-07 $X=5120 $Y=110430 $dt=15
M165 694 827 VSS! VSS! nfet_01v8 L=1.5e-07 W=7.6e-07 $X=5120 $Y=118710 $dt=15
M166 695 828 VSS! VSS! nfet_01v8 L=1.5e-07 W=7.6e-07 $X=5120 $Y=126990 $dt=15
M167 696 829 VSS! VSS! nfet_01v8 L=1.5e-07 W=7.6e-07 $X=5120 $Y=135270 $dt=15
M168 697 830 VSS! VSS! nfet_01v8 L=1.5e-07 W=7.6e-07 $X=5120 $Y=143550 $dt=15
M169 698 831 VSS! VSS! nfet_01v8 L=1.5e-07 W=7.6e-07 $X=5120 $Y=151830 $dt=15
M170 699 832 VSS! VSS! nfet_01v8 L=1.5e-07 W=7.6e-07 $X=5120 $Y=160110 $dt=15
M171 VSS! 719 776 VSS! nfet_01v8 L=1.5e-07 W=7.6e-07 $X=6040 $Y=13010 $dt=15
M172 VSS! 721 777 VSS! nfet_01v8 L=1.5e-07 W=7.6e-07 $X=6040 $Y=21290 $dt=15
M173 VSS! 723 778 VSS! nfet_01v8 L=1.5e-07 W=7.6e-07 $X=6040 $Y=29570 $dt=15
M174 VSS! 725 779 VSS! nfet_01v8 L=1.5e-07 W=7.6e-07 $X=6040 $Y=37850 $dt=15
M175 VSS! 727 780 VSS! nfet_01v8 L=1.5e-07 W=7.6e-07 $X=6040 $Y=46130 $dt=15
M176 VSS! 729 781 VSS! nfet_01v8 L=1.5e-07 W=7.6e-07 $X=6040 $Y=54410 $dt=15
M177 VSS! 731 782 VSS! nfet_01v8 L=1.5e-07 W=7.6e-07 $X=6040 $Y=62690 $dt=15
M178 VSS! 733 783 VSS! nfet_01v8 L=1.5e-07 W=7.6e-07 $X=6040 $Y=70970 $dt=15
M179 VSS! 735 784 VSS! nfet_01v8 L=1.5e-07 W=7.6e-07 $X=6040 $Y=79250 $dt=15
M180 VSS! 737 785 VSS! nfet_01v8 L=1.5e-07 W=7.6e-07 $X=6040 $Y=87530 $dt=15
M181 VSS! 739 786 VSS! nfet_01v8 L=1.5e-07 W=7.6e-07 $X=6040 $Y=95810 $dt=15
M182 VSS! 741 787 VSS! nfet_01v8 L=1.5e-07 W=7.6e-07 $X=6040 $Y=104090 $dt=15
M183 VSS! 743 788 VSS! nfet_01v8 L=1.5e-07 W=7.6e-07 $X=6040 $Y=112370 $dt=15
M184 VSS! 745 789 VSS! nfet_01v8 L=1.5e-07 W=7.6e-07 $X=6040 $Y=120650 $dt=15
M185 VSS! 747 790 VSS! nfet_01v8 L=1.5e-07 W=7.6e-07 $X=6040 $Y=128930 $dt=15
M186 VSS! 749 791 VSS! nfet_01v8 L=1.5e-07 W=7.6e-07 $X=6040 $Y=137210 $dt=15
M187 VSS! 751 792 VSS! nfet_01v8 L=1.5e-07 W=7.6e-07 $X=6040 $Y=145490 $dt=15
M188 VSS! 753 793 VSS! nfet_01v8 L=1.5e-07 W=7.6e-07 $X=6040 $Y=153770 $dt=15
M189 VSS! 755 794 VSS! nfet_01v8 L=1.5e-07 W=7.6e-07 $X=6040 $Y=162050 $dt=15
M190 534 776 VSS! VSS! nfet_01v8 L=1.5e-07 W=7.6e-07 $X=6470 $Y=13010 $dt=15
M191 536 777 VSS! VSS! nfet_01v8 L=1.5e-07 W=7.6e-07 $X=6470 $Y=21290 $dt=15
M192 538 778 VSS! VSS! nfet_01v8 L=1.5e-07 W=7.6e-07 $X=6470 $Y=29570 $dt=15
M193 540 779 VSS! VSS! nfet_01v8 L=1.5e-07 W=7.6e-07 $X=6470 $Y=37850 $dt=15
M194 542 780 VSS! VSS! nfet_01v8 L=1.5e-07 W=7.6e-07 $X=6470 $Y=46130 $dt=15
M195 544 781 VSS! VSS! nfet_01v8 L=1.5e-07 W=7.6e-07 $X=6470 $Y=54410 $dt=15
M196 546 782 VSS! VSS! nfet_01v8 L=1.5e-07 W=7.6e-07 $X=6470 $Y=62690 $dt=15
M197 548 783 VSS! VSS! nfet_01v8 L=1.5e-07 W=7.6e-07 $X=6470 $Y=70970 $dt=15
M198 550 784 VSS! VSS! nfet_01v8 L=1.5e-07 W=7.6e-07 $X=6470 $Y=79250 $dt=15
M199 552 785 VSS! VSS! nfet_01v8 L=1.5e-07 W=7.6e-07 $X=6470 $Y=87530 $dt=15
M200 554 786 VSS! VSS! nfet_01v8 L=1.5e-07 W=7.6e-07 $X=6470 $Y=95810 $dt=15
M201 556 787 VSS! VSS! nfet_01v8 L=1.5e-07 W=7.6e-07 $X=6470 $Y=104090 $dt=15
M202 558 788 VSS! VSS! nfet_01v8 L=1.5e-07 W=7.6e-07 $X=6470 $Y=112370 $dt=15
M203 560 789 VSS! VSS! nfet_01v8 L=1.5e-07 W=7.6e-07 $X=6470 $Y=120650 $dt=15
M204 562 790 VSS! VSS! nfet_01v8 L=1.5e-07 W=7.6e-07 $X=6470 $Y=128930 $dt=15
M205 564 791 VSS! VSS! nfet_01v8 L=1.5e-07 W=7.6e-07 $X=6470 $Y=137210 $dt=15
M206 566 792 VSS! VSS! nfet_01v8 L=1.5e-07 W=7.6e-07 $X=6470 $Y=145490 $dt=15
M207 568 793 VSS! VSS! nfet_01v8 L=1.5e-07 W=7.6e-07 $X=6470 $Y=153770 $dt=15
M208 570 794 VSS! VSS! nfet_01v8 L=1.5e-07 W=7.6e-07 $X=6470 $Y=162050 $dt=15
M209 457 720 VSS! VSS! nfet_01v8 L=1.5e-07 W=7.6e-07 $X=6500 $Y=11070 $dt=15
M210 459 722 VSS! VSS! nfet_01v8 L=1.5e-07 W=7.6e-07 $X=6500 $Y=19350 $dt=15
M211 461 724 VSS! VSS! nfet_01v8 L=1.5e-07 W=7.6e-07 $X=6500 $Y=27630 $dt=15
M212 463 726 VSS! VSS! nfet_01v8 L=1.5e-07 W=7.6e-07 $X=6500 $Y=35910 $dt=15
M213 465 728 VSS! VSS! nfet_01v8 L=1.5e-07 W=7.6e-07 $X=6500 $Y=44190 $dt=15
M214 467 730 VSS! VSS! nfet_01v8 L=1.5e-07 W=7.6e-07 $X=6500 $Y=52470 $dt=15
M215 469 732 VSS! VSS! nfet_01v8 L=1.5e-07 W=7.6e-07 $X=6500 $Y=60750 $dt=15
M216 471 734 VSS! VSS! nfet_01v8 L=1.5e-07 W=7.6e-07 $X=6500 $Y=69030 $dt=15
M217 473 736 VSS! VSS! nfet_01v8 L=1.5e-07 W=7.6e-07 $X=6500 $Y=77310 $dt=15
M218 475 738 VSS! VSS! nfet_01v8 L=1.5e-07 W=7.6e-07 $X=6500 $Y=85590 $dt=15
M219 477 740 VSS! VSS! nfet_01v8 L=1.5e-07 W=7.6e-07 $X=6500 $Y=93870 $dt=15
M220 479 742 VSS! VSS! nfet_01v8 L=1.5e-07 W=7.6e-07 $X=6500 $Y=102150 $dt=15
M221 481 744 VSS! VSS! nfet_01v8 L=1.5e-07 W=7.6e-07 $X=6500 $Y=110430 $dt=15
M222 483 746 VSS! VSS! nfet_01v8 L=1.5e-07 W=7.6e-07 $X=6500 $Y=118710 $dt=15
M223 485 748 VSS! VSS! nfet_01v8 L=1.5e-07 W=7.6e-07 $X=6500 $Y=126990 $dt=15
M224 487 750 VSS! VSS! nfet_01v8 L=1.5e-07 W=7.6e-07 $X=6500 $Y=135270 $dt=15
M225 489 752 VSS! VSS! nfet_01v8 L=1.5e-07 W=7.6e-07 $X=6500 $Y=143550 $dt=15
M226 491 754 VSS! VSS! nfet_01v8 L=1.5e-07 W=7.6e-07 $X=6500 $Y=151830 $dt=15
M227 493 756 VSS! VSS! nfet_01v8 L=1.5e-07 W=7.6e-07 $X=6500 $Y=160110 $dt=15
M228 VSS! 776 534 VSS! nfet_01v8 L=1.5e-07 W=7.6e-07 $X=6900 $Y=13010 $dt=15
M229 VSS! 777 536 VSS! nfet_01v8 L=1.5e-07 W=7.6e-07 $X=6900 $Y=21290 $dt=15
M230 VSS! 778 538 VSS! nfet_01v8 L=1.5e-07 W=7.6e-07 $X=6900 $Y=29570 $dt=15
M231 VSS! 779 540 VSS! nfet_01v8 L=1.5e-07 W=7.6e-07 $X=6900 $Y=37850 $dt=15
M232 VSS! 780 542 VSS! nfet_01v8 L=1.5e-07 W=7.6e-07 $X=6900 $Y=46130 $dt=15
M233 VSS! 781 544 VSS! nfet_01v8 L=1.5e-07 W=7.6e-07 $X=6900 $Y=54410 $dt=15
M234 VSS! 782 546 VSS! nfet_01v8 L=1.5e-07 W=7.6e-07 $X=6900 $Y=62690 $dt=15
M235 VSS! 783 548 VSS! nfet_01v8 L=1.5e-07 W=7.6e-07 $X=6900 $Y=70970 $dt=15
M236 VSS! 784 550 VSS! nfet_01v8 L=1.5e-07 W=7.6e-07 $X=6900 $Y=79250 $dt=15
M237 VSS! 785 552 VSS! nfet_01v8 L=1.5e-07 W=7.6e-07 $X=6900 $Y=87530 $dt=15
M238 VSS! 786 554 VSS! nfet_01v8 L=1.5e-07 W=7.6e-07 $X=6900 $Y=95810 $dt=15
M239 VSS! 787 556 VSS! nfet_01v8 L=1.5e-07 W=7.6e-07 $X=6900 $Y=104090 $dt=15
M240 VSS! 788 558 VSS! nfet_01v8 L=1.5e-07 W=7.6e-07 $X=6900 $Y=112370 $dt=15
M241 VSS! 789 560 VSS! nfet_01v8 L=1.5e-07 W=7.6e-07 $X=6900 $Y=120650 $dt=15
M242 VSS! 790 562 VSS! nfet_01v8 L=1.5e-07 W=7.6e-07 $X=6900 $Y=128930 $dt=15
M243 VSS! 791 564 VSS! nfet_01v8 L=1.5e-07 W=7.6e-07 $X=6900 $Y=137210 $dt=15
M244 VSS! 792 566 VSS! nfet_01v8 L=1.5e-07 W=7.6e-07 $X=6900 $Y=145490 $dt=15
M245 VSS! 793 568 VSS! nfet_01v8 L=1.5e-07 W=7.6e-07 $X=6900 $Y=153770 $dt=15
M246 VSS! 794 570 VSS! nfet_01v8 L=1.5e-07 W=7.6e-07 $X=6900 $Y=162050 $dt=15
M247 VSS! 720 457 VSS! nfet_01v8 L=1.5e-07 W=7.6e-07 $X=6930 $Y=11070 $dt=15
M248 VSS! 722 459 VSS! nfet_01v8 L=1.5e-07 W=7.6e-07 $X=6930 $Y=19350 $dt=15
M249 VSS! 724 461 VSS! nfet_01v8 L=1.5e-07 W=7.6e-07 $X=6930 $Y=27630 $dt=15
M250 VSS! 726 463 VSS! nfet_01v8 L=1.5e-07 W=7.6e-07 $X=6930 $Y=35910 $dt=15
M251 VSS! 728 465 VSS! nfet_01v8 L=1.5e-07 W=7.6e-07 $X=6930 $Y=44190 $dt=15
M252 VSS! 730 467 VSS! nfet_01v8 L=1.5e-07 W=7.6e-07 $X=6930 $Y=52470 $dt=15
M253 VSS! 732 469 VSS! nfet_01v8 L=1.5e-07 W=7.6e-07 $X=6930 $Y=60750 $dt=15
M254 VSS! 734 471 VSS! nfet_01v8 L=1.5e-07 W=7.6e-07 $X=6930 $Y=69030 $dt=15
M255 VSS! 736 473 VSS! nfet_01v8 L=1.5e-07 W=7.6e-07 $X=6930 $Y=77310 $dt=15
M256 VSS! 738 475 VSS! nfet_01v8 L=1.5e-07 W=7.6e-07 $X=6930 $Y=85590 $dt=15
M257 VSS! 740 477 VSS! nfet_01v8 L=1.5e-07 W=7.6e-07 $X=6930 $Y=93870 $dt=15
M258 VSS! 742 479 VSS! nfet_01v8 L=1.5e-07 W=7.6e-07 $X=6930 $Y=102150 $dt=15
M259 VSS! 744 481 VSS! nfet_01v8 L=1.5e-07 W=7.6e-07 $X=6930 $Y=110430 $dt=15
M260 VSS! 746 483 VSS! nfet_01v8 L=1.5e-07 W=7.6e-07 $X=6930 $Y=118710 $dt=15
M261 VSS! 748 485 VSS! nfet_01v8 L=1.5e-07 W=7.6e-07 $X=6930 $Y=126990 $dt=15
M262 VSS! 750 487 VSS! nfet_01v8 L=1.5e-07 W=7.6e-07 $X=6930 $Y=135270 $dt=15
M263 VSS! 752 489 VSS! nfet_01v8 L=1.5e-07 W=7.6e-07 $X=6930 $Y=143550 $dt=15
M264 VSS! 754 491 VSS! nfet_01v8 L=1.5e-07 W=7.6e-07 $X=6930 $Y=151830 $dt=15
M265 VSS! 756 493 VSS! nfet_01v8 L=1.5e-07 W=7.6e-07 $X=6930 $Y=160110 $dt=15
M266 534 776 VSS! VSS! nfet_01v8 L=1.5e-07 W=7.6e-07 $X=7330 $Y=13010 $dt=15
M267 536 777 VSS! VSS! nfet_01v8 L=1.5e-07 W=7.6e-07 $X=7330 $Y=21290 $dt=15
M268 538 778 VSS! VSS! nfet_01v8 L=1.5e-07 W=7.6e-07 $X=7330 $Y=29570 $dt=15
M269 540 779 VSS! VSS! nfet_01v8 L=1.5e-07 W=7.6e-07 $X=7330 $Y=37850 $dt=15
M270 542 780 VSS! VSS! nfet_01v8 L=1.5e-07 W=7.6e-07 $X=7330 $Y=46130 $dt=15
M271 544 781 VSS! VSS! nfet_01v8 L=1.5e-07 W=7.6e-07 $X=7330 $Y=54410 $dt=15
M272 546 782 VSS! VSS! nfet_01v8 L=1.5e-07 W=7.6e-07 $X=7330 $Y=62690 $dt=15
M273 548 783 VSS! VSS! nfet_01v8 L=1.5e-07 W=7.6e-07 $X=7330 $Y=70970 $dt=15
M274 550 784 VSS! VSS! nfet_01v8 L=1.5e-07 W=7.6e-07 $X=7330 $Y=79250 $dt=15
M275 552 785 VSS! VSS! nfet_01v8 L=1.5e-07 W=7.6e-07 $X=7330 $Y=87530 $dt=15
M276 554 786 VSS! VSS! nfet_01v8 L=1.5e-07 W=7.6e-07 $X=7330 $Y=95810 $dt=15
M277 556 787 VSS! VSS! nfet_01v8 L=1.5e-07 W=7.6e-07 $X=7330 $Y=104090 $dt=15
M278 558 788 VSS! VSS! nfet_01v8 L=1.5e-07 W=7.6e-07 $X=7330 $Y=112370 $dt=15
M279 560 789 VSS! VSS! nfet_01v8 L=1.5e-07 W=7.6e-07 $X=7330 $Y=120650 $dt=15
M280 562 790 VSS! VSS! nfet_01v8 L=1.5e-07 W=7.6e-07 $X=7330 $Y=128930 $dt=15
M281 564 791 VSS! VSS! nfet_01v8 L=1.5e-07 W=7.6e-07 $X=7330 $Y=137210 $dt=15
M282 566 792 VSS! VSS! nfet_01v8 L=1.5e-07 W=7.6e-07 $X=7330 $Y=145490 $dt=15
M283 568 793 VSS! VSS! nfet_01v8 L=1.5e-07 W=7.6e-07 $X=7330 $Y=153770 $dt=15
M284 570 794 VSS! VSS! nfet_01v8 L=1.5e-07 W=7.6e-07 $X=7330 $Y=162050 $dt=15
M285 457 720 VSS! VSS! nfet_01v8 L=1.5e-07 W=7.6e-07 $X=7360 $Y=11070 $dt=15
M286 459 722 VSS! VSS! nfet_01v8 L=1.5e-07 W=7.6e-07 $X=7360 $Y=19350 $dt=15
M287 461 724 VSS! VSS! nfet_01v8 L=1.5e-07 W=7.6e-07 $X=7360 $Y=27630 $dt=15
M288 463 726 VSS! VSS! nfet_01v8 L=1.5e-07 W=7.6e-07 $X=7360 $Y=35910 $dt=15
M289 465 728 VSS! VSS! nfet_01v8 L=1.5e-07 W=7.6e-07 $X=7360 $Y=44190 $dt=15
M290 467 730 VSS! VSS! nfet_01v8 L=1.5e-07 W=7.6e-07 $X=7360 $Y=52470 $dt=15
M291 469 732 VSS! VSS! nfet_01v8 L=1.5e-07 W=7.6e-07 $X=7360 $Y=60750 $dt=15
M292 471 734 VSS! VSS! nfet_01v8 L=1.5e-07 W=7.6e-07 $X=7360 $Y=69030 $dt=15
M293 473 736 VSS! VSS! nfet_01v8 L=1.5e-07 W=7.6e-07 $X=7360 $Y=77310 $dt=15
M294 475 738 VSS! VSS! nfet_01v8 L=1.5e-07 W=7.6e-07 $X=7360 $Y=85590 $dt=15
M295 477 740 VSS! VSS! nfet_01v8 L=1.5e-07 W=7.6e-07 $X=7360 $Y=93870 $dt=15
M296 479 742 VSS! VSS! nfet_01v8 L=1.5e-07 W=7.6e-07 $X=7360 $Y=102150 $dt=15
M297 481 744 VSS! VSS! nfet_01v8 L=1.5e-07 W=7.6e-07 $X=7360 $Y=110430 $dt=15
M298 483 746 VSS! VSS! nfet_01v8 L=1.5e-07 W=7.6e-07 $X=7360 $Y=118710 $dt=15
M299 485 748 VSS! VSS! nfet_01v8 L=1.5e-07 W=7.6e-07 $X=7360 $Y=126990 $dt=15
M300 487 750 VSS! VSS! nfet_01v8 L=1.5e-07 W=7.6e-07 $X=7360 $Y=135270 $dt=15
M301 489 752 VSS! VSS! nfet_01v8 L=1.5e-07 W=7.6e-07 $X=7360 $Y=143550 $dt=15
M302 491 754 VSS! VSS! nfet_01v8 L=1.5e-07 W=7.6e-07 $X=7360 $Y=151830 $dt=15
M303 493 756 VSS! VSS! nfet_01v8 L=1.5e-07 W=7.6e-07 $X=7360 $Y=160110 $dt=15
M304 VSS! 776 534 VSS! nfet_01v8 L=1.5e-07 W=7.6e-07 $X=7760 $Y=13010 $dt=15
M305 VSS! 777 536 VSS! nfet_01v8 L=1.5e-07 W=7.6e-07 $X=7760 $Y=21290 $dt=15
M306 VSS! 778 538 VSS! nfet_01v8 L=1.5e-07 W=7.6e-07 $X=7760 $Y=29570 $dt=15
M307 VSS! 779 540 VSS! nfet_01v8 L=1.5e-07 W=7.6e-07 $X=7760 $Y=37850 $dt=15
M308 VSS! 780 542 VSS! nfet_01v8 L=1.5e-07 W=7.6e-07 $X=7760 $Y=46130 $dt=15
M309 VSS! 781 544 VSS! nfet_01v8 L=1.5e-07 W=7.6e-07 $X=7760 $Y=54410 $dt=15
M310 VSS! 782 546 VSS! nfet_01v8 L=1.5e-07 W=7.6e-07 $X=7760 $Y=62690 $dt=15
M311 VSS! 783 548 VSS! nfet_01v8 L=1.5e-07 W=7.6e-07 $X=7760 $Y=70970 $dt=15
M312 VSS! 784 550 VSS! nfet_01v8 L=1.5e-07 W=7.6e-07 $X=7760 $Y=79250 $dt=15
M313 VSS! 785 552 VSS! nfet_01v8 L=1.5e-07 W=7.6e-07 $X=7760 $Y=87530 $dt=15
M314 VSS! 786 554 VSS! nfet_01v8 L=1.5e-07 W=7.6e-07 $X=7760 $Y=95810 $dt=15
M315 VSS! 787 556 VSS! nfet_01v8 L=1.5e-07 W=7.6e-07 $X=7760 $Y=104090 $dt=15
M316 VSS! 788 558 VSS! nfet_01v8 L=1.5e-07 W=7.6e-07 $X=7760 $Y=112370 $dt=15
M317 VSS! 789 560 VSS! nfet_01v8 L=1.5e-07 W=7.6e-07 $X=7760 $Y=120650 $dt=15
M318 VSS! 790 562 VSS! nfet_01v8 L=1.5e-07 W=7.6e-07 $X=7760 $Y=128930 $dt=15
M319 VSS! 791 564 VSS! nfet_01v8 L=1.5e-07 W=7.6e-07 $X=7760 $Y=137210 $dt=15
M320 VSS! 792 566 VSS! nfet_01v8 L=1.5e-07 W=7.6e-07 $X=7760 $Y=145490 $dt=15
M321 VSS! 793 568 VSS! nfet_01v8 L=1.5e-07 W=7.6e-07 $X=7760 $Y=153770 $dt=15
M322 VSS! 794 570 VSS! nfet_01v8 L=1.5e-07 W=7.6e-07 $X=7760 $Y=162050 $dt=15
M323 VSS! 720 457 VSS! nfet_01v8 L=1.5e-07 W=7.6e-07 $X=7790 $Y=11070 $dt=15
M324 VSS! 722 459 VSS! nfet_01v8 L=1.5e-07 W=7.6e-07 $X=7790 $Y=19350 $dt=15
M325 VSS! 724 461 VSS! nfet_01v8 L=1.5e-07 W=7.6e-07 $X=7790 $Y=27630 $dt=15
M326 VSS! 726 463 VSS! nfet_01v8 L=1.5e-07 W=7.6e-07 $X=7790 $Y=35910 $dt=15
M327 VSS! 728 465 VSS! nfet_01v8 L=1.5e-07 W=7.6e-07 $X=7790 $Y=44190 $dt=15
M328 VSS! 730 467 VSS! nfet_01v8 L=1.5e-07 W=7.6e-07 $X=7790 $Y=52470 $dt=15
M329 VSS! 732 469 VSS! nfet_01v8 L=1.5e-07 W=7.6e-07 $X=7790 $Y=60750 $dt=15
M330 VSS! 734 471 VSS! nfet_01v8 L=1.5e-07 W=7.6e-07 $X=7790 $Y=69030 $dt=15
M331 VSS! 736 473 VSS! nfet_01v8 L=1.5e-07 W=7.6e-07 $X=7790 $Y=77310 $dt=15
M332 VSS! 738 475 VSS! nfet_01v8 L=1.5e-07 W=7.6e-07 $X=7790 $Y=85590 $dt=15
M333 VSS! 740 477 VSS! nfet_01v8 L=1.5e-07 W=7.6e-07 $X=7790 $Y=93870 $dt=15
M334 VSS! 742 479 VSS! nfet_01v8 L=1.5e-07 W=7.6e-07 $X=7790 $Y=102150 $dt=15
M335 VSS! 744 481 VSS! nfet_01v8 L=1.5e-07 W=7.6e-07 $X=7790 $Y=110430 $dt=15
M336 VSS! 746 483 VSS! nfet_01v8 L=1.5e-07 W=7.6e-07 $X=7790 $Y=118710 $dt=15
M337 VSS! 748 485 VSS! nfet_01v8 L=1.5e-07 W=7.6e-07 $X=7790 $Y=126990 $dt=15
M338 VSS! 750 487 VSS! nfet_01v8 L=1.5e-07 W=7.6e-07 $X=7790 $Y=135270 $dt=15
M339 VSS! 752 489 VSS! nfet_01v8 L=1.5e-07 W=7.6e-07 $X=7790 $Y=143550 $dt=15
M340 VSS! 754 491 VSS! nfet_01v8 L=1.5e-07 W=7.6e-07 $X=7790 $Y=151830 $dt=15
M341 VSS! 756 493 VSS! nfet_01v8 L=1.5e-07 W=7.6e-07 $X=7790 $Y=160110 $dt=15
M342 533 719 VSS! VSS! nfet_01v8 L=1.5e-07 W=7.6e-07 $X=8800 $Y=11070 $dt=15
M343 VSS! 720 757 VSS! nfet_01v8 L=1.5e-07 W=7.6e-07 $X=8800 $Y=13010 $dt=15
M344 535 721 VSS! VSS! nfet_01v8 L=1.5e-07 W=7.6e-07 $X=8800 $Y=19350 $dt=15
M345 VSS! 722 758 VSS! nfet_01v8 L=1.5e-07 W=7.6e-07 $X=8800 $Y=21290 $dt=15
M346 537 723 VSS! VSS! nfet_01v8 L=1.5e-07 W=7.6e-07 $X=8800 $Y=27630 $dt=15
M347 VSS! 724 759 VSS! nfet_01v8 L=1.5e-07 W=7.6e-07 $X=8800 $Y=29570 $dt=15
M348 539 725 VSS! VSS! nfet_01v8 L=1.5e-07 W=7.6e-07 $X=8800 $Y=35910 $dt=15
M349 VSS! 726 760 VSS! nfet_01v8 L=1.5e-07 W=7.6e-07 $X=8800 $Y=37850 $dt=15
M350 541 727 VSS! VSS! nfet_01v8 L=1.5e-07 W=7.6e-07 $X=8800 $Y=44190 $dt=15
M351 VSS! 728 761 VSS! nfet_01v8 L=1.5e-07 W=7.6e-07 $X=8800 $Y=46130 $dt=15
M352 543 729 VSS! VSS! nfet_01v8 L=1.5e-07 W=7.6e-07 $X=8800 $Y=52470 $dt=15
M353 VSS! 730 762 VSS! nfet_01v8 L=1.5e-07 W=7.6e-07 $X=8800 $Y=54410 $dt=15
M354 545 731 VSS! VSS! nfet_01v8 L=1.5e-07 W=7.6e-07 $X=8800 $Y=60750 $dt=15
M355 VSS! 732 763 VSS! nfet_01v8 L=1.5e-07 W=7.6e-07 $X=8800 $Y=62690 $dt=15
M356 547 733 VSS! VSS! nfet_01v8 L=1.5e-07 W=7.6e-07 $X=8800 $Y=69030 $dt=15
M357 VSS! 734 764 VSS! nfet_01v8 L=1.5e-07 W=7.6e-07 $X=8800 $Y=70970 $dt=15
M358 549 735 VSS! VSS! nfet_01v8 L=1.5e-07 W=7.6e-07 $X=8800 $Y=77310 $dt=15
M359 VSS! 736 765 VSS! nfet_01v8 L=1.5e-07 W=7.6e-07 $X=8800 $Y=79250 $dt=15
M360 551 737 VSS! VSS! nfet_01v8 L=1.5e-07 W=7.6e-07 $X=8800 $Y=85590 $dt=15
M361 VSS! 738 766 VSS! nfet_01v8 L=1.5e-07 W=7.6e-07 $X=8800 $Y=87530 $dt=15
M362 553 739 VSS! VSS! nfet_01v8 L=1.5e-07 W=7.6e-07 $X=8800 $Y=93870 $dt=15
M363 VSS! 740 767 VSS! nfet_01v8 L=1.5e-07 W=7.6e-07 $X=8800 $Y=95810 $dt=15
M364 555 741 VSS! VSS! nfet_01v8 L=1.5e-07 W=7.6e-07 $X=8800 $Y=102150 $dt=15
M365 VSS! 742 768 VSS! nfet_01v8 L=1.5e-07 W=7.6e-07 $X=8800 $Y=104090 $dt=15
M366 557 743 VSS! VSS! nfet_01v8 L=1.5e-07 W=7.6e-07 $X=8800 $Y=110430 $dt=15
M367 VSS! 744 769 VSS! nfet_01v8 L=1.5e-07 W=7.6e-07 $X=8800 $Y=112370 $dt=15
M368 559 745 VSS! VSS! nfet_01v8 L=1.5e-07 W=7.6e-07 $X=8800 $Y=118710 $dt=15
M369 VSS! 746 770 VSS! nfet_01v8 L=1.5e-07 W=7.6e-07 $X=8800 $Y=120650 $dt=15
M370 561 747 VSS! VSS! nfet_01v8 L=1.5e-07 W=7.6e-07 $X=8800 $Y=126990 $dt=15
M371 VSS! 748 771 VSS! nfet_01v8 L=1.5e-07 W=7.6e-07 $X=8800 $Y=128930 $dt=15
M372 563 749 VSS! VSS! nfet_01v8 L=1.5e-07 W=7.6e-07 $X=8800 $Y=135270 $dt=15
M373 VSS! 750 772 VSS! nfet_01v8 L=1.5e-07 W=7.6e-07 $X=8800 $Y=137210 $dt=15
M374 565 751 VSS! VSS! nfet_01v8 L=1.5e-07 W=7.6e-07 $X=8800 $Y=143550 $dt=15
M375 VSS! 752 773 VSS! nfet_01v8 L=1.5e-07 W=7.6e-07 $X=8800 $Y=145490 $dt=15
M376 567 753 VSS! VSS! nfet_01v8 L=1.5e-07 W=7.6e-07 $X=8800 $Y=151830 $dt=15
M377 VSS! 754 774 VSS! nfet_01v8 L=1.5e-07 W=7.6e-07 $X=8800 $Y=153770 $dt=15
M378 569 755 VSS! VSS! nfet_01v8 L=1.5e-07 W=7.6e-07 $X=8800 $Y=160110 $dt=15
M379 VSS! 756 775 VSS! nfet_01v8 L=1.5e-07 W=7.6e-07 $X=8800 $Y=162050 $dt=15
M380 VSS! 719 533 VSS! nfet_01v8 L=1.5e-07 W=7.6e-07 $X=9230 $Y=11070 $dt=15
M381 458 757 VSS! VSS! nfet_01v8 L=1.5e-07 W=7.6e-07 $X=9230 $Y=13010 $dt=15
M382 VSS! 721 535 VSS! nfet_01v8 L=1.5e-07 W=7.6e-07 $X=9230 $Y=19350 $dt=15
M383 460 758 VSS! VSS! nfet_01v8 L=1.5e-07 W=7.6e-07 $X=9230 $Y=21290 $dt=15
M384 VSS! 723 537 VSS! nfet_01v8 L=1.5e-07 W=7.6e-07 $X=9230 $Y=27630 $dt=15
M385 462 759 VSS! VSS! nfet_01v8 L=1.5e-07 W=7.6e-07 $X=9230 $Y=29570 $dt=15
M386 VSS! 725 539 VSS! nfet_01v8 L=1.5e-07 W=7.6e-07 $X=9230 $Y=35910 $dt=15
M387 464 760 VSS! VSS! nfet_01v8 L=1.5e-07 W=7.6e-07 $X=9230 $Y=37850 $dt=15
M388 VSS! 727 541 VSS! nfet_01v8 L=1.5e-07 W=7.6e-07 $X=9230 $Y=44190 $dt=15
M389 466 761 VSS! VSS! nfet_01v8 L=1.5e-07 W=7.6e-07 $X=9230 $Y=46130 $dt=15
M390 VSS! 729 543 VSS! nfet_01v8 L=1.5e-07 W=7.6e-07 $X=9230 $Y=52470 $dt=15
M391 468 762 VSS! VSS! nfet_01v8 L=1.5e-07 W=7.6e-07 $X=9230 $Y=54410 $dt=15
M392 VSS! 731 545 VSS! nfet_01v8 L=1.5e-07 W=7.6e-07 $X=9230 $Y=60750 $dt=15
M393 470 763 VSS! VSS! nfet_01v8 L=1.5e-07 W=7.6e-07 $X=9230 $Y=62690 $dt=15
M394 VSS! 733 547 VSS! nfet_01v8 L=1.5e-07 W=7.6e-07 $X=9230 $Y=69030 $dt=15
M395 472 764 VSS! VSS! nfet_01v8 L=1.5e-07 W=7.6e-07 $X=9230 $Y=70970 $dt=15
M396 VSS! 735 549 VSS! nfet_01v8 L=1.5e-07 W=7.6e-07 $X=9230 $Y=77310 $dt=15
M397 474 765 VSS! VSS! nfet_01v8 L=1.5e-07 W=7.6e-07 $X=9230 $Y=79250 $dt=15
M398 VSS! 737 551 VSS! nfet_01v8 L=1.5e-07 W=7.6e-07 $X=9230 $Y=85590 $dt=15
M399 476 766 VSS! VSS! nfet_01v8 L=1.5e-07 W=7.6e-07 $X=9230 $Y=87530 $dt=15
M400 VSS! 739 553 VSS! nfet_01v8 L=1.5e-07 W=7.6e-07 $X=9230 $Y=93870 $dt=15
M401 478 767 VSS! VSS! nfet_01v8 L=1.5e-07 W=7.6e-07 $X=9230 $Y=95810 $dt=15
M402 VSS! 741 555 VSS! nfet_01v8 L=1.5e-07 W=7.6e-07 $X=9230 $Y=102150 $dt=15
M403 480 768 VSS! VSS! nfet_01v8 L=1.5e-07 W=7.6e-07 $X=9230 $Y=104090 $dt=15
M404 VSS! 743 557 VSS! nfet_01v8 L=1.5e-07 W=7.6e-07 $X=9230 $Y=110430 $dt=15
M405 482 769 VSS! VSS! nfet_01v8 L=1.5e-07 W=7.6e-07 $X=9230 $Y=112370 $dt=15
M406 VSS! 745 559 VSS! nfet_01v8 L=1.5e-07 W=7.6e-07 $X=9230 $Y=118710 $dt=15
M407 484 770 VSS! VSS! nfet_01v8 L=1.5e-07 W=7.6e-07 $X=9230 $Y=120650 $dt=15
M408 VSS! 747 561 VSS! nfet_01v8 L=1.5e-07 W=7.6e-07 $X=9230 $Y=126990 $dt=15
M409 486 771 VSS! VSS! nfet_01v8 L=1.5e-07 W=7.6e-07 $X=9230 $Y=128930 $dt=15
M410 VSS! 749 563 VSS! nfet_01v8 L=1.5e-07 W=7.6e-07 $X=9230 $Y=135270 $dt=15
M411 488 772 VSS! VSS! nfet_01v8 L=1.5e-07 W=7.6e-07 $X=9230 $Y=137210 $dt=15
M412 VSS! 751 565 VSS! nfet_01v8 L=1.5e-07 W=7.6e-07 $X=9230 $Y=143550 $dt=15
M413 490 773 VSS! VSS! nfet_01v8 L=1.5e-07 W=7.6e-07 $X=9230 $Y=145490 $dt=15
M414 VSS! 753 567 VSS! nfet_01v8 L=1.5e-07 W=7.6e-07 $X=9230 $Y=151830 $dt=15
M415 492 774 VSS! VSS! nfet_01v8 L=1.5e-07 W=7.6e-07 $X=9230 $Y=153770 $dt=15
M416 VSS! 755 569 VSS! nfet_01v8 L=1.5e-07 W=7.6e-07 $X=9230 $Y=160110 $dt=15
M417 494 775 VSS! VSS! nfet_01v8 L=1.5e-07 W=7.6e-07 $X=9230 $Y=162050 $dt=15
M418 533 719 VSS! VSS! nfet_01v8 L=1.5e-07 W=7.6e-07 $X=9660 $Y=11070 $dt=15
M419 VSS! 757 458 VSS! nfet_01v8 L=1.5e-07 W=7.6e-07 $X=9660 $Y=13010 $dt=15
M420 535 721 VSS! VSS! nfet_01v8 L=1.5e-07 W=7.6e-07 $X=9660 $Y=19350 $dt=15
M421 VSS! 758 460 VSS! nfet_01v8 L=1.5e-07 W=7.6e-07 $X=9660 $Y=21290 $dt=15
M422 537 723 VSS! VSS! nfet_01v8 L=1.5e-07 W=7.6e-07 $X=9660 $Y=27630 $dt=15
M423 VSS! 759 462 VSS! nfet_01v8 L=1.5e-07 W=7.6e-07 $X=9660 $Y=29570 $dt=15
M424 539 725 VSS! VSS! nfet_01v8 L=1.5e-07 W=7.6e-07 $X=9660 $Y=35910 $dt=15
M425 VSS! 760 464 VSS! nfet_01v8 L=1.5e-07 W=7.6e-07 $X=9660 $Y=37850 $dt=15
M426 541 727 VSS! VSS! nfet_01v8 L=1.5e-07 W=7.6e-07 $X=9660 $Y=44190 $dt=15
M427 VSS! 761 466 VSS! nfet_01v8 L=1.5e-07 W=7.6e-07 $X=9660 $Y=46130 $dt=15
M428 543 729 VSS! VSS! nfet_01v8 L=1.5e-07 W=7.6e-07 $X=9660 $Y=52470 $dt=15
M429 VSS! 762 468 VSS! nfet_01v8 L=1.5e-07 W=7.6e-07 $X=9660 $Y=54410 $dt=15
M430 545 731 VSS! VSS! nfet_01v8 L=1.5e-07 W=7.6e-07 $X=9660 $Y=60750 $dt=15
M431 VSS! 763 470 VSS! nfet_01v8 L=1.5e-07 W=7.6e-07 $X=9660 $Y=62690 $dt=15
M432 547 733 VSS! VSS! nfet_01v8 L=1.5e-07 W=7.6e-07 $X=9660 $Y=69030 $dt=15
M433 VSS! 764 472 VSS! nfet_01v8 L=1.5e-07 W=7.6e-07 $X=9660 $Y=70970 $dt=15
M434 549 735 VSS! VSS! nfet_01v8 L=1.5e-07 W=7.6e-07 $X=9660 $Y=77310 $dt=15
M435 VSS! 765 474 VSS! nfet_01v8 L=1.5e-07 W=7.6e-07 $X=9660 $Y=79250 $dt=15
M436 551 737 VSS! VSS! nfet_01v8 L=1.5e-07 W=7.6e-07 $X=9660 $Y=85590 $dt=15
M437 VSS! 766 476 VSS! nfet_01v8 L=1.5e-07 W=7.6e-07 $X=9660 $Y=87530 $dt=15
M438 553 739 VSS! VSS! nfet_01v8 L=1.5e-07 W=7.6e-07 $X=9660 $Y=93870 $dt=15
M439 VSS! 767 478 VSS! nfet_01v8 L=1.5e-07 W=7.6e-07 $X=9660 $Y=95810 $dt=15
M440 555 741 VSS! VSS! nfet_01v8 L=1.5e-07 W=7.6e-07 $X=9660 $Y=102150 $dt=15
M441 VSS! 768 480 VSS! nfet_01v8 L=1.5e-07 W=7.6e-07 $X=9660 $Y=104090 $dt=15
M442 557 743 VSS! VSS! nfet_01v8 L=1.5e-07 W=7.6e-07 $X=9660 $Y=110430 $dt=15
M443 VSS! 769 482 VSS! nfet_01v8 L=1.5e-07 W=7.6e-07 $X=9660 $Y=112370 $dt=15
M444 559 745 VSS! VSS! nfet_01v8 L=1.5e-07 W=7.6e-07 $X=9660 $Y=118710 $dt=15
M445 VSS! 770 484 VSS! nfet_01v8 L=1.5e-07 W=7.6e-07 $X=9660 $Y=120650 $dt=15
M446 561 747 VSS! VSS! nfet_01v8 L=1.5e-07 W=7.6e-07 $X=9660 $Y=126990 $dt=15
M447 VSS! 771 486 VSS! nfet_01v8 L=1.5e-07 W=7.6e-07 $X=9660 $Y=128930 $dt=15
M448 563 749 VSS! VSS! nfet_01v8 L=1.5e-07 W=7.6e-07 $X=9660 $Y=135270 $dt=15
M449 VSS! 772 488 VSS! nfet_01v8 L=1.5e-07 W=7.6e-07 $X=9660 $Y=137210 $dt=15
M450 565 751 VSS! VSS! nfet_01v8 L=1.5e-07 W=7.6e-07 $X=9660 $Y=143550 $dt=15
M451 VSS! 773 490 VSS! nfet_01v8 L=1.5e-07 W=7.6e-07 $X=9660 $Y=145490 $dt=15
M452 567 753 VSS! VSS! nfet_01v8 L=1.5e-07 W=7.6e-07 $X=9660 $Y=151830 $dt=15
M453 VSS! 774 492 VSS! nfet_01v8 L=1.5e-07 W=7.6e-07 $X=9660 $Y=153770 $dt=15
M454 569 755 VSS! VSS! nfet_01v8 L=1.5e-07 W=7.6e-07 $X=9660 $Y=160110 $dt=15
M455 VSS! 775 494 VSS! nfet_01v8 L=1.5e-07 W=7.6e-07 $X=9660 $Y=162050 $dt=15
M456 VSS! 719 533 VSS! nfet_01v8 L=1.5e-07 W=7.6e-07 $X=10090 $Y=11070 $dt=15
M457 458 757 VSS! VSS! nfet_01v8 L=1.5e-07 W=7.6e-07 $X=10090 $Y=13010 $dt=15
M458 VSS! 721 535 VSS! nfet_01v8 L=1.5e-07 W=7.6e-07 $X=10090 $Y=19350 $dt=15
M459 460 758 VSS! VSS! nfet_01v8 L=1.5e-07 W=7.6e-07 $X=10090 $Y=21290 $dt=15
M460 VSS! 723 537 VSS! nfet_01v8 L=1.5e-07 W=7.6e-07 $X=10090 $Y=27630 $dt=15
M461 462 759 VSS! VSS! nfet_01v8 L=1.5e-07 W=7.6e-07 $X=10090 $Y=29570 $dt=15
M462 VSS! 725 539 VSS! nfet_01v8 L=1.5e-07 W=7.6e-07 $X=10090 $Y=35910 $dt=15
M463 464 760 VSS! VSS! nfet_01v8 L=1.5e-07 W=7.6e-07 $X=10090 $Y=37850 $dt=15
M464 VSS! 727 541 VSS! nfet_01v8 L=1.5e-07 W=7.6e-07 $X=10090 $Y=44190 $dt=15
M465 466 761 VSS! VSS! nfet_01v8 L=1.5e-07 W=7.6e-07 $X=10090 $Y=46130 $dt=15
M466 VSS! 729 543 VSS! nfet_01v8 L=1.5e-07 W=7.6e-07 $X=10090 $Y=52470 $dt=15
M467 468 762 VSS! VSS! nfet_01v8 L=1.5e-07 W=7.6e-07 $X=10090 $Y=54410 $dt=15
M468 VSS! 731 545 VSS! nfet_01v8 L=1.5e-07 W=7.6e-07 $X=10090 $Y=60750 $dt=15
M469 470 763 VSS! VSS! nfet_01v8 L=1.5e-07 W=7.6e-07 $X=10090 $Y=62690 $dt=15
M470 VSS! 733 547 VSS! nfet_01v8 L=1.5e-07 W=7.6e-07 $X=10090 $Y=69030 $dt=15
M471 472 764 VSS! VSS! nfet_01v8 L=1.5e-07 W=7.6e-07 $X=10090 $Y=70970 $dt=15
M472 VSS! 735 549 VSS! nfet_01v8 L=1.5e-07 W=7.6e-07 $X=10090 $Y=77310 $dt=15
M473 474 765 VSS! VSS! nfet_01v8 L=1.5e-07 W=7.6e-07 $X=10090 $Y=79250 $dt=15
M474 VSS! 737 551 VSS! nfet_01v8 L=1.5e-07 W=7.6e-07 $X=10090 $Y=85590 $dt=15
M475 476 766 VSS! VSS! nfet_01v8 L=1.5e-07 W=7.6e-07 $X=10090 $Y=87530 $dt=15
M476 VSS! 739 553 VSS! nfet_01v8 L=1.5e-07 W=7.6e-07 $X=10090 $Y=93870 $dt=15
M477 478 767 VSS! VSS! nfet_01v8 L=1.5e-07 W=7.6e-07 $X=10090 $Y=95810 $dt=15
M478 VSS! 741 555 VSS! nfet_01v8 L=1.5e-07 W=7.6e-07 $X=10090 $Y=102150 $dt=15
M479 480 768 VSS! VSS! nfet_01v8 L=1.5e-07 W=7.6e-07 $X=10090 $Y=104090 $dt=15
M480 VSS! 743 557 VSS! nfet_01v8 L=1.5e-07 W=7.6e-07 $X=10090 $Y=110430 $dt=15
M481 482 769 VSS! VSS! nfet_01v8 L=1.5e-07 W=7.6e-07 $X=10090 $Y=112370 $dt=15
M482 VSS! 745 559 VSS! nfet_01v8 L=1.5e-07 W=7.6e-07 $X=10090 $Y=118710 $dt=15
M483 484 770 VSS! VSS! nfet_01v8 L=1.5e-07 W=7.6e-07 $X=10090 $Y=120650 $dt=15
M484 VSS! 747 561 VSS! nfet_01v8 L=1.5e-07 W=7.6e-07 $X=10090 $Y=126990 $dt=15
M485 486 771 VSS! VSS! nfet_01v8 L=1.5e-07 W=7.6e-07 $X=10090 $Y=128930 $dt=15
M486 VSS! 749 563 VSS! nfet_01v8 L=1.5e-07 W=7.6e-07 $X=10090 $Y=135270 $dt=15
M487 488 772 VSS! VSS! nfet_01v8 L=1.5e-07 W=7.6e-07 $X=10090 $Y=137210 $dt=15
M488 VSS! 751 565 VSS! nfet_01v8 L=1.5e-07 W=7.6e-07 $X=10090 $Y=143550 $dt=15
M489 490 773 VSS! VSS! nfet_01v8 L=1.5e-07 W=7.6e-07 $X=10090 $Y=145490 $dt=15
M490 VSS! 753 567 VSS! nfet_01v8 L=1.5e-07 W=7.6e-07 $X=10090 $Y=151830 $dt=15
M491 492 774 VSS! VSS! nfet_01v8 L=1.5e-07 W=7.6e-07 $X=10090 $Y=153770 $dt=15
M492 VSS! 755 569 VSS! nfet_01v8 L=1.5e-07 W=7.6e-07 $X=10090 $Y=160110 $dt=15
M493 494 775 VSS! VSS! nfet_01v8 L=1.5e-07 W=7.6e-07 $X=10090 $Y=162050 $dt=15
M494 VSS! 757 458 VSS! nfet_01v8 L=1.5e-07 W=7.6e-07 $X=10520 $Y=13010 $dt=15
M495 VSS! 758 460 VSS! nfet_01v8 L=1.5e-07 W=7.6e-07 $X=10520 $Y=21290 $dt=15
M496 VSS! 759 462 VSS! nfet_01v8 L=1.5e-07 W=7.6e-07 $X=10520 $Y=29570 $dt=15
M497 VSS! 760 464 VSS! nfet_01v8 L=1.5e-07 W=7.6e-07 $X=10520 $Y=37850 $dt=15
M498 VSS! 761 466 VSS! nfet_01v8 L=1.5e-07 W=7.6e-07 $X=10520 $Y=46130 $dt=15
M499 VSS! 762 468 VSS! nfet_01v8 L=1.5e-07 W=7.6e-07 $X=10520 $Y=54410 $dt=15
M500 VSS! 763 470 VSS! nfet_01v8 L=1.5e-07 W=7.6e-07 $X=10520 $Y=62690 $dt=15
M501 VSS! 764 472 VSS! nfet_01v8 L=1.5e-07 W=7.6e-07 $X=10520 $Y=70970 $dt=15
M502 VSS! 765 474 VSS! nfet_01v8 L=1.5e-07 W=7.6e-07 $X=10520 $Y=79250 $dt=15
M503 VSS! 766 476 VSS! nfet_01v8 L=1.5e-07 W=7.6e-07 $X=10520 $Y=87530 $dt=15
M504 VSS! 767 478 VSS! nfet_01v8 L=1.5e-07 W=7.6e-07 $X=10520 $Y=95810 $dt=15
M505 VSS! 768 480 VSS! nfet_01v8 L=1.5e-07 W=7.6e-07 $X=10520 $Y=104090 $dt=15
M506 VSS! 769 482 VSS! nfet_01v8 L=1.5e-07 W=7.6e-07 $X=10520 $Y=112370 $dt=15
M507 VSS! 770 484 VSS! nfet_01v8 L=1.5e-07 W=7.6e-07 $X=10520 $Y=120650 $dt=15
M508 VSS! 771 486 VSS! nfet_01v8 L=1.5e-07 W=7.6e-07 $X=10520 $Y=128930 $dt=15
M509 VSS! 772 488 VSS! nfet_01v8 L=1.5e-07 W=7.6e-07 $X=10520 $Y=137210 $dt=15
M510 VSS! 773 490 VSS! nfet_01v8 L=1.5e-07 W=7.6e-07 $X=10520 $Y=145490 $dt=15
M511 VSS! 774 492 VSS! nfet_01v8 L=1.5e-07 W=7.6e-07 $X=10520 $Y=153770 $dt=15
M512 VSS! 775 494 VSS! nfet_01v8 L=1.5e-07 W=7.6e-07 $X=10520 $Y=162050 $dt=15
M513 700 681 VSS! VSS! nfet_01v8 L=1.5e-07 W=7.6e-07 $X=11560 $Y=13010 $dt=15
M514 701 682 VSS! VSS! nfet_01v8 L=1.5e-07 W=7.6e-07 $X=11560 $Y=21290 $dt=15
M515 702 683 VSS! VSS! nfet_01v8 L=1.5e-07 W=7.6e-07 $X=11560 $Y=29570 $dt=15
M516 703 684 VSS! VSS! nfet_01v8 L=1.5e-07 W=7.6e-07 $X=11560 $Y=37850 $dt=15
M517 704 685 VSS! VSS! nfet_01v8 L=1.5e-07 W=7.6e-07 $X=11560 $Y=46130 $dt=15
M518 705 686 VSS! VSS! nfet_01v8 L=1.5e-07 W=7.6e-07 $X=11560 $Y=54410 $dt=15
M519 706 687 VSS! VSS! nfet_01v8 L=1.5e-07 W=7.6e-07 $X=11560 $Y=62690 $dt=15
M520 707 688 VSS! VSS! nfet_01v8 L=1.5e-07 W=7.6e-07 $X=11560 $Y=70970 $dt=15
M521 708 689 VSS! VSS! nfet_01v8 L=1.5e-07 W=7.6e-07 $X=11560 $Y=79250 $dt=15
M522 709 690 VSS! VSS! nfet_01v8 L=1.5e-07 W=7.6e-07 $X=11560 $Y=87530 $dt=15
M523 710 691 VSS! VSS! nfet_01v8 L=1.5e-07 W=7.6e-07 $X=11560 $Y=95810 $dt=15
M524 711 692 VSS! VSS! nfet_01v8 L=1.5e-07 W=7.6e-07 $X=11560 $Y=104090 $dt=15
M525 712 693 VSS! VSS! nfet_01v8 L=1.5e-07 W=7.6e-07 $X=11560 $Y=112370 $dt=15
M526 713 694 VSS! VSS! nfet_01v8 L=1.5e-07 W=7.6e-07 $X=11560 $Y=120650 $dt=15
M527 714 695 VSS! VSS! nfet_01v8 L=1.5e-07 W=7.6e-07 $X=11560 $Y=128930 $dt=15
M528 715 696 VSS! VSS! nfet_01v8 L=1.5e-07 W=7.6e-07 $X=11560 $Y=137210 $dt=15
M529 716 697 VSS! VSS! nfet_01v8 L=1.5e-07 W=7.6e-07 $X=11560 $Y=145490 $dt=15
M530 717 698 VSS! VSS! nfet_01v8 L=1.5e-07 W=7.6e-07 $X=11560 $Y=153770 $dt=15
M531 718 699 VSS! VSS! nfet_01v8 L=1.5e-07 W=7.6e-07 $X=11560 $Y=162050 $dt=15
M532 VSS! 681 700 VSS! nfet_01v8 L=1.5e-07 W=7.6e-07 $X=11990 $Y=13010 $dt=15
M533 VSS! 682 701 VSS! nfet_01v8 L=1.5e-07 W=7.6e-07 $X=11990 $Y=21290 $dt=15
M534 VSS! 683 702 VSS! nfet_01v8 L=1.5e-07 W=7.6e-07 $X=11990 $Y=29570 $dt=15
M535 VSS! 684 703 VSS! nfet_01v8 L=1.5e-07 W=7.6e-07 $X=11990 $Y=37850 $dt=15
M536 VSS! 685 704 VSS! nfet_01v8 L=1.5e-07 W=7.6e-07 $X=11990 $Y=46130 $dt=15
M537 VSS! 686 705 VSS! nfet_01v8 L=1.5e-07 W=7.6e-07 $X=11990 $Y=54410 $dt=15
M538 VSS! 687 706 VSS! nfet_01v8 L=1.5e-07 W=7.6e-07 $X=11990 $Y=62690 $dt=15
M539 VSS! 688 707 VSS! nfet_01v8 L=1.5e-07 W=7.6e-07 $X=11990 $Y=70970 $dt=15
M540 VSS! 689 708 VSS! nfet_01v8 L=1.5e-07 W=7.6e-07 $X=11990 $Y=79250 $dt=15
M541 VSS! 690 709 VSS! nfet_01v8 L=1.5e-07 W=7.6e-07 $X=11990 $Y=87530 $dt=15
M542 VSS! 691 710 VSS! nfet_01v8 L=1.5e-07 W=7.6e-07 $X=11990 $Y=95810 $dt=15
M543 VSS! 692 711 VSS! nfet_01v8 L=1.5e-07 W=7.6e-07 $X=11990 $Y=104090 $dt=15
M544 VSS! 693 712 VSS! nfet_01v8 L=1.5e-07 W=7.6e-07 $X=11990 $Y=112370 $dt=15
M545 VSS! 694 713 VSS! nfet_01v8 L=1.5e-07 W=7.6e-07 $X=11990 $Y=120650 $dt=15
M546 VSS! 695 714 VSS! nfet_01v8 L=1.5e-07 W=7.6e-07 $X=11990 $Y=128930 $dt=15
M547 VSS! 696 715 VSS! nfet_01v8 L=1.5e-07 W=7.6e-07 $X=11990 $Y=137210 $dt=15
M548 VSS! 697 716 VSS! nfet_01v8 L=1.5e-07 W=7.6e-07 $X=11990 $Y=145490 $dt=15
M549 VSS! 698 717 VSS! nfet_01v8 L=1.5e-07 W=7.6e-07 $X=11990 $Y=153770 $dt=15
M550 VSS! 699 718 VSS! nfet_01v8 L=1.5e-07 W=7.6e-07 $X=11990 $Y=162050 $dt=15
M551 495 700 VSS! VSS! nfet_01v8 L=1.5e-07 W=7.6e-07 $X=12420 $Y=13010 $dt=15
M552 496 701 VSS! VSS! nfet_01v8 L=1.5e-07 W=7.6e-07 $X=12420 $Y=21290 $dt=15
M553 497 702 VSS! VSS! nfet_01v8 L=1.5e-07 W=7.6e-07 $X=12420 $Y=29570 $dt=15
M554 498 703 VSS! VSS! nfet_01v8 L=1.5e-07 W=7.6e-07 $X=12420 $Y=37850 $dt=15
M555 499 704 VSS! VSS! nfet_01v8 L=1.5e-07 W=7.6e-07 $X=12420 $Y=46130 $dt=15
M556 500 705 VSS! VSS! nfet_01v8 L=1.5e-07 W=7.6e-07 $X=12420 $Y=54410 $dt=15
M557 501 706 VSS! VSS! nfet_01v8 L=1.5e-07 W=7.6e-07 $X=12420 $Y=62690 $dt=15
M558 502 707 VSS! VSS! nfet_01v8 L=1.5e-07 W=7.6e-07 $X=12420 $Y=70970 $dt=15
M559 503 708 VSS! VSS! nfet_01v8 L=1.5e-07 W=7.6e-07 $X=12420 $Y=79250 $dt=15
M560 504 709 VSS! VSS! nfet_01v8 L=1.5e-07 W=7.6e-07 $X=12420 $Y=87530 $dt=15
M561 505 710 VSS! VSS! nfet_01v8 L=1.5e-07 W=7.6e-07 $X=12420 $Y=95810 $dt=15
M562 506 711 VSS! VSS! nfet_01v8 L=1.5e-07 W=7.6e-07 $X=12420 $Y=104090 $dt=15
M563 507 712 VSS! VSS! nfet_01v8 L=1.5e-07 W=7.6e-07 $X=12420 $Y=112370 $dt=15
M564 508 713 VSS! VSS! nfet_01v8 L=1.5e-07 W=7.6e-07 $X=12420 $Y=120650 $dt=15
M565 509 714 VSS! VSS! nfet_01v8 L=1.5e-07 W=7.6e-07 $X=12420 $Y=128930 $dt=15
M566 510 715 VSS! VSS! nfet_01v8 L=1.5e-07 W=7.6e-07 $X=12420 $Y=137210 $dt=15
M567 511 716 VSS! VSS! nfet_01v8 L=1.5e-07 W=7.6e-07 $X=12420 $Y=145490 $dt=15
M568 512 717 VSS! VSS! nfet_01v8 L=1.5e-07 W=7.6e-07 $X=12420 $Y=153770 $dt=15
M569 513 718 VSS! VSS! nfet_01v8 L=1.5e-07 W=7.6e-07 $X=12420 $Y=162050 $dt=15
M570 514 681 VSS! VSS! nfet_01v8 L=1.5e-07 W=7.6e-07 $X=12480 $Y=11070 $dt=15
M571 515 682 VSS! VSS! nfet_01v8 L=1.5e-07 W=7.6e-07 $X=12480 $Y=19350 $dt=15
M572 516 683 VSS! VSS! nfet_01v8 L=1.5e-07 W=7.6e-07 $X=12480 $Y=27630 $dt=15
M573 517 684 VSS! VSS! nfet_01v8 L=1.5e-07 W=7.6e-07 $X=12480 $Y=35910 $dt=15
M574 518 685 VSS! VSS! nfet_01v8 L=1.5e-07 W=7.6e-07 $X=12480 $Y=44190 $dt=15
M575 519 686 VSS! VSS! nfet_01v8 L=1.5e-07 W=7.6e-07 $X=12480 $Y=52470 $dt=15
M576 520 687 VSS! VSS! nfet_01v8 L=1.5e-07 W=7.6e-07 $X=12480 $Y=60750 $dt=15
M577 521 688 VSS! VSS! nfet_01v8 L=1.5e-07 W=7.6e-07 $X=12480 $Y=69030 $dt=15
M578 522 689 VSS! VSS! nfet_01v8 L=1.5e-07 W=7.6e-07 $X=12480 $Y=77310 $dt=15
M579 523 690 VSS! VSS! nfet_01v8 L=1.5e-07 W=7.6e-07 $X=12480 $Y=85590 $dt=15
M580 524 691 VSS! VSS! nfet_01v8 L=1.5e-07 W=7.6e-07 $X=12480 $Y=93870 $dt=15
M581 525 692 VSS! VSS! nfet_01v8 L=1.5e-07 W=7.6e-07 $X=12480 $Y=102150 $dt=15
M582 526 693 VSS! VSS! nfet_01v8 L=1.5e-07 W=7.6e-07 $X=12480 $Y=110430 $dt=15
M583 527 694 VSS! VSS! nfet_01v8 L=1.5e-07 W=7.6e-07 $X=12480 $Y=118710 $dt=15
M584 528 695 VSS! VSS! nfet_01v8 L=1.5e-07 W=7.6e-07 $X=12480 $Y=126990 $dt=15
M585 529 696 VSS! VSS! nfet_01v8 L=1.5e-07 W=7.6e-07 $X=12480 $Y=135270 $dt=15
M586 530 697 VSS! VSS! nfet_01v8 L=1.5e-07 W=7.6e-07 $X=12480 $Y=143550 $dt=15
M587 531 698 VSS! VSS! nfet_01v8 L=1.5e-07 W=7.6e-07 $X=12480 $Y=151830 $dt=15
M588 532 699 VSS! VSS! nfet_01v8 L=1.5e-07 W=7.6e-07 $X=12480 $Y=160110 $dt=15
M589 VSS! 700 495 VSS! nfet_01v8 L=1.5e-07 W=7.6e-07 $X=12850 $Y=13010 $dt=15
M590 VSS! 701 496 VSS! nfet_01v8 L=1.5e-07 W=7.6e-07 $X=12850 $Y=21290 $dt=15
M591 VSS! 702 497 VSS! nfet_01v8 L=1.5e-07 W=7.6e-07 $X=12850 $Y=29570 $dt=15
M592 VSS! 703 498 VSS! nfet_01v8 L=1.5e-07 W=7.6e-07 $X=12850 $Y=37850 $dt=15
M593 VSS! 704 499 VSS! nfet_01v8 L=1.5e-07 W=7.6e-07 $X=12850 $Y=46130 $dt=15
M594 VSS! 705 500 VSS! nfet_01v8 L=1.5e-07 W=7.6e-07 $X=12850 $Y=54410 $dt=15
M595 VSS! 706 501 VSS! nfet_01v8 L=1.5e-07 W=7.6e-07 $X=12850 $Y=62690 $dt=15
M596 VSS! 707 502 VSS! nfet_01v8 L=1.5e-07 W=7.6e-07 $X=12850 $Y=70970 $dt=15
M597 VSS! 708 503 VSS! nfet_01v8 L=1.5e-07 W=7.6e-07 $X=12850 $Y=79250 $dt=15
M598 VSS! 709 504 VSS! nfet_01v8 L=1.5e-07 W=7.6e-07 $X=12850 $Y=87530 $dt=15
M599 VSS! 710 505 VSS! nfet_01v8 L=1.5e-07 W=7.6e-07 $X=12850 $Y=95810 $dt=15
M600 VSS! 711 506 VSS! nfet_01v8 L=1.5e-07 W=7.6e-07 $X=12850 $Y=104090 $dt=15
M601 VSS! 712 507 VSS! nfet_01v8 L=1.5e-07 W=7.6e-07 $X=12850 $Y=112370 $dt=15
M602 VSS! 713 508 VSS! nfet_01v8 L=1.5e-07 W=7.6e-07 $X=12850 $Y=120650 $dt=15
M603 VSS! 714 509 VSS! nfet_01v8 L=1.5e-07 W=7.6e-07 $X=12850 $Y=128930 $dt=15
M604 VSS! 715 510 VSS! nfet_01v8 L=1.5e-07 W=7.6e-07 $X=12850 $Y=137210 $dt=15
M605 VSS! 716 511 VSS! nfet_01v8 L=1.5e-07 W=7.6e-07 $X=12850 $Y=145490 $dt=15
M606 VSS! 717 512 VSS! nfet_01v8 L=1.5e-07 W=7.6e-07 $X=12850 $Y=153770 $dt=15
M607 VSS! 718 513 VSS! nfet_01v8 L=1.5e-07 W=7.6e-07 $X=12850 $Y=162050 $dt=15
M608 VSS! 681 514 VSS! nfet_01v8 L=1.5e-07 W=7.6e-07 $X=12910 $Y=11070 $dt=15
M609 VSS! 682 515 VSS! nfet_01v8 L=1.5e-07 W=7.6e-07 $X=12910 $Y=19350 $dt=15
M610 VSS! 683 516 VSS! nfet_01v8 L=1.5e-07 W=7.6e-07 $X=12910 $Y=27630 $dt=15
M611 VSS! 684 517 VSS! nfet_01v8 L=1.5e-07 W=7.6e-07 $X=12910 $Y=35910 $dt=15
M612 VSS! 685 518 VSS! nfet_01v8 L=1.5e-07 W=7.6e-07 $X=12910 $Y=44190 $dt=15
M613 VSS! 686 519 VSS! nfet_01v8 L=1.5e-07 W=7.6e-07 $X=12910 $Y=52470 $dt=15
M614 VSS! 687 520 VSS! nfet_01v8 L=1.5e-07 W=7.6e-07 $X=12910 $Y=60750 $dt=15
M615 VSS! 688 521 VSS! nfet_01v8 L=1.5e-07 W=7.6e-07 $X=12910 $Y=69030 $dt=15
M616 VSS! 689 522 VSS! nfet_01v8 L=1.5e-07 W=7.6e-07 $X=12910 $Y=77310 $dt=15
M617 VSS! 690 523 VSS! nfet_01v8 L=1.5e-07 W=7.6e-07 $X=12910 $Y=85590 $dt=15
M618 VSS! 691 524 VSS! nfet_01v8 L=1.5e-07 W=7.6e-07 $X=12910 $Y=93870 $dt=15
M619 VSS! 692 525 VSS! nfet_01v8 L=1.5e-07 W=7.6e-07 $X=12910 $Y=102150 $dt=15
M620 VSS! 693 526 VSS! nfet_01v8 L=1.5e-07 W=7.6e-07 $X=12910 $Y=110430 $dt=15
M621 VSS! 694 527 VSS! nfet_01v8 L=1.5e-07 W=7.6e-07 $X=12910 $Y=118710 $dt=15
M622 VSS! 695 528 VSS! nfet_01v8 L=1.5e-07 W=7.6e-07 $X=12910 $Y=126990 $dt=15
M623 VSS! 696 529 VSS! nfet_01v8 L=1.5e-07 W=7.6e-07 $X=12910 $Y=135270 $dt=15
M624 VSS! 697 530 VSS! nfet_01v8 L=1.5e-07 W=7.6e-07 $X=12910 $Y=143550 $dt=15
M625 VSS! 698 531 VSS! nfet_01v8 L=1.5e-07 W=7.6e-07 $X=12910 $Y=151830 $dt=15
M626 VSS! 699 532 VSS! nfet_01v8 L=1.5e-07 W=7.6e-07 $X=12910 $Y=160110 $dt=15
M627 495 700 VSS! VSS! nfet_01v8 L=1.5e-07 W=7.6e-07 $X=13280 $Y=13010 $dt=15
M628 496 701 VSS! VSS! nfet_01v8 L=1.5e-07 W=7.6e-07 $X=13280 $Y=21290 $dt=15
M629 497 702 VSS! VSS! nfet_01v8 L=1.5e-07 W=7.6e-07 $X=13280 $Y=29570 $dt=15
M630 498 703 VSS! VSS! nfet_01v8 L=1.5e-07 W=7.6e-07 $X=13280 $Y=37850 $dt=15
M631 499 704 VSS! VSS! nfet_01v8 L=1.5e-07 W=7.6e-07 $X=13280 $Y=46130 $dt=15
M632 500 705 VSS! VSS! nfet_01v8 L=1.5e-07 W=7.6e-07 $X=13280 $Y=54410 $dt=15
M633 501 706 VSS! VSS! nfet_01v8 L=1.5e-07 W=7.6e-07 $X=13280 $Y=62690 $dt=15
M634 502 707 VSS! VSS! nfet_01v8 L=1.5e-07 W=7.6e-07 $X=13280 $Y=70970 $dt=15
M635 503 708 VSS! VSS! nfet_01v8 L=1.5e-07 W=7.6e-07 $X=13280 $Y=79250 $dt=15
M636 504 709 VSS! VSS! nfet_01v8 L=1.5e-07 W=7.6e-07 $X=13280 $Y=87530 $dt=15
M637 505 710 VSS! VSS! nfet_01v8 L=1.5e-07 W=7.6e-07 $X=13280 $Y=95810 $dt=15
M638 506 711 VSS! VSS! nfet_01v8 L=1.5e-07 W=7.6e-07 $X=13280 $Y=104090 $dt=15
M639 507 712 VSS! VSS! nfet_01v8 L=1.5e-07 W=7.6e-07 $X=13280 $Y=112370 $dt=15
M640 508 713 VSS! VSS! nfet_01v8 L=1.5e-07 W=7.6e-07 $X=13280 $Y=120650 $dt=15
M641 509 714 VSS! VSS! nfet_01v8 L=1.5e-07 W=7.6e-07 $X=13280 $Y=128930 $dt=15
M642 510 715 VSS! VSS! nfet_01v8 L=1.5e-07 W=7.6e-07 $X=13280 $Y=137210 $dt=15
M643 511 716 VSS! VSS! nfet_01v8 L=1.5e-07 W=7.6e-07 $X=13280 $Y=145490 $dt=15
M644 512 717 VSS! VSS! nfet_01v8 L=1.5e-07 W=7.6e-07 $X=13280 $Y=153770 $dt=15
M645 513 718 VSS! VSS! nfet_01v8 L=1.5e-07 W=7.6e-07 $X=13280 $Y=162050 $dt=15
M646 514 681 VSS! VSS! nfet_01v8 L=1.5e-07 W=7.6e-07 $X=13340 $Y=11070 $dt=15
M647 515 682 VSS! VSS! nfet_01v8 L=1.5e-07 W=7.6e-07 $X=13340 $Y=19350 $dt=15
M648 516 683 VSS! VSS! nfet_01v8 L=1.5e-07 W=7.6e-07 $X=13340 $Y=27630 $dt=15
M649 517 684 VSS! VSS! nfet_01v8 L=1.5e-07 W=7.6e-07 $X=13340 $Y=35910 $dt=15
M650 518 685 VSS! VSS! nfet_01v8 L=1.5e-07 W=7.6e-07 $X=13340 $Y=44190 $dt=15
M651 519 686 VSS! VSS! nfet_01v8 L=1.5e-07 W=7.6e-07 $X=13340 $Y=52470 $dt=15
M652 520 687 VSS! VSS! nfet_01v8 L=1.5e-07 W=7.6e-07 $X=13340 $Y=60750 $dt=15
M653 521 688 VSS! VSS! nfet_01v8 L=1.5e-07 W=7.6e-07 $X=13340 $Y=69030 $dt=15
M654 522 689 VSS! VSS! nfet_01v8 L=1.5e-07 W=7.6e-07 $X=13340 $Y=77310 $dt=15
M655 523 690 VSS! VSS! nfet_01v8 L=1.5e-07 W=7.6e-07 $X=13340 $Y=85590 $dt=15
M656 524 691 VSS! VSS! nfet_01v8 L=1.5e-07 W=7.6e-07 $X=13340 $Y=93870 $dt=15
M657 525 692 VSS! VSS! nfet_01v8 L=1.5e-07 W=7.6e-07 $X=13340 $Y=102150 $dt=15
M658 526 693 VSS! VSS! nfet_01v8 L=1.5e-07 W=7.6e-07 $X=13340 $Y=110430 $dt=15
M659 527 694 VSS! VSS! nfet_01v8 L=1.5e-07 W=7.6e-07 $X=13340 $Y=118710 $dt=15
M660 528 695 VSS! VSS! nfet_01v8 L=1.5e-07 W=7.6e-07 $X=13340 $Y=126990 $dt=15
M661 529 696 VSS! VSS! nfet_01v8 L=1.5e-07 W=7.6e-07 $X=13340 $Y=135270 $dt=15
M662 530 697 VSS! VSS! nfet_01v8 L=1.5e-07 W=7.6e-07 $X=13340 $Y=143550 $dt=15
M663 531 698 VSS! VSS! nfet_01v8 L=1.5e-07 W=7.6e-07 $X=13340 $Y=151830 $dt=15
M664 532 699 VSS! VSS! nfet_01v8 L=1.5e-07 W=7.6e-07 $X=13340 $Y=160110 $dt=15
M665 VSS! 700 495 VSS! nfet_01v8 L=1.5e-07 W=7.6e-07 $X=13710 $Y=13010 $dt=15
M666 VSS! 701 496 VSS! nfet_01v8 L=1.5e-07 W=7.6e-07 $X=13710 $Y=21290 $dt=15
M667 VSS! 702 497 VSS! nfet_01v8 L=1.5e-07 W=7.6e-07 $X=13710 $Y=29570 $dt=15
M668 VSS! 703 498 VSS! nfet_01v8 L=1.5e-07 W=7.6e-07 $X=13710 $Y=37850 $dt=15
M669 VSS! 704 499 VSS! nfet_01v8 L=1.5e-07 W=7.6e-07 $X=13710 $Y=46130 $dt=15
M670 VSS! 705 500 VSS! nfet_01v8 L=1.5e-07 W=7.6e-07 $X=13710 $Y=54410 $dt=15
M671 VSS! 706 501 VSS! nfet_01v8 L=1.5e-07 W=7.6e-07 $X=13710 $Y=62690 $dt=15
M672 VSS! 707 502 VSS! nfet_01v8 L=1.5e-07 W=7.6e-07 $X=13710 $Y=70970 $dt=15
M673 VSS! 708 503 VSS! nfet_01v8 L=1.5e-07 W=7.6e-07 $X=13710 $Y=79250 $dt=15
M674 VSS! 709 504 VSS! nfet_01v8 L=1.5e-07 W=7.6e-07 $X=13710 $Y=87530 $dt=15
M675 VSS! 710 505 VSS! nfet_01v8 L=1.5e-07 W=7.6e-07 $X=13710 $Y=95810 $dt=15
M676 VSS! 711 506 VSS! nfet_01v8 L=1.5e-07 W=7.6e-07 $X=13710 $Y=104090 $dt=15
M677 VSS! 712 507 VSS! nfet_01v8 L=1.5e-07 W=7.6e-07 $X=13710 $Y=112370 $dt=15
M678 VSS! 713 508 VSS! nfet_01v8 L=1.5e-07 W=7.6e-07 $X=13710 $Y=120650 $dt=15
M679 VSS! 714 509 VSS! nfet_01v8 L=1.5e-07 W=7.6e-07 $X=13710 $Y=128930 $dt=15
M680 VSS! 715 510 VSS! nfet_01v8 L=1.5e-07 W=7.6e-07 $X=13710 $Y=137210 $dt=15
M681 VSS! 716 511 VSS! nfet_01v8 L=1.5e-07 W=7.6e-07 $X=13710 $Y=145490 $dt=15
M682 VSS! 717 512 VSS! nfet_01v8 L=1.5e-07 W=7.6e-07 $X=13710 $Y=153770 $dt=15
M683 VSS! 718 513 VSS! nfet_01v8 L=1.5e-07 W=7.6e-07 $X=13710 $Y=162050 $dt=15
M684 VSS! 681 514 VSS! nfet_01v8 L=1.5e-07 W=7.6e-07 $X=13770 $Y=11070 $dt=15
M685 VSS! 682 515 VSS! nfet_01v8 L=1.5e-07 W=7.6e-07 $X=13770 $Y=19350 $dt=15
M686 VSS! 683 516 VSS! nfet_01v8 L=1.5e-07 W=7.6e-07 $X=13770 $Y=27630 $dt=15
M687 VSS! 684 517 VSS! nfet_01v8 L=1.5e-07 W=7.6e-07 $X=13770 $Y=35910 $dt=15
M688 VSS! 685 518 VSS! nfet_01v8 L=1.5e-07 W=7.6e-07 $X=13770 $Y=44190 $dt=15
M689 VSS! 686 519 VSS! nfet_01v8 L=1.5e-07 W=7.6e-07 $X=13770 $Y=52470 $dt=15
M690 VSS! 687 520 VSS! nfet_01v8 L=1.5e-07 W=7.6e-07 $X=13770 $Y=60750 $dt=15
M691 VSS! 688 521 VSS! nfet_01v8 L=1.5e-07 W=7.6e-07 $X=13770 $Y=69030 $dt=15
M692 VSS! 689 522 VSS! nfet_01v8 L=1.5e-07 W=7.6e-07 $X=13770 $Y=77310 $dt=15
M693 VSS! 690 523 VSS! nfet_01v8 L=1.5e-07 W=7.6e-07 $X=13770 $Y=85590 $dt=15
M694 VSS! 691 524 VSS! nfet_01v8 L=1.5e-07 W=7.6e-07 $X=13770 $Y=93870 $dt=15
M695 VSS! 692 525 VSS! nfet_01v8 L=1.5e-07 W=7.6e-07 $X=13770 $Y=102150 $dt=15
M696 VSS! 693 526 VSS! nfet_01v8 L=1.5e-07 W=7.6e-07 $X=13770 $Y=110430 $dt=15
M697 VSS! 694 527 VSS! nfet_01v8 L=1.5e-07 W=7.6e-07 $X=13770 $Y=118710 $dt=15
M698 VSS! 695 528 VSS! nfet_01v8 L=1.5e-07 W=7.6e-07 $X=13770 $Y=126990 $dt=15
M699 VSS! 696 529 VSS! nfet_01v8 L=1.5e-07 W=7.6e-07 $X=13770 $Y=135270 $dt=15
M700 VSS! 697 530 VSS! nfet_01v8 L=1.5e-07 W=7.6e-07 $X=13770 $Y=143550 $dt=15
M701 VSS! 698 531 VSS! nfet_01v8 L=1.5e-07 W=7.6e-07 $X=13770 $Y=151830 $dt=15
M702 VSS! 699 532 VSS! nfet_01v8 L=1.5e-07 W=7.6e-07 $X=13770 $Y=160110 $dt=15
M703 495 700 VSS! VSS! nfet_01v8 L=1.5e-07 W=7.6e-07 $X=14140 $Y=13010 $dt=15
M704 496 701 VSS! VSS! nfet_01v8 L=1.5e-07 W=7.6e-07 $X=14140 $Y=21290 $dt=15
M705 497 702 VSS! VSS! nfet_01v8 L=1.5e-07 W=7.6e-07 $X=14140 $Y=29570 $dt=15
M706 498 703 VSS! VSS! nfet_01v8 L=1.5e-07 W=7.6e-07 $X=14140 $Y=37850 $dt=15
M707 499 704 VSS! VSS! nfet_01v8 L=1.5e-07 W=7.6e-07 $X=14140 $Y=46130 $dt=15
M708 500 705 VSS! VSS! nfet_01v8 L=1.5e-07 W=7.6e-07 $X=14140 $Y=54410 $dt=15
M709 501 706 VSS! VSS! nfet_01v8 L=1.5e-07 W=7.6e-07 $X=14140 $Y=62690 $dt=15
M710 502 707 VSS! VSS! nfet_01v8 L=1.5e-07 W=7.6e-07 $X=14140 $Y=70970 $dt=15
M711 503 708 VSS! VSS! nfet_01v8 L=1.5e-07 W=7.6e-07 $X=14140 $Y=79250 $dt=15
M712 504 709 VSS! VSS! nfet_01v8 L=1.5e-07 W=7.6e-07 $X=14140 $Y=87530 $dt=15
M713 505 710 VSS! VSS! nfet_01v8 L=1.5e-07 W=7.6e-07 $X=14140 $Y=95810 $dt=15
M714 506 711 VSS! VSS! nfet_01v8 L=1.5e-07 W=7.6e-07 $X=14140 $Y=104090 $dt=15
M715 507 712 VSS! VSS! nfet_01v8 L=1.5e-07 W=7.6e-07 $X=14140 $Y=112370 $dt=15
M716 508 713 VSS! VSS! nfet_01v8 L=1.5e-07 W=7.6e-07 $X=14140 $Y=120650 $dt=15
M717 509 714 VSS! VSS! nfet_01v8 L=1.5e-07 W=7.6e-07 $X=14140 $Y=128930 $dt=15
M718 510 715 VSS! VSS! nfet_01v8 L=1.5e-07 W=7.6e-07 $X=14140 $Y=137210 $dt=15
M719 511 716 VSS! VSS! nfet_01v8 L=1.5e-07 W=7.6e-07 $X=14140 $Y=145490 $dt=15
M720 512 717 VSS! VSS! nfet_01v8 L=1.5e-07 W=7.6e-07 $X=14140 $Y=153770 $dt=15
M721 513 718 VSS! VSS! nfet_01v8 L=1.5e-07 W=7.6e-07 $X=14140 $Y=162050 $dt=15
M722 514 681 VSS! VSS! nfet_01v8 L=1.5e-07 W=7.6e-07 $X=14200 $Y=11070 $dt=15
M723 515 682 VSS! VSS! nfet_01v8 L=1.5e-07 W=7.6e-07 $X=14200 $Y=19350 $dt=15
M724 516 683 VSS! VSS! nfet_01v8 L=1.5e-07 W=7.6e-07 $X=14200 $Y=27630 $dt=15
M725 517 684 VSS! VSS! nfet_01v8 L=1.5e-07 W=7.6e-07 $X=14200 $Y=35910 $dt=15
M726 518 685 VSS! VSS! nfet_01v8 L=1.5e-07 W=7.6e-07 $X=14200 $Y=44190 $dt=15
M727 519 686 VSS! VSS! nfet_01v8 L=1.5e-07 W=7.6e-07 $X=14200 $Y=52470 $dt=15
M728 520 687 VSS! VSS! nfet_01v8 L=1.5e-07 W=7.6e-07 $X=14200 $Y=60750 $dt=15
M729 521 688 VSS! VSS! nfet_01v8 L=1.5e-07 W=7.6e-07 $X=14200 $Y=69030 $dt=15
M730 522 689 VSS! VSS! nfet_01v8 L=1.5e-07 W=7.6e-07 $X=14200 $Y=77310 $dt=15
M731 523 690 VSS! VSS! nfet_01v8 L=1.5e-07 W=7.6e-07 $X=14200 $Y=85590 $dt=15
M732 524 691 VSS! VSS! nfet_01v8 L=1.5e-07 W=7.6e-07 $X=14200 $Y=93870 $dt=15
M733 525 692 VSS! VSS! nfet_01v8 L=1.5e-07 W=7.6e-07 $X=14200 $Y=102150 $dt=15
M734 526 693 VSS! VSS! nfet_01v8 L=1.5e-07 W=7.6e-07 $X=14200 $Y=110430 $dt=15
M735 527 694 VSS! VSS! nfet_01v8 L=1.5e-07 W=7.6e-07 $X=14200 $Y=118710 $dt=15
M736 528 695 VSS! VSS! nfet_01v8 L=1.5e-07 W=7.6e-07 $X=14200 $Y=126990 $dt=15
M737 529 696 VSS! VSS! nfet_01v8 L=1.5e-07 W=7.6e-07 $X=14200 $Y=135270 $dt=15
M738 530 697 VSS! VSS! nfet_01v8 L=1.5e-07 W=7.6e-07 $X=14200 $Y=143550 $dt=15
M739 531 698 VSS! VSS! nfet_01v8 L=1.5e-07 W=7.6e-07 $X=14200 $Y=151830 $dt=15
M740 532 699 VSS! VSS! nfet_01v8 L=1.5e-07 W=7.6e-07 $X=14200 $Y=160110 $dt=15
M741 VSS! 700 495 VSS! nfet_01v8 L=1.5e-07 W=7.6e-07 $X=14570 $Y=13010 $dt=15
M742 VSS! 701 496 VSS! nfet_01v8 L=1.5e-07 W=7.6e-07 $X=14570 $Y=21290 $dt=15
M743 VSS! 702 497 VSS! nfet_01v8 L=1.5e-07 W=7.6e-07 $X=14570 $Y=29570 $dt=15
M744 VSS! 703 498 VSS! nfet_01v8 L=1.5e-07 W=7.6e-07 $X=14570 $Y=37850 $dt=15
M745 VSS! 704 499 VSS! nfet_01v8 L=1.5e-07 W=7.6e-07 $X=14570 $Y=46130 $dt=15
M746 VSS! 705 500 VSS! nfet_01v8 L=1.5e-07 W=7.6e-07 $X=14570 $Y=54410 $dt=15
M747 VSS! 706 501 VSS! nfet_01v8 L=1.5e-07 W=7.6e-07 $X=14570 $Y=62690 $dt=15
M748 VSS! 707 502 VSS! nfet_01v8 L=1.5e-07 W=7.6e-07 $X=14570 $Y=70970 $dt=15
M749 VSS! 708 503 VSS! nfet_01v8 L=1.5e-07 W=7.6e-07 $X=14570 $Y=79250 $dt=15
M750 VSS! 709 504 VSS! nfet_01v8 L=1.5e-07 W=7.6e-07 $X=14570 $Y=87530 $dt=15
M751 VSS! 710 505 VSS! nfet_01v8 L=1.5e-07 W=7.6e-07 $X=14570 $Y=95810 $dt=15
M752 VSS! 711 506 VSS! nfet_01v8 L=1.5e-07 W=7.6e-07 $X=14570 $Y=104090 $dt=15
M753 VSS! 712 507 VSS! nfet_01v8 L=1.5e-07 W=7.6e-07 $X=14570 $Y=112370 $dt=15
M754 VSS! 713 508 VSS! nfet_01v8 L=1.5e-07 W=7.6e-07 $X=14570 $Y=120650 $dt=15
M755 VSS! 714 509 VSS! nfet_01v8 L=1.5e-07 W=7.6e-07 $X=14570 $Y=128930 $dt=15
M756 VSS! 715 510 VSS! nfet_01v8 L=1.5e-07 W=7.6e-07 $X=14570 $Y=137210 $dt=15
M757 VSS! 716 511 VSS! nfet_01v8 L=1.5e-07 W=7.6e-07 $X=14570 $Y=145490 $dt=15
M758 VSS! 717 512 VSS! nfet_01v8 L=1.5e-07 W=7.6e-07 $X=14570 $Y=153770 $dt=15
M759 VSS! 718 513 VSS! nfet_01v8 L=1.5e-07 W=7.6e-07 $X=14570 $Y=162050 $dt=15
M760 VSS! 681 514 VSS! nfet_01v8 L=1.5e-07 W=7.6e-07 $X=14630 $Y=11070 $dt=15
M761 VSS! 682 515 VSS! nfet_01v8 L=1.5e-07 W=7.6e-07 $X=14630 $Y=19350 $dt=15
M762 VSS! 683 516 VSS! nfet_01v8 L=1.5e-07 W=7.6e-07 $X=14630 $Y=27630 $dt=15
M763 VSS! 684 517 VSS! nfet_01v8 L=1.5e-07 W=7.6e-07 $X=14630 $Y=35910 $dt=15
M764 VSS! 685 518 VSS! nfet_01v8 L=1.5e-07 W=7.6e-07 $X=14630 $Y=44190 $dt=15
M765 VSS! 686 519 VSS! nfet_01v8 L=1.5e-07 W=7.6e-07 $X=14630 $Y=52470 $dt=15
M766 VSS! 687 520 VSS! nfet_01v8 L=1.5e-07 W=7.6e-07 $X=14630 $Y=60750 $dt=15
M767 VSS! 688 521 VSS! nfet_01v8 L=1.5e-07 W=7.6e-07 $X=14630 $Y=69030 $dt=15
M768 VSS! 689 522 VSS! nfet_01v8 L=1.5e-07 W=7.6e-07 $X=14630 $Y=77310 $dt=15
M769 VSS! 690 523 VSS! nfet_01v8 L=1.5e-07 W=7.6e-07 $X=14630 $Y=85590 $dt=15
M770 VSS! 691 524 VSS! nfet_01v8 L=1.5e-07 W=7.6e-07 $X=14630 $Y=93870 $dt=15
M771 VSS! 692 525 VSS! nfet_01v8 L=1.5e-07 W=7.6e-07 $X=14630 $Y=102150 $dt=15
M772 VSS! 693 526 VSS! nfet_01v8 L=1.5e-07 W=7.6e-07 $X=14630 $Y=110430 $dt=15
M773 VSS! 694 527 VSS! nfet_01v8 L=1.5e-07 W=7.6e-07 $X=14630 $Y=118710 $dt=15
M774 VSS! 695 528 VSS! nfet_01v8 L=1.5e-07 W=7.6e-07 $X=14630 $Y=126990 $dt=15
M775 VSS! 696 529 VSS! nfet_01v8 L=1.5e-07 W=7.6e-07 $X=14630 $Y=135270 $dt=15
M776 VSS! 697 530 VSS! nfet_01v8 L=1.5e-07 W=7.6e-07 $X=14630 $Y=143550 $dt=15
M777 VSS! 698 531 VSS! nfet_01v8 L=1.5e-07 W=7.6e-07 $X=14630 $Y=151830 $dt=15
M778 VSS! 699 532 VSS! nfet_01v8 L=1.5e-07 W=7.6e-07 $X=14630 $Y=160110 $dt=15
M779 495 700 VSS! VSS! nfet_01v8 L=1.5e-07 W=7.6e-07 $X=15000 $Y=13010 $dt=15
M780 496 701 VSS! VSS! nfet_01v8 L=1.5e-07 W=7.6e-07 $X=15000 $Y=21290 $dt=15
M781 497 702 VSS! VSS! nfet_01v8 L=1.5e-07 W=7.6e-07 $X=15000 $Y=29570 $dt=15
M782 498 703 VSS! VSS! nfet_01v8 L=1.5e-07 W=7.6e-07 $X=15000 $Y=37850 $dt=15
M783 499 704 VSS! VSS! nfet_01v8 L=1.5e-07 W=7.6e-07 $X=15000 $Y=46130 $dt=15
M784 500 705 VSS! VSS! nfet_01v8 L=1.5e-07 W=7.6e-07 $X=15000 $Y=54410 $dt=15
M785 501 706 VSS! VSS! nfet_01v8 L=1.5e-07 W=7.6e-07 $X=15000 $Y=62690 $dt=15
M786 502 707 VSS! VSS! nfet_01v8 L=1.5e-07 W=7.6e-07 $X=15000 $Y=70970 $dt=15
M787 503 708 VSS! VSS! nfet_01v8 L=1.5e-07 W=7.6e-07 $X=15000 $Y=79250 $dt=15
M788 504 709 VSS! VSS! nfet_01v8 L=1.5e-07 W=7.6e-07 $X=15000 $Y=87530 $dt=15
M789 505 710 VSS! VSS! nfet_01v8 L=1.5e-07 W=7.6e-07 $X=15000 $Y=95810 $dt=15
M790 506 711 VSS! VSS! nfet_01v8 L=1.5e-07 W=7.6e-07 $X=15000 $Y=104090 $dt=15
M791 507 712 VSS! VSS! nfet_01v8 L=1.5e-07 W=7.6e-07 $X=15000 $Y=112370 $dt=15
M792 508 713 VSS! VSS! nfet_01v8 L=1.5e-07 W=7.6e-07 $X=15000 $Y=120650 $dt=15
M793 509 714 VSS! VSS! nfet_01v8 L=1.5e-07 W=7.6e-07 $X=15000 $Y=128930 $dt=15
M794 510 715 VSS! VSS! nfet_01v8 L=1.5e-07 W=7.6e-07 $X=15000 $Y=137210 $dt=15
M795 511 716 VSS! VSS! nfet_01v8 L=1.5e-07 W=7.6e-07 $X=15000 $Y=145490 $dt=15
M796 512 717 VSS! VSS! nfet_01v8 L=1.5e-07 W=7.6e-07 $X=15000 $Y=153770 $dt=15
M797 513 718 VSS! VSS! nfet_01v8 L=1.5e-07 W=7.6e-07 $X=15000 $Y=162050 $dt=15
M798 514 681 VSS! VSS! nfet_01v8 L=1.5e-07 W=7.6e-07 $X=15060 $Y=11070 $dt=15
M799 515 682 VSS! VSS! nfet_01v8 L=1.5e-07 W=7.6e-07 $X=15060 $Y=19350 $dt=15
M800 516 683 VSS! VSS! nfet_01v8 L=1.5e-07 W=7.6e-07 $X=15060 $Y=27630 $dt=15
M801 517 684 VSS! VSS! nfet_01v8 L=1.5e-07 W=7.6e-07 $X=15060 $Y=35910 $dt=15
M802 518 685 VSS! VSS! nfet_01v8 L=1.5e-07 W=7.6e-07 $X=15060 $Y=44190 $dt=15
M803 519 686 VSS! VSS! nfet_01v8 L=1.5e-07 W=7.6e-07 $X=15060 $Y=52470 $dt=15
M804 520 687 VSS! VSS! nfet_01v8 L=1.5e-07 W=7.6e-07 $X=15060 $Y=60750 $dt=15
M805 521 688 VSS! VSS! nfet_01v8 L=1.5e-07 W=7.6e-07 $X=15060 $Y=69030 $dt=15
M806 522 689 VSS! VSS! nfet_01v8 L=1.5e-07 W=7.6e-07 $X=15060 $Y=77310 $dt=15
M807 523 690 VSS! VSS! nfet_01v8 L=1.5e-07 W=7.6e-07 $X=15060 $Y=85590 $dt=15
M808 524 691 VSS! VSS! nfet_01v8 L=1.5e-07 W=7.6e-07 $X=15060 $Y=93870 $dt=15
M809 525 692 VSS! VSS! nfet_01v8 L=1.5e-07 W=7.6e-07 $X=15060 $Y=102150 $dt=15
M810 526 693 VSS! VSS! nfet_01v8 L=1.5e-07 W=7.6e-07 $X=15060 $Y=110430 $dt=15
M811 527 694 VSS! VSS! nfet_01v8 L=1.5e-07 W=7.6e-07 $X=15060 $Y=118710 $dt=15
M812 528 695 VSS! VSS! nfet_01v8 L=1.5e-07 W=7.6e-07 $X=15060 $Y=126990 $dt=15
M813 529 696 VSS! VSS! nfet_01v8 L=1.5e-07 W=7.6e-07 $X=15060 $Y=135270 $dt=15
M814 530 697 VSS! VSS! nfet_01v8 L=1.5e-07 W=7.6e-07 $X=15060 $Y=143550 $dt=15
M815 531 698 VSS! VSS! nfet_01v8 L=1.5e-07 W=7.6e-07 $X=15060 $Y=151830 $dt=15
M816 532 699 VSS! VSS! nfet_01v8 L=1.5e-07 W=7.6e-07 $X=15060 $Y=160110 $dt=15
M817 VSS! 700 495 VSS! nfet_01v8 L=1.5e-07 W=7.6e-07 $X=15430 $Y=13010 $dt=15
M818 VSS! 701 496 VSS! nfet_01v8 L=1.5e-07 W=7.6e-07 $X=15430 $Y=21290 $dt=15
M819 VSS! 702 497 VSS! nfet_01v8 L=1.5e-07 W=7.6e-07 $X=15430 $Y=29570 $dt=15
M820 VSS! 703 498 VSS! nfet_01v8 L=1.5e-07 W=7.6e-07 $X=15430 $Y=37850 $dt=15
M821 VSS! 704 499 VSS! nfet_01v8 L=1.5e-07 W=7.6e-07 $X=15430 $Y=46130 $dt=15
M822 VSS! 705 500 VSS! nfet_01v8 L=1.5e-07 W=7.6e-07 $X=15430 $Y=54410 $dt=15
M823 VSS! 706 501 VSS! nfet_01v8 L=1.5e-07 W=7.6e-07 $X=15430 $Y=62690 $dt=15
M824 VSS! 707 502 VSS! nfet_01v8 L=1.5e-07 W=7.6e-07 $X=15430 $Y=70970 $dt=15
M825 VSS! 708 503 VSS! nfet_01v8 L=1.5e-07 W=7.6e-07 $X=15430 $Y=79250 $dt=15
M826 VSS! 709 504 VSS! nfet_01v8 L=1.5e-07 W=7.6e-07 $X=15430 $Y=87530 $dt=15
M827 VSS! 710 505 VSS! nfet_01v8 L=1.5e-07 W=7.6e-07 $X=15430 $Y=95810 $dt=15
M828 VSS! 711 506 VSS! nfet_01v8 L=1.5e-07 W=7.6e-07 $X=15430 $Y=104090 $dt=15
M829 VSS! 712 507 VSS! nfet_01v8 L=1.5e-07 W=7.6e-07 $X=15430 $Y=112370 $dt=15
M830 VSS! 713 508 VSS! nfet_01v8 L=1.5e-07 W=7.6e-07 $X=15430 $Y=120650 $dt=15
M831 VSS! 714 509 VSS! nfet_01v8 L=1.5e-07 W=7.6e-07 $X=15430 $Y=128930 $dt=15
M832 VSS! 715 510 VSS! nfet_01v8 L=1.5e-07 W=7.6e-07 $X=15430 $Y=137210 $dt=15
M833 VSS! 716 511 VSS! nfet_01v8 L=1.5e-07 W=7.6e-07 $X=15430 $Y=145490 $dt=15
M834 VSS! 717 512 VSS! nfet_01v8 L=1.5e-07 W=7.6e-07 $X=15430 $Y=153770 $dt=15
M835 VSS! 718 513 VSS! nfet_01v8 L=1.5e-07 W=7.6e-07 $X=15430 $Y=162050 $dt=15
M836 VSS! 681 514 VSS! nfet_01v8 L=1.5e-07 W=7.6e-07 $X=15490 $Y=11070 $dt=15
M837 VSS! 682 515 VSS! nfet_01v8 L=1.5e-07 W=7.6e-07 $X=15490 $Y=19350 $dt=15
M838 VSS! 683 516 VSS! nfet_01v8 L=1.5e-07 W=7.6e-07 $X=15490 $Y=27630 $dt=15
M839 VSS! 684 517 VSS! nfet_01v8 L=1.5e-07 W=7.6e-07 $X=15490 $Y=35910 $dt=15
M840 VSS! 685 518 VSS! nfet_01v8 L=1.5e-07 W=7.6e-07 $X=15490 $Y=44190 $dt=15
M841 VSS! 686 519 VSS! nfet_01v8 L=1.5e-07 W=7.6e-07 $X=15490 $Y=52470 $dt=15
M842 VSS! 687 520 VSS! nfet_01v8 L=1.5e-07 W=7.6e-07 $X=15490 $Y=60750 $dt=15
M843 VSS! 688 521 VSS! nfet_01v8 L=1.5e-07 W=7.6e-07 $X=15490 $Y=69030 $dt=15
M844 VSS! 689 522 VSS! nfet_01v8 L=1.5e-07 W=7.6e-07 $X=15490 $Y=77310 $dt=15
M845 VSS! 690 523 VSS! nfet_01v8 L=1.5e-07 W=7.6e-07 $X=15490 $Y=85590 $dt=15
M846 VSS! 691 524 VSS! nfet_01v8 L=1.5e-07 W=7.6e-07 $X=15490 $Y=93870 $dt=15
M847 VSS! 692 525 VSS! nfet_01v8 L=1.5e-07 W=7.6e-07 $X=15490 $Y=102150 $dt=15
M848 VSS! 693 526 VSS! nfet_01v8 L=1.5e-07 W=7.6e-07 $X=15490 $Y=110430 $dt=15
M849 VSS! 694 527 VSS! nfet_01v8 L=1.5e-07 W=7.6e-07 $X=15490 $Y=118710 $dt=15
M850 VSS! 695 528 VSS! nfet_01v8 L=1.5e-07 W=7.6e-07 $X=15490 $Y=126990 $dt=15
M851 VSS! 696 529 VSS! nfet_01v8 L=1.5e-07 W=7.6e-07 $X=15490 $Y=135270 $dt=15
M852 VSS! 697 530 VSS! nfet_01v8 L=1.5e-07 W=7.6e-07 $X=15490 $Y=143550 $dt=15
M853 VSS! 698 531 VSS! nfet_01v8 L=1.5e-07 W=7.6e-07 $X=15490 $Y=151830 $dt=15
M854 VSS! 699 532 VSS! nfet_01v8 L=1.5e-07 W=7.6e-07 $X=15490 $Y=160110 $dt=15
M855 667 534 VREF_P VSS! nfet_01v8 L=1.5e-07 W=1.5e-06 $X=17630 $Y=13190 $dt=15
M856 668 536 VREF_P VSS! nfet_01v8 L=1.5e-07 W=1.5e-06 $X=17630 $Y=21470 $dt=15
M857 669 538 VREF_P VSS! nfet_01v8 L=1.5e-07 W=1.5e-06 $X=17630 $Y=29750 $dt=15
M858 670 540 VREF_P VSS! nfet_01v8 L=1.5e-07 W=1.5e-06 $X=17630 $Y=38030 $dt=15
M859 671 542 VREF_P VSS! nfet_01v8 L=1.5e-07 W=1.5e-06 $X=17630 $Y=46310 $dt=15
M860 672 544 VREF_P VSS! nfet_01v8 L=1.5e-07 W=1.5e-06 $X=17630 $Y=54590 $dt=15
M861 673 546 VREF_P VSS! nfet_01v8 L=1.5e-07 W=1.5e-06 $X=17630 $Y=62870 $dt=15
M862 VSS! VDD! VSS! VSS! nfet_01v8 L=5.8e-07 W=1.5e-06 $X=17630 $Y=71150 $dt=15
M863 VSS! VDD! VSS! VSS! nfet_01v8 L=5.8e-07 W=1.5e-06 $X=17630 $Y=79430 $dt=15
M864 VSS! VDD! VSS! VSS! nfet_01v8 L=5.8e-07 W=1.5e-06 $X=17630 $Y=87710 $dt=15
M865 VSS! VDD! VSS! VSS! nfet_01v8 L=5.8e-07 W=1.5e-06 $X=17630 $Y=95990 $dt=15
M866 VSS! VDD! VSS! VSS! nfet_01v8 L=5.8e-07 W=1.5e-06 $X=17630 $Y=104270 $dt=15
M867 674 558 VREF_P VSS! nfet_01v8 L=1.5e-07 W=1.5e-06 $X=17630 $Y=112550 $dt=15
M868 675 560 VREF_P VSS! nfet_01v8 L=1.5e-07 W=1.5e-06 $X=17630 $Y=120830 $dt=15
M869 676 562 VREF_P VSS! nfet_01v8 L=1.5e-07 W=1.5e-06 $X=17630 $Y=129110 $dt=15
M870 677 564 VREF_P VSS! nfet_01v8 L=1.5e-07 W=1.5e-06 $X=17630 $Y=137390 $dt=15
M871 678 566 VREF_P VSS! nfet_01v8 L=1.5e-07 W=1.5e-06 $X=17630 $Y=145670 $dt=15
M872 679 568 VREF_P VSS! nfet_01v8 L=1.5e-07 W=1.5e-06 $X=17630 $Y=153950 $dt=15
M873 680 570 VREF_P VSS! nfet_01v8 L=1.5e-07 W=1.5e-06 $X=17630 $Y=162230 $dt=15
M874 667 514 667 VSS! nfet_01v8 L=1.5e-07 W=1.5e-06 $X=18060 $Y=13190 $dt=15
M875 668 515 668 VSS! nfet_01v8 L=1.5e-07 W=1.5e-06 $X=18060 $Y=21470 $dt=15
M876 669 516 669 VSS! nfet_01v8 L=1.5e-07 W=1.5e-06 $X=18060 $Y=29750 $dt=15
M877 670 517 670 VSS! nfet_01v8 L=1.5e-07 W=1.5e-06 $X=18060 $Y=38030 $dt=15
M878 671 518 671 VSS! nfet_01v8 L=1.5e-07 W=1.5e-06 $X=18060 $Y=46310 $dt=15
M879 672 519 672 VSS! nfet_01v8 L=1.5e-07 W=1.5e-06 $X=18060 $Y=54590 $dt=15
M880 673 520 673 VSS! nfet_01v8 L=1.5e-07 W=1.5e-06 $X=18060 $Y=62870 $dt=15
M881 674 526 674 VSS! nfet_01v8 L=1.5e-07 W=1.5e-06 $X=18060 $Y=112550 $dt=15
M882 675 527 675 VSS! nfet_01v8 L=1.5e-07 W=1.5e-06 $X=18060 $Y=120830 $dt=15
M883 676 528 676 VSS! nfet_01v8 L=1.5e-07 W=1.5e-06 $X=18060 $Y=129110 $dt=15
M884 677 529 677 VSS! nfet_01v8 L=1.5e-07 W=1.5e-06 $X=18060 $Y=137390 $dt=15
M885 678 530 678 VSS! nfet_01v8 L=1.5e-07 W=1.5e-06 $X=18060 $Y=145670 $dt=15
M886 679 531 679 VSS! nfet_01v8 L=1.5e-07 W=1.5e-06 $X=18060 $Y=153950 $dt=15
M887 680 532 680 VSS! nfet_01v8 L=1.5e-07 W=1.5e-06 $X=18060 $Y=162230 $dt=15
M888 VSS! VDD! VSS! VSS! nfet_01v8 L=5.8e-07 W=1.5e-06 $X=23750 $Y=71150 $dt=15
M889 VSS! VDD! VSS! VSS! nfet_01v8 L=5.8e-07 W=1.5e-06 $X=23750 $Y=79430 $dt=15
M890 VSS! VDD! VSS! VSS! nfet_01v8 L=5.8e-07 W=1.5e-06 $X=23750 $Y=87710 $dt=15
M891 VSS! VDD! VSS! VSS! nfet_01v8 L=5.8e-07 W=1.5e-06 $X=23750 $Y=95990 $dt=15
M892 VSS! VDD! VSS! VSS! nfet_01v8 L=5.8e-07 W=1.5e-06 $X=23750 $Y=104270 $dt=15
M893 667 495 VIN VSS! nfet_01v8 L=1.5e-07 W=1.5e-06 $X=23760 $Y=13190 $dt=15
M894 668 496 VIN VSS! nfet_01v8 L=1.5e-07 W=1.5e-06 $X=23760 $Y=21470 $dt=15
M895 669 497 VIN VSS! nfet_01v8 L=1.5e-07 W=1.5e-06 $X=23760 $Y=29750 $dt=15
M896 670 498 VIN VSS! nfet_01v8 L=1.5e-07 W=1.5e-06 $X=23760 $Y=38030 $dt=15
M897 671 499 VIN VSS! nfet_01v8 L=1.5e-07 W=1.5e-06 $X=23760 $Y=46310 $dt=15
M898 672 500 VIN VSS! nfet_01v8 L=1.5e-07 W=1.5e-06 $X=23760 $Y=54590 $dt=15
M899 673 501 VIN VSS! nfet_01v8 L=1.5e-07 W=1.5e-06 $X=23760 $Y=62870 $dt=15
M900 674 507 VIN VSS! nfet_01v8 L=1.5e-07 W=1.5e-06 $X=23760 $Y=112550 $dt=15
M901 675 508 VIN VSS! nfet_01v8 L=1.5e-07 W=1.5e-06 $X=23760 $Y=120830 $dt=15
M902 676 509 VIN VSS! nfet_01v8 L=1.5e-07 W=1.5e-06 $X=23760 $Y=129110 $dt=15
M903 677 510 VIN VSS! nfet_01v8 L=1.5e-07 W=1.5e-06 $X=23760 $Y=137390 $dt=15
M904 678 511 VIN VSS! nfet_01v8 L=1.5e-07 W=1.5e-06 $X=23760 $Y=145670 $dt=15
M905 679 512 VIN VSS! nfet_01v8 L=1.5e-07 W=1.5e-06 $X=23760 $Y=153950 $dt=15
M906 680 513 VIN VSS! nfet_01v8 L=1.5e-07 W=1.5e-06 $X=23760 $Y=162230 $dt=15
M907 VREF_N 458 667 VSS! nfet_01v8 L=1.5e-07 W=1.5e-06 $X=24190 $Y=13190 $dt=15
M908 VREF_N 460 668 VSS! nfet_01v8 L=1.5e-07 W=1.5e-06 $X=24190 $Y=21470 $dt=15
M909 VREF_N 462 669 VSS! nfet_01v8 L=1.5e-07 W=1.5e-06 $X=24190 $Y=29750 $dt=15
M910 VREF_N 464 670 VSS! nfet_01v8 L=1.5e-07 W=1.5e-06 $X=24190 $Y=38030 $dt=15
M911 VREF_N 466 671 VSS! nfet_01v8 L=1.5e-07 W=1.5e-06 $X=24190 $Y=46310 $dt=15
M912 VREF_N 468 672 VSS! nfet_01v8 L=1.5e-07 W=1.5e-06 $X=24190 $Y=54590 $dt=15
M913 VREF_N 470 673 VSS! nfet_01v8 L=1.5e-07 W=1.5e-06 $X=24190 $Y=62870 $dt=15
M914 VREF_N 482 674 VSS! nfet_01v8 L=1.5e-07 W=1.5e-06 $X=24190 $Y=112550 $dt=15
M915 VREF_N 484 675 VSS! nfet_01v8 L=1.5e-07 W=1.5e-06 $X=24190 $Y=120830 $dt=15
M916 VREF_N 486 676 VSS! nfet_01v8 L=1.5e-07 W=1.5e-06 $X=24190 $Y=129110 $dt=15
M917 VREF_N 488 677 VSS! nfet_01v8 L=1.5e-07 W=1.5e-06 $X=24190 $Y=137390 $dt=15
M918 VREF_N 490 678 VSS! nfet_01v8 L=1.5e-07 W=1.5e-06 $X=24190 $Y=145670 $dt=15
M919 VREF_N 492 679 VSS! nfet_01v8 L=1.5e-07 W=1.5e-06 $X=24190 $Y=153950 $dt=15
M920 VREF_N 494 680 VSS! nfet_01v8 L=1.5e-07 W=1.5e-06 $X=24190 $Y=162230 $dt=15
M921 653 534 VREF_P VSS! nfet_01v8 L=1.5e-07 W=1.5e-06 $X=25910 $Y=13190 $dt=15
M922 654 536 VREF_P VSS! nfet_01v8 L=1.5e-07 W=1.5e-06 $X=25910 $Y=21470 $dt=15
M923 655 538 VREF_P VSS! nfet_01v8 L=1.5e-07 W=1.5e-06 $X=25910 $Y=29750 $dt=15
M924 656 540 VREF_P VSS! nfet_01v8 L=1.5e-07 W=1.5e-06 $X=25910 $Y=38030 $dt=15
M925 657 542 VREF_P VSS! nfet_01v8 L=1.5e-07 W=1.5e-06 $X=25910 $Y=46310 $dt=15
M926 658 544 VREF_P VSS! nfet_01v8 L=1.5e-07 W=1.5e-06 $X=25910 $Y=54590 $dt=15
M927 659 546 VREF_P VSS! nfet_01v8 L=1.5e-07 W=1.5e-06 $X=25910 $Y=62870 $dt=15
M928 VSS! VDD! VSS! VSS! nfet_01v8 L=5.8e-07 W=1.5e-06 $X=25910 $Y=71150 $dt=15
M929 VSS! VDD! VSS! VSS! nfet_01v8 L=5.8e-07 W=1.5e-06 $X=25910 $Y=79430 $dt=15
M930 VSS! VDD! VSS! VSS! nfet_01v8 L=5.8e-07 W=1.5e-06 $X=25910 $Y=87710 $dt=15
M931 VSS! VDD! VSS! VSS! nfet_01v8 L=5.8e-07 W=1.5e-06 $X=25910 $Y=95990 $dt=15
M932 VSS! VDD! VSS! VSS! nfet_01v8 L=5.8e-07 W=1.5e-06 $X=25910 $Y=104270 $dt=15
M933 660 558 VREF_P VSS! nfet_01v8 L=1.5e-07 W=1.5e-06 $X=25910 $Y=112550 $dt=15
M934 661 560 VREF_P VSS! nfet_01v8 L=1.5e-07 W=1.5e-06 $X=25910 $Y=120830 $dt=15
M935 662 562 VREF_P VSS! nfet_01v8 L=1.5e-07 W=1.5e-06 $X=25910 $Y=129110 $dt=15
M936 663 564 VREF_P VSS! nfet_01v8 L=1.5e-07 W=1.5e-06 $X=25910 $Y=137390 $dt=15
M937 664 566 VREF_P VSS! nfet_01v8 L=1.5e-07 W=1.5e-06 $X=25910 $Y=145670 $dt=15
M938 665 568 VREF_P VSS! nfet_01v8 L=1.5e-07 W=1.5e-06 $X=25910 $Y=153950 $dt=15
M939 666 570 VREF_P VSS! nfet_01v8 L=1.5e-07 W=1.5e-06 $X=25910 $Y=162230 $dt=15
M940 653 514 653 VSS! nfet_01v8 L=1.5e-07 W=1.5e-06 $X=26340 $Y=13190 $dt=15
M941 654 515 654 VSS! nfet_01v8 L=1.5e-07 W=1.5e-06 $X=26340 $Y=21470 $dt=15
M942 655 516 655 VSS! nfet_01v8 L=1.5e-07 W=1.5e-06 $X=26340 $Y=29750 $dt=15
M943 656 517 656 VSS! nfet_01v8 L=1.5e-07 W=1.5e-06 $X=26340 $Y=38030 $dt=15
M944 657 518 657 VSS! nfet_01v8 L=1.5e-07 W=1.5e-06 $X=26340 $Y=46310 $dt=15
M945 658 519 658 VSS! nfet_01v8 L=1.5e-07 W=1.5e-06 $X=26340 $Y=54590 $dt=15
M946 659 520 659 VSS! nfet_01v8 L=1.5e-07 W=1.5e-06 $X=26340 $Y=62870 $dt=15
M947 660 526 660 VSS! nfet_01v8 L=1.5e-07 W=1.5e-06 $X=26340 $Y=112550 $dt=15
M948 661 527 661 VSS! nfet_01v8 L=1.5e-07 W=1.5e-06 $X=26340 $Y=120830 $dt=15
M949 662 528 662 VSS! nfet_01v8 L=1.5e-07 W=1.5e-06 $X=26340 $Y=129110 $dt=15
M950 663 529 663 VSS! nfet_01v8 L=1.5e-07 W=1.5e-06 $X=26340 $Y=137390 $dt=15
M951 664 530 664 VSS! nfet_01v8 L=1.5e-07 W=1.5e-06 $X=26340 $Y=145670 $dt=15
M952 665 531 665 VSS! nfet_01v8 L=1.5e-07 W=1.5e-06 $X=26340 $Y=153950 $dt=15
M953 666 532 666 VSS! nfet_01v8 L=1.5e-07 W=1.5e-06 $X=26340 $Y=162230 $dt=15
M954 VSS! VDD! VSS! VSS! nfet_01v8 L=5.8e-07 W=1.5e-06 $X=32030 $Y=71150 $dt=15
M955 VSS! VDD! VSS! VSS! nfet_01v8 L=5.8e-07 W=1.5e-06 $X=32030 $Y=79430 $dt=15
M956 VSS! VDD! VSS! VSS! nfet_01v8 L=5.8e-07 W=1.5e-06 $X=32030 $Y=87710 $dt=15
M957 VSS! VDD! VSS! VSS! nfet_01v8 L=5.8e-07 W=1.5e-06 $X=32030 $Y=95990 $dt=15
M958 VSS! VDD! VSS! VSS! nfet_01v8 L=5.8e-07 W=1.5e-06 $X=32030 $Y=104270 $dt=15
M959 653 495 VIN VSS! nfet_01v8 L=1.5e-07 W=1.5e-06 $X=32040 $Y=13190 $dt=15
M960 654 496 VIN VSS! nfet_01v8 L=1.5e-07 W=1.5e-06 $X=32040 $Y=21470 $dt=15
M961 655 497 VIN VSS! nfet_01v8 L=1.5e-07 W=1.5e-06 $X=32040 $Y=29750 $dt=15
M962 656 498 VIN VSS! nfet_01v8 L=1.5e-07 W=1.5e-06 $X=32040 $Y=38030 $dt=15
M963 657 499 VIN VSS! nfet_01v8 L=1.5e-07 W=1.5e-06 $X=32040 $Y=46310 $dt=15
M964 658 500 VIN VSS! nfet_01v8 L=1.5e-07 W=1.5e-06 $X=32040 $Y=54590 $dt=15
M965 659 501 VIN VSS! nfet_01v8 L=1.5e-07 W=1.5e-06 $X=32040 $Y=62870 $dt=15
M966 660 507 VIN VSS! nfet_01v8 L=1.5e-07 W=1.5e-06 $X=32040 $Y=112550 $dt=15
M967 661 508 VIN VSS! nfet_01v8 L=1.5e-07 W=1.5e-06 $X=32040 $Y=120830 $dt=15
M968 662 509 VIN VSS! nfet_01v8 L=1.5e-07 W=1.5e-06 $X=32040 $Y=129110 $dt=15
M969 663 510 VIN VSS! nfet_01v8 L=1.5e-07 W=1.5e-06 $X=32040 $Y=137390 $dt=15
M970 664 511 VIN VSS! nfet_01v8 L=1.5e-07 W=1.5e-06 $X=32040 $Y=145670 $dt=15
M971 665 512 VIN VSS! nfet_01v8 L=1.5e-07 W=1.5e-06 $X=32040 $Y=153950 $dt=15
M972 666 513 VIN VSS! nfet_01v8 L=1.5e-07 W=1.5e-06 $X=32040 $Y=162230 $dt=15
M973 VREF_N 458 653 VSS! nfet_01v8 L=1.5e-07 W=1.5e-06 $X=32470 $Y=13190 $dt=15
M974 VREF_N 460 654 VSS! nfet_01v8 L=1.5e-07 W=1.5e-06 $X=32470 $Y=21470 $dt=15
M975 VREF_N 462 655 VSS! nfet_01v8 L=1.5e-07 W=1.5e-06 $X=32470 $Y=29750 $dt=15
M976 VREF_N 464 656 VSS! nfet_01v8 L=1.5e-07 W=1.5e-06 $X=32470 $Y=38030 $dt=15
M977 VREF_N 466 657 VSS! nfet_01v8 L=1.5e-07 W=1.5e-06 $X=32470 $Y=46310 $dt=15
M978 VREF_N 468 658 VSS! nfet_01v8 L=1.5e-07 W=1.5e-06 $X=32470 $Y=54590 $dt=15
M979 VREF_N 470 659 VSS! nfet_01v8 L=1.5e-07 W=1.5e-06 $X=32470 $Y=62870 $dt=15
M980 VREF_N 482 660 VSS! nfet_01v8 L=1.5e-07 W=1.5e-06 $X=32470 $Y=112550 $dt=15
M981 VREF_N 484 661 VSS! nfet_01v8 L=1.5e-07 W=1.5e-06 $X=32470 $Y=120830 $dt=15
M982 VREF_N 486 662 VSS! nfet_01v8 L=1.5e-07 W=1.5e-06 $X=32470 $Y=129110 $dt=15
M983 VREF_N 488 663 VSS! nfet_01v8 L=1.5e-07 W=1.5e-06 $X=32470 $Y=137390 $dt=15
M984 VREF_N 490 664 VSS! nfet_01v8 L=1.5e-07 W=1.5e-06 $X=32470 $Y=145670 $dt=15
M985 VREF_N 492 665 VSS! nfet_01v8 L=1.5e-07 W=1.5e-06 $X=32470 $Y=153950 $dt=15
M986 VREF_N 494 666 VSS! nfet_01v8 L=1.5e-07 W=1.5e-06 $X=32470 $Y=162230 $dt=15
M987 639 534 VREF_P VSS! nfet_01v8 L=1.5e-07 W=1.5e-06 $X=34190 $Y=13190 $dt=15
M988 640 536 VREF_P VSS! nfet_01v8 L=1.5e-07 W=1.5e-06 $X=34190 $Y=21470 $dt=15
M989 641 538 VREF_P VSS! nfet_01v8 L=1.5e-07 W=1.5e-06 $X=34190 $Y=29750 $dt=15
M990 642 540 VREF_P VSS! nfet_01v8 L=1.5e-07 W=1.5e-06 $X=34190 $Y=38030 $dt=15
M991 643 542 VREF_P VSS! nfet_01v8 L=1.5e-07 W=1.5e-06 $X=34190 $Y=46310 $dt=15
M992 644 544 VREF_P VSS! nfet_01v8 L=1.5e-07 W=1.5e-06 $X=34190 $Y=54590 $dt=15
M993 645 546 VREF_P VSS! nfet_01v8 L=1.5e-07 W=1.5e-06 $X=34190 $Y=62870 $dt=15
M994 VSS! VDD! VSS! VSS! nfet_01v8 L=5.8e-07 W=1.5e-06 $X=34190 $Y=71150 $dt=15
M995 VSS! VDD! VSS! VSS! nfet_01v8 L=5.8e-07 W=1.5e-06 $X=34190 $Y=79430 $dt=15
M996 VSS! VDD! VSS! VSS! nfet_01v8 L=5.8e-07 W=1.5e-06 $X=34190 $Y=87710 $dt=15
M997 VSS! VDD! VSS! VSS! nfet_01v8 L=5.8e-07 W=1.5e-06 $X=34190 $Y=95990 $dt=15
M998 VSS! VDD! VSS! VSS! nfet_01v8 L=5.8e-07 W=1.5e-06 $X=34190 $Y=104270 $dt=15
M999 646 558 VREF_P VSS! nfet_01v8 L=1.5e-07 W=1.5e-06 $X=34190 $Y=112550 $dt=15
M1000 647 560 VREF_P VSS! nfet_01v8 L=1.5e-07 W=1.5e-06 $X=34190 $Y=120830 $dt=15
M1001 648 562 VREF_P VSS! nfet_01v8 L=1.5e-07 W=1.5e-06 $X=34190 $Y=129110 $dt=15
M1002 649 564 VREF_P VSS! nfet_01v8 L=1.5e-07 W=1.5e-06 $X=34190 $Y=137390 $dt=15
M1003 650 566 VREF_P VSS! nfet_01v8 L=1.5e-07 W=1.5e-06 $X=34190 $Y=145670 $dt=15
M1004 651 568 VREF_P VSS! nfet_01v8 L=1.5e-07 W=1.5e-06 $X=34190 $Y=153950 $dt=15
M1005 652 570 VREF_P VSS! nfet_01v8 L=1.5e-07 W=1.5e-06 $X=34190 $Y=162230 $dt=15
M1006 639 514 639 VSS! nfet_01v8 L=1.5e-07 W=1.5e-06 $X=34620 $Y=13190 $dt=15
M1007 640 515 640 VSS! nfet_01v8 L=1.5e-07 W=1.5e-06 $X=34620 $Y=21470 $dt=15
M1008 641 516 641 VSS! nfet_01v8 L=1.5e-07 W=1.5e-06 $X=34620 $Y=29750 $dt=15
M1009 642 517 642 VSS! nfet_01v8 L=1.5e-07 W=1.5e-06 $X=34620 $Y=38030 $dt=15
M1010 643 518 643 VSS! nfet_01v8 L=1.5e-07 W=1.5e-06 $X=34620 $Y=46310 $dt=15
M1011 644 519 644 VSS! nfet_01v8 L=1.5e-07 W=1.5e-06 $X=34620 $Y=54590 $dt=15
M1012 645 520 645 VSS! nfet_01v8 L=1.5e-07 W=1.5e-06 $X=34620 $Y=62870 $dt=15
M1013 646 526 646 VSS! nfet_01v8 L=1.5e-07 W=1.5e-06 $X=34620 $Y=112550 $dt=15
M1014 647 527 647 VSS! nfet_01v8 L=1.5e-07 W=1.5e-06 $X=34620 $Y=120830 $dt=15
M1015 648 528 648 VSS! nfet_01v8 L=1.5e-07 W=1.5e-06 $X=34620 $Y=129110 $dt=15
M1016 649 529 649 VSS! nfet_01v8 L=1.5e-07 W=1.5e-06 $X=34620 $Y=137390 $dt=15
M1017 650 530 650 VSS! nfet_01v8 L=1.5e-07 W=1.5e-06 $X=34620 $Y=145670 $dt=15
M1018 651 531 651 VSS! nfet_01v8 L=1.5e-07 W=1.5e-06 $X=34620 $Y=153950 $dt=15
M1019 652 532 652 VSS! nfet_01v8 L=1.5e-07 W=1.5e-06 $X=34620 $Y=162230 $dt=15
M1020 VSS! VDD! VSS! VSS! nfet_01v8 L=5.8e-07 W=1.5e-06 $X=40310 $Y=71150 $dt=15
M1021 VSS! VDD! VSS! VSS! nfet_01v8 L=5.8e-07 W=1.5e-06 $X=40310 $Y=79430 $dt=15
M1022 VSS! VDD! VSS! VSS! nfet_01v8 L=5.8e-07 W=1.5e-06 $X=40310 $Y=87710 $dt=15
M1023 VSS! VDD! VSS! VSS! nfet_01v8 L=5.8e-07 W=1.5e-06 $X=40310 $Y=95990 $dt=15
M1024 VSS! VDD! VSS! VSS! nfet_01v8 L=5.8e-07 W=1.5e-06 $X=40310 $Y=104270 $dt=15
M1025 639 495 VIN VSS! nfet_01v8 L=1.5e-07 W=1.5e-06 $X=40320 $Y=13190 $dt=15
M1026 640 496 VIN VSS! nfet_01v8 L=1.5e-07 W=1.5e-06 $X=40320 $Y=21470 $dt=15
M1027 641 497 VIN VSS! nfet_01v8 L=1.5e-07 W=1.5e-06 $X=40320 $Y=29750 $dt=15
M1028 642 498 VIN VSS! nfet_01v8 L=1.5e-07 W=1.5e-06 $X=40320 $Y=38030 $dt=15
M1029 643 499 VIN VSS! nfet_01v8 L=1.5e-07 W=1.5e-06 $X=40320 $Y=46310 $dt=15
M1030 644 500 VIN VSS! nfet_01v8 L=1.5e-07 W=1.5e-06 $X=40320 $Y=54590 $dt=15
M1031 645 501 VIN VSS! nfet_01v8 L=1.5e-07 W=1.5e-06 $X=40320 $Y=62870 $dt=15
M1032 646 507 VIN VSS! nfet_01v8 L=1.5e-07 W=1.5e-06 $X=40320 $Y=112550 $dt=15
M1033 647 508 VIN VSS! nfet_01v8 L=1.5e-07 W=1.5e-06 $X=40320 $Y=120830 $dt=15
M1034 648 509 VIN VSS! nfet_01v8 L=1.5e-07 W=1.5e-06 $X=40320 $Y=129110 $dt=15
M1035 649 510 VIN VSS! nfet_01v8 L=1.5e-07 W=1.5e-06 $X=40320 $Y=137390 $dt=15
M1036 650 511 VIN VSS! nfet_01v8 L=1.5e-07 W=1.5e-06 $X=40320 $Y=145670 $dt=15
M1037 651 512 VIN VSS! nfet_01v8 L=1.5e-07 W=1.5e-06 $X=40320 $Y=153950 $dt=15
M1038 652 513 VIN VSS! nfet_01v8 L=1.5e-07 W=1.5e-06 $X=40320 $Y=162230 $dt=15
M1039 VREF_N 458 639 VSS! nfet_01v8 L=1.5e-07 W=1.5e-06 $X=40750 $Y=13190 $dt=15
M1040 VREF_N 460 640 VSS! nfet_01v8 L=1.5e-07 W=1.5e-06 $X=40750 $Y=21470 $dt=15
M1041 VREF_N 462 641 VSS! nfet_01v8 L=1.5e-07 W=1.5e-06 $X=40750 $Y=29750 $dt=15
M1042 VREF_N 464 642 VSS! nfet_01v8 L=1.5e-07 W=1.5e-06 $X=40750 $Y=38030 $dt=15
M1043 VREF_N 466 643 VSS! nfet_01v8 L=1.5e-07 W=1.5e-06 $X=40750 $Y=46310 $dt=15
M1044 VREF_N 468 644 VSS! nfet_01v8 L=1.5e-07 W=1.5e-06 $X=40750 $Y=54590 $dt=15
M1045 VREF_N 470 645 VSS! nfet_01v8 L=1.5e-07 W=1.5e-06 $X=40750 $Y=62870 $dt=15
M1046 VREF_N 482 646 VSS! nfet_01v8 L=1.5e-07 W=1.5e-06 $X=40750 $Y=112550 $dt=15
M1047 VREF_N 484 647 VSS! nfet_01v8 L=1.5e-07 W=1.5e-06 $X=40750 $Y=120830 $dt=15
M1048 VREF_N 486 648 VSS! nfet_01v8 L=1.5e-07 W=1.5e-06 $X=40750 $Y=129110 $dt=15
M1049 VREF_N 488 649 VSS! nfet_01v8 L=1.5e-07 W=1.5e-06 $X=40750 $Y=137390 $dt=15
M1050 VREF_N 490 650 VSS! nfet_01v8 L=1.5e-07 W=1.5e-06 $X=40750 $Y=145670 $dt=15
M1051 VREF_N 492 651 VSS! nfet_01v8 L=1.5e-07 W=1.5e-06 $X=40750 $Y=153950 $dt=15
M1052 VREF_N 494 652 VSS! nfet_01v8 L=1.5e-07 W=1.5e-06 $X=40750 $Y=162230 $dt=15
M1053 625 534 VREF_P VSS! nfet_01v8 L=1.5e-07 W=1.5e-06 $X=42470 $Y=13190 $dt=15
M1054 626 536 VREF_P VSS! nfet_01v8 L=1.5e-07 W=1.5e-06 $X=42470 $Y=21470 $dt=15
M1055 627 538 VREF_P VSS! nfet_01v8 L=1.5e-07 W=1.5e-06 $X=42470 $Y=29750 $dt=15
M1056 628 540 VREF_P VSS! nfet_01v8 L=1.5e-07 W=1.5e-06 $X=42470 $Y=38030 $dt=15
M1057 629 542 VREF_P VSS! nfet_01v8 L=1.5e-07 W=1.5e-06 $X=42470 $Y=46310 $dt=15
M1058 630 544 VREF_P VSS! nfet_01v8 L=1.5e-07 W=1.5e-06 $X=42470 $Y=54590 $dt=15
M1059 631 546 VREF_P VSS! nfet_01v8 L=1.5e-07 W=1.5e-06 $X=42470 $Y=62870 $dt=15
M1060 VSS! VDD! VSS! VSS! nfet_01v8 L=5.8e-07 W=1.5e-06 $X=42470 $Y=71150 $dt=15
M1061 VSS! VDD! VSS! VSS! nfet_01v8 L=5.8e-07 W=1.5e-06 $X=42470 $Y=79430 $dt=15
M1062 VSS! VDD! VSS! VSS! nfet_01v8 L=5.8e-07 W=1.5e-06 $X=42470 $Y=87710 $dt=15
M1063 VSS! VDD! VSS! VSS! nfet_01v8 L=5.8e-07 W=1.5e-06 $X=42470 $Y=95990 $dt=15
M1064 VSS! VDD! VSS! VSS! nfet_01v8 L=5.8e-07 W=1.5e-06 $X=42470 $Y=104270 $dt=15
M1065 632 558 VREF_P VSS! nfet_01v8 L=1.5e-07 W=1.5e-06 $X=42470 $Y=112550 $dt=15
M1066 633 560 VREF_P VSS! nfet_01v8 L=1.5e-07 W=1.5e-06 $X=42470 $Y=120830 $dt=15
M1067 634 562 VREF_P VSS! nfet_01v8 L=1.5e-07 W=1.5e-06 $X=42470 $Y=129110 $dt=15
M1068 635 564 VREF_P VSS! nfet_01v8 L=1.5e-07 W=1.5e-06 $X=42470 $Y=137390 $dt=15
M1069 636 566 VREF_P VSS! nfet_01v8 L=1.5e-07 W=1.5e-06 $X=42470 $Y=145670 $dt=15
M1070 637 568 VREF_P VSS! nfet_01v8 L=1.5e-07 W=1.5e-06 $X=42470 $Y=153950 $dt=15
M1071 638 570 VREF_P VSS! nfet_01v8 L=1.5e-07 W=1.5e-06 $X=42470 $Y=162230 $dt=15
M1072 625 514 625 VSS! nfet_01v8 L=1.5e-07 W=1.5e-06 $X=42900 $Y=13190 $dt=15
M1073 626 515 626 VSS! nfet_01v8 L=1.5e-07 W=1.5e-06 $X=42900 $Y=21470 $dt=15
M1074 627 516 627 VSS! nfet_01v8 L=1.5e-07 W=1.5e-06 $X=42900 $Y=29750 $dt=15
M1075 628 517 628 VSS! nfet_01v8 L=1.5e-07 W=1.5e-06 $X=42900 $Y=38030 $dt=15
M1076 629 518 629 VSS! nfet_01v8 L=1.5e-07 W=1.5e-06 $X=42900 $Y=46310 $dt=15
M1077 630 519 630 VSS! nfet_01v8 L=1.5e-07 W=1.5e-06 $X=42900 $Y=54590 $dt=15
M1078 631 520 631 VSS! nfet_01v8 L=1.5e-07 W=1.5e-06 $X=42900 $Y=62870 $dt=15
M1079 632 526 632 VSS! nfet_01v8 L=1.5e-07 W=1.5e-06 $X=42900 $Y=112550 $dt=15
M1080 633 527 633 VSS! nfet_01v8 L=1.5e-07 W=1.5e-06 $X=42900 $Y=120830 $dt=15
M1081 634 528 634 VSS! nfet_01v8 L=1.5e-07 W=1.5e-06 $X=42900 $Y=129110 $dt=15
M1082 635 529 635 VSS! nfet_01v8 L=1.5e-07 W=1.5e-06 $X=42900 $Y=137390 $dt=15
M1083 636 530 636 VSS! nfet_01v8 L=1.5e-07 W=1.5e-06 $X=42900 $Y=145670 $dt=15
M1084 637 531 637 VSS! nfet_01v8 L=1.5e-07 W=1.5e-06 $X=42900 $Y=153950 $dt=15
M1085 638 532 638 VSS! nfet_01v8 L=1.5e-07 W=1.5e-06 $X=42900 $Y=162230 $dt=15
M1086 VSS! VDD! VSS! VSS! nfet_01v8 L=5.8e-07 W=1.5e-06 $X=48590 $Y=71150 $dt=15
M1087 VSS! VDD! VSS! VSS! nfet_01v8 L=5.8e-07 W=1.5e-06 $X=48590 $Y=79430 $dt=15
M1088 VSS! VDD! VSS! VSS! nfet_01v8 L=5.8e-07 W=1.5e-06 $X=48590 $Y=87710 $dt=15
M1089 VSS! VDD! VSS! VSS! nfet_01v8 L=5.8e-07 W=1.5e-06 $X=48590 $Y=95990 $dt=15
M1090 VSS! VDD! VSS! VSS! nfet_01v8 L=5.8e-07 W=1.5e-06 $X=48590 $Y=104270 $dt=15
M1091 625 495 VIN VSS! nfet_01v8 L=1.5e-07 W=1.5e-06 $X=48600 $Y=13190 $dt=15
M1092 626 496 VIN VSS! nfet_01v8 L=1.5e-07 W=1.5e-06 $X=48600 $Y=21470 $dt=15
M1093 627 497 VIN VSS! nfet_01v8 L=1.5e-07 W=1.5e-06 $X=48600 $Y=29750 $dt=15
M1094 628 498 VIN VSS! nfet_01v8 L=1.5e-07 W=1.5e-06 $X=48600 $Y=38030 $dt=15
M1095 629 499 VIN VSS! nfet_01v8 L=1.5e-07 W=1.5e-06 $X=48600 $Y=46310 $dt=15
M1096 630 500 VIN VSS! nfet_01v8 L=1.5e-07 W=1.5e-06 $X=48600 $Y=54590 $dt=15
M1097 631 501 VIN VSS! nfet_01v8 L=1.5e-07 W=1.5e-06 $X=48600 $Y=62870 $dt=15
M1098 632 507 VIN VSS! nfet_01v8 L=1.5e-07 W=1.5e-06 $X=48600 $Y=112550 $dt=15
M1099 633 508 VIN VSS! nfet_01v8 L=1.5e-07 W=1.5e-06 $X=48600 $Y=120830 $dt=15
M1100 634 509 VIN VSS! nfet_01v8 L=1.5e-07 W=1.5e-06 $X=48600 $Y=129110 $dt=15
M1101 635 510 VIN VSS! nfet_01v8 L=1.5e-07 W=1.5e-06 $X=48600 $Y=137390 $dt=15
M1102 636 511 VIN VSS! nfet_01v8 L=1.5e-07 W=1.5e-06 $X=48600 $Y=145670 $dt=15
M1103 637 512 VIN VSS! nfet_01v8 L=1.5e-07 W=1.5e-06 $X=48600 $Y=153950 $dt=15
M1104 638 513 VIN VSS! nfet_01v8 L=1.5e-07 W=1.5e-06 $X=48600 $Y=162230 $dt=15
M1105 VREF_N 458 625 VSS! nfet_01v8 L=1.5e-07 W=1.5e-06 $X=49030 $Y=13190 $dt=15
M1106 VREF_N 460 626 VSS! nfet_01v8 L=1.5e-07 W=1.5e-06 $X=49030 $Y=21470 $dt=15
M1107 VREF_N 462 627 VSS! nfet_01v8 L=1.5e-07 W=1.5e-06 $X=49030 $Y=29750 $dt=15
M1108 VREF_N 464 628 VSS! nfet_01v8 L=1.5e-07 W=1.5e-06 $X=49030 $Y=38030 $dt=15
M1109 VREF_N 466 629 VSS! nfet_01v8 L=1.5e-07 W=1.5e-06 $X=49030 $Y=46310 $dt=15
M1110 VREF_N 468 630 VSS! nfet_01v8 L=1.5e-07 W=1.5e-06 $X=49030 $Y=54590 $dt=15
M1111 VREF_N 470 631 VSS! nfet_01v8 L=1.5e-07 W=1.5e-06 $X=49030 $Y=62870 $dt=15
M1112 VREF_N 482 632 VSS! nfet_01v8 L=1.5e-07 W=1.5e-06 $X=49030 $Y=112550 $dt=15
M1113 VREF_N 484 633 VSS! nfet_01v8 L=1.5e-07 W=1.5e-06 $X=49030 $Y=120830 $dt=15
M1114 VREF_N 486 634 VSS! nfet_01v8 L=1.5e-07 W=1.5e-06 $X=49030 $Y=129110 $dt=15
M1115 VREF_N 488 635 VSS! nfet_01v8 L=1.5e-07 W=1.5e-06 $X=49030 $Y=137390 $dt=15
M1116 VREF_N 490 636 VSS! nfet_01v8 L=1.5e-07 W=1.5e-06 $X=49030 $Y=145670 $dt=15
M1117 VREF_N 492 637 VSS! nfet_01v8 L=1.5e-07 W=1.5e-06 $X=49030 $Y=153950 $dt=15
M1118 VREF_N 494 638 VSS! nfet_01v8 L=1.5e-07 W=1.5e-06 $X=49030 $Y=162230 $dt=15
M1119 607 534 VREF_P VSS! nfet_01v8 L=1.5e-07 W=1.5e-06 $X=50750 $Y=13190 $dt=15
M1120 608 536 VREF_P VSS! nfet_01v8 L=1.5e-07 W=1.5e-06 $X=50750 $Y=21470 $dt=15
M1121 609 538 VREF_P VSS! nfet_01v8 L=1.5e-07 W=1.5e-06 $X=50750 $Y=29750 $dt=15
M1122 610 540 VREF_P VSS! nfet_01v8 L=1.5e-07 W=1.5e-06 $X=50750 $Y=38030 $dt=15
M1123 611 542 VREF_P VSS! nfet_01v8 L=1.5e-07 W=1.5e-06 $X=50750 $Y=46310 $dt=15
M1124 612 544 VREF_P VSS! nfet_01v8 L=1.5e-07 W=1.5e-06 $X=50750 $Y=54590 $dt=15
M1125 613 546 VREF_P VSS! nfet_01v8 L=1.5e-07 W=1.5e-06 $X=50750 $Y=62870 $dt=15
M1126 614 548 VREF_P VSS! nfet_01v8 L=1.5e-07 W=1.5e-06 $X=50750 $Y=71150 $dt=15
M1127 615 550 VREF_P VSS! nfet_01v8 L=1.5e-07 W=1.5e-06 $X=50750 $Y=79430 $dt=15
M1128 VSS! VDD! VSS! VSS! nfet_01v8 L=5.8e-07 W=1.5e-06 $X=50750 $Y=87710 $dt=15
M1129 616 554 VREF_P VSS! nfet_01v8 L=1.5e-07 W=1.5e-06 $X=50750 $Y=95990 $dt=15
M1130 617 556 VREF_P VSS! nfet_01v8 L=1.5e-07 W=1.5e-06 $X=50750 $Y=104270 $dt=15
M1131 618 558 VREF_P VSS! nfet_01v8 L=1.5e-07 W=1.5e-06 $X=50750 $Y=112550 $dt=15
M1132 619 560 VREF_P VSS! nfet_01v8 L=1.5e-07 W=1.5e-06 $X=50750 $Y=120830 $dt=15
M1133 620 562 VREF_P VSS! nfet_01v8 L=1.5e-07 W=1.5e-06 $X=50750 $Y=129110 $dt=15
M1134 621 564 VREF_P VSS! nfet_01v8 L=1.5e-07 W=1.5e-06 $X=50750 $Y=137390 $dt=15
M1135 622 566 VREF_P VSS! nfet_01v8 L=1.5e-07 W=1.5e-06 $X=50750 $Y=145670 $dt=15
M1136 623 568 VREF_P VSS! nfet_01v8 L=1.5e-07 W=1.5e-06 $X=50750 $Y=153950 $dt=15
M1137 624 570 VREF_P VSS! nfet_01v8 L=1.5e-07 W=1.5e-06 $X=50750 $Y=162230 $dt=15
M1138 607 514 607 VSS! nfet_01v8 L=1.5e-07 W=1.5e-06 $X=51180 $Y=13190 $dt=15
M1139 608 515 608 VSS! nfet_01v8 L=1.5e-07 W=1.5e-06 $X=51180 $Y=21470 $dt=15
M1140 609 516 609 VSS! nfet_01v8 L=1.5e-07 W=1.5e-06 $X=51180 $Y=29750 $dt=15
M1141 610 517 610 VSS! nfet_01v8 L=1.5e-07 W=1.5e-06 $X=51180 $Y=38030 $dt=15
M1142 611 518 611 VSS! nfet_01v8 L=1.5e-07 W=1.5e-06 $X=51180 $Y=46310 $dt=15
M1143 612 519 612 VSS! nfet_01v8 L=1.5e-07 W=1.5e-06 $X=51180 $Y=54590 $dt=15
M1144 613 520 613 VSS! nfet_01v8 L=1.5e-07 W=1.5e-06 $X=51180 $Y=62870 $dt=15
M1145 614 521 614 VSS! nfet_01v8 L=1.5e-07 W=1.5e-06 $X=51180 $Y=71150 $dt=15
M1146 615 522 615 VSS! nfet_01v8 L=1.5e-07 W=1.5e-06 $X=51180 $Y=79430 $dt=15
M1147 616 524 616 VSS! nfet_01v8 L=1.5e-07 W=1.5e-06 $X=51180 $Y=95990 $dt=15
M1148 617 525 617 VSS! nfet_01v8 L=1.5e-07 W=1.5e-06 $X=51180 $Y=104270 $dt=15
M1149 618 526 618 VSS! nfet_01v8 L=1.5e-07 W=1.5e-06 $X=51180 $Y=112550 $dt=15
M1150 619 527 619 VSS! nfet_01v8 L=1.5e-07 W=1.5e-06 $X=51180 $Y=120830 $dt=15
M1151 620 528 620 VSS! nfet_01v8 L=1.5e-07 W=1.5e-06 $X=51180 $Y=129110 $dt=15
M1152 621 529 621 VSS! nfet_01v8 L=1.5e-07 W=1.5e-06 $X=51180 $Y=137390 $dt=15
M1153 622 530 622 VSS! nfet_01v8 L=1.5e-07 W=1.5e-06 $X=51180 $Y=145670 $dt=15
M1154 623 531 623 VSS! nfet_01v8 L=1.5e-07 W=1.5e-06 $X=51180 $Y=153950 $dt=15
M1155 624 532 624 VSS! nfet_01v8 L=1.5e-07 W=1.5e-06 $X=51180 $Y=162230 $dt=15
M1156 VSS! VDD! VSS! VSS! nfet_01v8 L=5.8e-07 W=1.5e-06 $X=56870 $Y=87710 $dt=15
M1157 607 495 VIN VSS! nfet_01v8 L=1.5e-07 W=1.5e-06 $X=56880 $Y=13190 $dt=15
M1158 608 496 VIN VSS! nfet_01v8 L=1.5e-07 W=1.5e-06 $X=56880 $Y=21470 $dt=15
M1159 609 497 VIN VSS! nfet_01v8 L=1.5e-07 W=1.5e-06 $X=56880 $Y=29750 $dt=15
M1160 610 498 VIN VSS! nfet_01v8 L=1.5e-07 W=1.5e-06 $X=56880 $Y=38030 $dt=15
M1161 611 499 VIN VSS! nfet_01v8 L=1.5e-07 W=1.5e-06 $X=56880 $Y=46310 $dt=15
M1162 612 500 VIN VSS! nfet_01v8 L=1.5e-07 W=1.5e-06 $X=56880 $Y=54590 $dt=15
M1163 613 501 VIN VSS! nfet_01v8 L=1.5e-07 W=1.5e-06 $X=56880 $Y=62870 $dt=15
M1164 614 502 VIN VSS! nfet_01v8 L=1.5e-07 W=1.5e-06 $X=56880 $Y=71150 $dt=15
M1165 615 503 VIN VSS! nfet_01v8 L=1.5e-07 W=1.5e-06 $X=56880 $Y=79430 $dt=15
M1166 616 505 VIN VSS! nfet_01v8 L=1.5e-07 W=1.5e-06 $X=56880 $Y=95990 $dt=15
M1167 617 506 VIN VSS! nfet_01v8 L=1.5e-07 W=1.5e-06 $X=56880 $Y=104270 $dt=15
M1168 618 507 VIN VSS! nfet_01v8 L=1.5e-07 W=1.5e-06 $X=56880 $Y=112550 $dt=15
M1169 619 508 VIN VSS! nfet_01v8 L=1.5e-07 W=1.5e-06 $X=56880 $Y=120830 $dt=15
M1170 620 509 VIN VSS! nfet_01v8 L=1.5e-07 W=1.5e-06 $X=56880 $Y=129110 $dt=15
M1171 621 510 VIN VSS! nfet_01v8 L=1.5e-07 W=1.5e-06 $X=56880 $Y=137390 $dt=15
M1172 622 511 VIN VSS! nfet_01v8 L=1.5e-07 W=1.5e-06 $X=56880 $Y=145670 $dt=15
M1173 623 512 VIN VSS! nfet_01v8 L=1.5e-07 W=1.5e-06 $X=56880 $Y=153950 $dt=15
M1174 624 513 VIN VSS! nfet_01v8 L=1.5e-07 W=1.5e-06 $X=56880 $Y=162230 $dt=15
M1175 VREF_N 458 607 VSS! nfet_01v8 L=1.5e-07 W=1.5e-06 $X=57310 $Y=13190 $dt=15
M1176 VREF_N 460 608 VSS! nfet_01v8 L=1.5e-07 W=1.5e-06 $X=57310 $Y=21470 $dt=15
M1177 VREF_N 462 609 VSS! nfet_01v8 L=1.5e-07 W=1.5e-06 $X=57310 $Y=29750 $dt=15
M1178 VREF_N 464 610 VSS! nfet_01v8 L=1.5e-07 W=1.5e-06 $X=57310 $Y=38030 $dt=15
M1179 VREF_N 466 611 VSS! nfet_01v8 L=1.5e-07 W=1.5e-06 $X=57310 $Y=46310 $dt=15
M1180 VREF_N 468 612 VSS! nfet_01v8 L=1.5e-07 W=1.5e-06 $X=57310 $Y=54590 $dt=15
M1181 VREF_N 470 613 VSS! nfet_01v8 L=1.5e-07 W=1.5e-06 $X=57310 $Y=62870 $dt=15
M1182 VREF_N 472 614 VSS! nfet_01v8 L=1.5e-07 W=1.5e-06 $X=57310 $Y=71150 $dt=15
M1183 VREF_N 474 615 VSS! nfet_01v8 L=1.5e-07 W=1.5e-06 $X=57310 $Y=79430 $dt=15
M1184 VREF_N 478 616 VSS! nfet_01v8 L=1.5e-07 W=1.5e-06 $X=57310 $Y=95990 $dt=15
M1185 VREF_N 480 617 VSS! nfet_01v8 L=1.5e-07 W=1.5e-06 $X=57310 $Y=104270 $dt=15
M1186 VREF_N 482 618 VSS! nfet_01v8 L=1.5e-07 W=1.5e-06 $X=57310 $Y=112550 $dt=15
M1187 VREF_N 484 619 VSS! nfet_01v8 L=1.5e-07 W=1.5e-06 $X=57310 $Y=120830 $dt=15
M1188 VREF_N 486 620 VSS! nfet_01v8 L=1.5e-07 W=1.5e-06 $X=57310 $Y=129110 $dt=15
M1189 VREF_N 488 621 VSS! nfet_01v8 L=1.5e-07 W=1.5e-06 $X=57310 $Y=137390 $dt=15
M1190 VREF_N 490 622 VSS! nfet_01v8 L=1.5e-07 W=1.5e-06 $X=57310 $Y=145670 $dt=15
M1191 VREF_N 492 623 VSS! nfet_01v8 L=1.5e-07 W=1.5e-06 $X=57310 $Y=153950 $dt=15
M1192 VREF_N 494 624 VSS! nfet_01v8 L=1.5e-07 W=1.5e-06 $X=57310 $Y=162230 $dt=15
M1193 589 534 VREF_P VSS! nfet_01v8 L=1.5e-07 W=1.5e-06 $X=59030 $Y=13190 $dt=15
M1194 590 536 VREF_P VSS! nfet_01v8 L=1.5e-07 W=1.5e-06 $X=59030 $Y=21470 $dt=15
M1195 591 538 VREF_P VSS! nfet_01v8 L=1.5e-07 W=1.5e-06 $X=59030 $Y=29750 $dt=15
M1196 592 540 VREF_P VSS! nfet_01v8 L=1.5e-07 W=1.5e-06 $X=59030 $Y=38030 $dt=15
M1197 593 542 VREF_P VSS! nfet_01v8 L=1.5e-07 W=1.5e-06 $X=59030 $Y=46310 $dt=15
M1198 594 544 VREF_P VSS! nfet_01v8 L=1.5e-07 W=1.5e-06 $X=59030 $Y=54590 $dt=15
M1199 595 546 VREF_P VSS! nfet_01v8 L=1.5e-07 W=1.5e-06 $X=59030 $Y=62870 $dt=15
M1200 596 548 VREF_P VSS! nfet_01v8 L=1.5e-07 W=1.5e-06 $X=59030 $Y=71150 $dt=15
M1201 597 550 VREF_P VSS! nfet_01v8 L=1.5e-07 W=1.5e-06 $X=59030 $Y=79430 $dt=15
M1202 VSS! VDD! VSS! VSS! nfet_01v8 L=5.8e-07 W=1.5e-06 $X=59030 $Y=87710 $dt=15
M1203 598 554 VREF_P VSS! nfet_01v8 L=1.5e-07 W=1.5e-06 $X=59030 $Y=95990 $dt=15
M1204 599 556 VREF_P VSS! nfet_01v8 L=1.5e-07 W=1.5e-06 $X=59030 $Y=104270 $dt=15
M1205 600 558 VREF_P VSS! nfet_01v8 L=1.5e-07 W=1.5e-06 $X=59030 $Y=112550 $dt=15
M1206 601 560 VREF_P VSS! nfet_01v8 L=1.5e-07 W=1.5e-06 $X=59030 $Y=120830 $dt=15
M1207 602 562 VREF_P VSS! nfet_01v8 L=1.5e-07 W=1.5e-06 $X=59030 $Y=129110 $dt=15
M1208 603 564 VREF_P VSS! nfet_01v8 L=1.5e-07 W=1.5e-06 $X=59030 $Y=137390 $dt=15
M1209 604 566 VREF_P VSS! nfet_01v8 L=1.5e-07 W=1.5e-06 $X=59030 $Y=145670 $dt=15
M1210 605 568 VREF_P VSS! nfet_01v8 L=1.5e-07 W=1.5e-06 $X=59030 $Y=153950 $dt=15
M1211 606 570 VREF_P VSS! nfet_01v8 L=1.5e-07 W=1.5e-06 $X=59030 $Y=162230 $dt=15
M1212 589 514 589 VSS! nfet_01v8 L=1.5e-07 W=1.5e-06 $X=59460 $Y=13190 $dt=15
M1213 590 515 590 VSS! nfet_01v8 L=1.5e-07 W=1.5e-06 $X=59460 $Y=21470 $dt=15
M1214 591 516 591 VSS! nfet_01v8 L=1.5e-07 W=1.5e-06 $X=59460 $Y=29750 $dt=15
M1215 592 517 592 VSS! nfet_01v8 L=1.5e-07 W=1.5e-06 $X=59460 $Y=38030 $dt=15
M1216 593 518 593 VSS! nfet_01v8 L=1.5e-07 W=1.5e-06 $X=59460 $Y=46310 $dt=15
M1217 594 519 594 VSS! nfet_01v8 L=1.5e-07 W=1.5e-06 $X=59460 $Y=54590 $dt=15
M1218 595 520 595 VSS! nfet_01v8 L=1.5e-07 W=1.5e-06 $X=59460 $Y=62870 $dt=15
M1219 596 521 596 VSS! nfet_01v8 L=1.5e-07 W=1.5e-06 $X=59460 $Y=71150 $dt=15
M1220 597 522 597 VSS! nfet_01v8 L=1.5e-07 W=1.5e-06 $X=59460 $Y=79430 $dt=15
M1221 598 524 598 VSS! nfet_01v8 L=1.5e-07 W=1.5e-06 $X=59460 $Y=95990 $dt=15
M1222 599 525 599 VSS! nfet_01v8 L=1.5e-07 W=1.5e-06 $X=59460 $Y=104270 $dt=15
M1223 600 526 600 VSS! nfet_01v8 L=1.5e-07 W=1.5e-06 $X=59460 $Y=112550 $dt=15
M1224 601 527 601 VSS! nfet_01v8 L=1.5e-07 W=1.5e-06 $X=59460 $Y=120830 $dt=15
M1225 602 528 602 VSS! nfet_01v8 L=1.5e-07 W=1.5e-06 $X=59460 $Y=129110 $dt=15
M1226 603 529 603 VSS! nfet_01v8 L=1.5e-07 W=1.5e-06 $X=59460 $Y=137390 $dt=15
M1227 604 530 604 VSS! nfet_01v8 L=1.5e-07 W=1.5e-06 $X=59460 $Y=145670 $dt=15
M1228 605 531 605 VSS! nfet_01v8 L=1.5e-07 W=1.5e-06 $X=59460 $Y=153950 $dt=15
M1229 606 532 606 VSS! nfet_01v8 L=1.5e-07 W=1.5e-06 $X=59460 $Y=162230 $dt=15
M1230 VSS! VDD! VSS! VSS! nfet_01v8 L=5.8e-07 W=1.5e-06 $X=65150 $Y=87710 $dt=15
M1231 589 495 VIN VSS! nfet_01v8 L=1.5e-07 W=1.5e-06 $X=65160 $Y=13190 $dt=15
M1232 590 496 VIN VSS! nfet_01v8 L=1.5e-07 W=1.5e-06 $X=65160 $Y=21470 $dt=15
M1233 591 497 VIN VSS! nfet_01v8 L=1.5e-07 W=1.5e-06 $X=65160 $Y=29750 $dt=15
M1234 592 498 VIN VSS! nfet_01v8 L=1.5e-07 W=1.5e-06 $X=65160 $Y=38030 $dt=15
M1235 593 499 VIN VSS! nfet_01v8 L=1.5e-07 W=1.5e-06 $X=65160 $Y=46310 $dt=15
M1236 594 500 VIN VSS! nfet_01v8 L=1.5e-07 W=1.5e-06 $X=65160 $Y=54590 $dt=15
M1237 595 501 VIN VSS! nfet_01v8 L=1.5e-07 W=1.5e-06 $X=65160 $Y=62870 $dt=15
M1238 596 502 VIN VSS! nfet_01v8 L=1.5e-07 W=1.5e-06 $X=65160 $Y=71150 $dt=15
M1239 597 503 VIN VSS! nfet_01v8 L=1.5e-07 W=1.5e-06 $X=65160 $Y=79430 $dt=15
M1240 598 505 VIN VSS! nfet_01v8 L=1.5e-07 W=1.5e-06 $X=65160 $Y=95990 $dt=15
M1241 599 506 VIN VSS! nfet_01v8 L=1.5e-07 W=1.5e-06 $X=65160 $Y=104270 $dt=15
M1242 600 507 VIN VSS! nfet_01v8 L=1.5e-07 W=1.5e-06 $X=65160 $Y=112550 $dt=15
M1243 601 508 VIN VSS! nfet_01v8 L=1.5e-07 W=1.5e-06 $X=65160 $Y=120830 $dt=15
M1244 602 509 VIN VSS! nfet_01v8 L=1.5e-07 W=1.5e-06 $X=65160 $Y=129110 $dt=15
M1245 603 510 VIN VSS! nfet_01v8 L=1.5e-07 W=1.5e-06 $X=65160 $Y=137390 $dt=15
M1246 604 511 VIN VSS! nfet_01v8 L=1.5e-07 W=1.5e-06 $X=65160 $Y=145670 $dt=15
M1247 605 512 VIN VSS! nfet_01v8 L=1.5e-07 W=1.5e-06 $X=65160 $Y=153950 $dt=15
M1248 606 513 VIN VSS! nfet_01v8 L=1.5e-07 W=1.5e-06 $X=65160 $Y=162230 $dt=15
M1249 VREF_N 458 589 VSS! nfet_01v8 L=1.5e-07 W=1.5e-06 $X=65590 $Y=13190 $dt=15
M1250 VREF_N 460 590 VSS! nfet_01v8 L=1.5e-07 W=1.5e-06 $X=65590 $Y=21470 $dt=15
M1251 VREF_N 462 591 VSS! nfet_01v8 L=1.5e-07 W=1.5e-06 $X=65590 $Y=29750 $dt=15
M1252 VREF_N 464 592 VSS! nfet_01v8 L=1.5e-07 W=1.5e-06 $X=65590 $Y=38030 $dt=15
M1253 VREF_N 466 593 VSS! nfet_01v8 L=1.5e-07 W=1.5e-06 $X=65590 $Y=46310 $dt=15
M1254 VREF_N 468 594 VSS! nfet_01v8 L=1.5e-07 W=1.5e-06 $X=65590 $Y=54590 $dt=15
M1255 VREF_N 470 595 VSS! nfet_01v8 L=1.5e-07 W=1.5e-06 $X=65590 $Y=62870 $dt=15
M1256 VREF_N 472 596 VSS! nfet_01v8 L=1.5e-07 W=1.5e-06 $X=65590 $Y=71150 $dt=15
M1257 VREF_N 474 597 VSS! nfet_01v8 L=1.5e-07 W=1.5e-06 $X=65590 $Y=79430 $dt=15
M1258 VREF_N 478 598 VSS! nfet_01v8 L=1.5e-07 W=1.5e-06 $X=65590 $Y=95990 $dt=15
M1259 VREF_N 480 599 VSS! nfet_01v8 L=1.5e-07 W=1.5e-06 $X=65590 $Y=104270 $dt=15
M1260 VREF_N 482 600 VSS! nfet_01v8 L=1.5e-07 W=1.5e-06 $X=65590 $Y=112550 $dt=15
M1261 VREF_N 484 601 VSS! nfet_01v8 L=1.5e-07 W=1.5e-06 $X=65590 $Y=120830 $dt=15
M1262 VREF_N 486 602 VSS! nfet_01v8 L=1.5e-07 W=1.5e-06 $X=65590 $Y=129110 $dt=15
M1263 VREF_N 488 603 VSS! nfet_01v8 L=1.5e-07 W=1.5e-06 $X=65590 $Y=137390 $dt=15
M1264 VREF_N 490 604 VSS! nfet_01v8 L=1.5e-07 W=1.5e-06 $X=65590 $Y=145670 $dt=15
M1265 VREF_N 492 605 VSS! nfet_01v8 L=1.5e-07 W=1.5e-06 $X=65590 $Y=153950 $dt=15
M1266 VREF_N 494 606 VSS! nfet_01v8 L=1.5e-07 W=1.5e-06 $X=65590 $Y=162230 $dt=15
M1267 571 534 VREF_P VSS! nfet_01v8 L=1.5e-07 W=1.5e-06 $X=67310 $Y=13190 $dt=15
M1268 572 536 VREF_P VSS! nfet_01v8 L=1.5e-07 W=1.5e-06 $X=67310 $Y=21470 $dt=15
M1269 573 538 VREF_P VSS! nfet_01v8 L=1.5e-07 W=1.5e-06 $X=67310 $Y=29750 $dt=15
M1270 574 540 VREF_P VSS! nfet_01v8 L=1.5e-07 W=1.5e-06 $X=67310 $Y=38030 $dt=15
M1271 575 542 VREF_P VSS! nfet_01v8 L=1.5e-07 W=1.5e-06 $X=67310 $Y=46310 $dt=15
M1272 576 544 VREF_P VSS! nfet_01v8 L=1.5e-07 W=1.5e-06 $X=67310 $Y=54590 $dt=15
M1273 577 546 VREF_P VSS! nfet_01v8 L=1.5e-07 W=1.5e-06 $X=67310 $Y=62870 $dt=15
M1274 578 548 VREF_P VSS! nfet_01v8 L=1.5e-07 W=1.5e-06 $X=67310 $Y=71150 $dt=15
M1275 579 550 VREF_P VSS! nfet_01v8 L=1.5e-07 W=1.5e-06 $X=67310 $Y=79430 $dt=15
M1276 VSS! VDD! VSS! VSS! nfet_01v8 L=5.8e-07 W=1.5e-06 $X=67310 $Y=87710 $dt=15
M1277 580 554 VREF_P VSS! nfet_01v8 L=1.5e-07 W=1.5e-06 $X=67310 $Y=95990 $dt=15
M1278 581 556 VREF_P VSS! nfet_01v8 L=1.5e-07 W=1.5e-06 $X=67310 $Y=104270 $dt=15
M1279 582 558 VREF_P VSS! nfet_01v8 L=1.5e-07 W=1.5e-06 $X=67310 $Y=112550 $dt=15
M1280 583 560 VREF_P VSS! nfet_01v8 L=1.5e-07 W=1.5e-06 $X=67310 $Y=120830 $dt=15
M1281 584 562 VREF_P VSS! nfet_01v8 L=1.5e-07 W=1.5e-06 $X=67310 $Y=129110 $dt=15
M1282 585 564 VREF_P VSS! nfet_01v8 L=1.5e-07 W=1.5e-06 $X=67310 $Y=137390 $dt=15
M1283 586 566 VREF_P VSS! nfet_01v8 L=1.5e-07 W=1.5e-06 $X=67310 $Y=145670 $dt=15
M1284 587 568 VREF_P VSS! nfet_01v8 L=1.5e-07 W=1.5e-06 $X=67310 $Y=153950 $dt=15
M1285 588 570 VREF_P VSS! nfet_01v8 L=1.5e-07 W=1.5e-06 $X=67310 $Y=162230 $dt=15
M1286 571 514 571 VSS! nfet_01v8 L=1.5e-07 W=1.5e-06 $X=67740 $Y=13190 $dt=15
M1287 572 515 572 VSS! nfet_01v8 L=1.5e-07 W=1.5e-06 $X=67740 $Y=21470 $dt=15
M1288 573 516 573 VSS! nfet_01v8 L=1.5e-07 W=1.5e-06 $X=67740 $Y=29750 $dt=15
M1289 574 517 574 VSS! nfet_01v8 L=1.5e-07 W=1.5e-06 $X=67740 $Y=38030 $dt=15
M1290 575 518 575 VSS! nfet_01v8 L=1.5e-07 W=1.5e-06 $X=67740 $Y=46310 $dt=15
M1291 576 519 576 VSS! nfet_01v8 L=1.5e-07 W=1.5e-06 $X=67740 $Y=54590 $dt=15
M1292 577 520 577 VSS! nfet_01v8 L=1.5e-07 W=1.5e-06 $X=67740 $Y=62870 $dt=15
M1293 578 521 578 VSS! nfet_01v8 L=1.5e-07 W=1.5e-06 $X=67740 $Y=71150 $dt=15
M1294 579 522 579 VSS! nfet_01v8 L=1.5e-07 W=1.5e-06 $X=67740 $Y=79430 $dt=15
M1295 580 524 580 VSS! nfet_01v8 L=1.5e-07 W=1.5e-06 $X=67740 $Y=95990 $dt=15
M1296 581 525 581 VSS! nfet_01v8 L=1.5e-07 W=1.5e-06 $X=67740 $Y=104270 $dt=15
M1297 582 526 582 VSS! nfet_01v8 L=1.5e-07 W=1.5e-06 $X=67740 $Y=112550 $dt=15
M1298 583 527 583 VSS! nfet_01v8 L=1.5e-07 W=1.5e-06 $X=67740 $Y=120830 $dt=15
M1299 584 528 584 VSS! nfet_01v8 L=1.5e-07 W=1.5e-06 $X=67740 $Y=129110 $dt=15
M1300 585 529 585 VSS! nfet_01v8 L=1.5e-07 W=1.5e-06 $X=67740 $Y=137390 $dt=15
M1301 586 530 586 VSS! nfet_01v8 L=1.5e-07 W=1.5e-06 $X=67740 $Y=145670 $dt=15
M1302 587 531 587 VSS! nfet_01v8 L=1.5e-07 W=1.5e-06 $X=67740 $Y=153950 $dt=15
M1303 588 532 588 VSS! nfet_01v8 L=1.5e-07 W=1.5e-06 $X=67740 $Y=162230 $dt=15
M1304 VSS! VDD! VSS! VSS! nfet_01v8 L=5.8e-07 W=1.5e-06 $X=73430 $Y=87710 $dt=15
M1305 571 495 VIN VSS! nfet_01v8 L=1.5e-07 W=1.5e-06 $X=73440 $Y=13190 $dt=15
M1306 572 496 VIN VSS! nfet_01v8 L=1.5e-07 W=1.5e-06 $X=73440 $Y=21470 $dt=15
M1307 573 497 VIN VSS! nfet_01v8 L=1.5e-07 W=1.5e-06 $X=73440 $Y=29750 $dt=15
M1308 574 498 VIN VSS! nfet_01v8 L=1.5e-07 W=1.5e-06 $X=73440 $Y=38030 $dt=15
M1309 575 499 VIN VSS! nfet_01v8 L=1.5e-07 W=1.5e-06 $X=73440 $Y=46310 $dt=15
M1310 576 500 VIN VSS! nfet_01v8 L=1.5e-07 W=1.5e-06 $X=73440 $Y=54590 $dt=15
M1311 577 501 VIN VSS! nfet_01v8 L=1.5e-07 W=1.5e-06 $X=73440 $Y=62870 $dt=15
M1312 578 502 VIN VSS! nfet_01v8 L=1.5e-07 W=1.5e-06 $X=73440 $Y=71150 $dt=15
M1313 579 503 VIN VSS! nfet_01v8 L=1.5e-07 W=1.5e-06 $X=73440 $Y=79430 $dt=15
M1314 580 505 VIN VSS! nfet_01v8 L=1.5e-07 W=1.5e-06 $X=73440 $Y=95990 $dt=15
M1315 581 506 VIN VSS! nfet_01v8 L=1.5e-07 W=1.5e-06 $X=73440 $Y=104270 $dt=15
M1316 582 507 VIN VSS! nfet_01v8 L=1.5e-07 W=1.5e-06 $X=73440 $Y=112550 $dt=15
M1317 583 508 VIN VSS! nfet_01v8 L=1.5e-07 W=1.5e-06 $X=73440 $Y=120830 $dt=15
M1318 584 509 VIN VSS! nfet_01v8 L=1.5e-07 W=1.5e-06 $X=73440 $Y=129110 $dt=15
M1319 585 510 VIN VSS! nfet_01v8 L=1.5e-07 W=1.5e-06 $X=73440 $Y=137390 $dt=15
M1320 586 511 VIN VSS! nfet_01v8 L=1.5e-07 W=1.5e-06 $X=73440 $Y=145670 $dt=15
M1321 587 512 VIN VSS! nfet_01v8 L=1.5e-07 W=1.5e-06 $X=73440 $Y=153950 $dt=15
M1322 588 513 VIN VSS! nfet_01v8 L=1.5e-07 W=1.5e-06 $X=73440 $Y=162230 $dt=15
M1323 VREF_N 458 571 VSS! nfet_01v8 L=1.5e-07 W=1.5e-06 $X=73870 $Y=13190 $dt=15
M1324 VREF_N 460 572 VSS! nfet_01v8 L=1.5e-07 W=1.5e-06 $X=73870 $Y=21470 $dt=15
M1325 VREF_N 462 573 VSS! nfet_01v8 L=1.5e-07 W=1.5e-06 $X=73870 $Y=29750 $dt=15
M1326 VREF_N 464 574 VSS! nfet_01v8 L=1.5e-07 W=1.5e-06 $X=73870 $Y=38030 $dt=15
M1327 VREF_N 466 575 VSS! nfet_01v8 L=1.5e-07 W=1.5e-06 $X=73870 $Y=46310 $dt=15
M1328 VREF_N 468 576 VSS! nfet_01v8 L=1.5e-07 W=1.5e-06 $X=73870 $Y=54590 $dt=15
M1329 VREF_N 470 577 VSS! nfet_01v8 L=1.5e-07 W=1.5e-06 $X=73870 $Y=62870 $dt=15
M1330 VREF_N 472 578 VSS! nfet_01v8 L=1.5e-07 W=1.5e-06 $X=73870 $Y=71150 $dt=15
M1331 VREF_N 474 579 VSS! nfet_01v8 L=1.5e-07 W=1.5e-06 $X=73870 $Y=79430 $dt=15
M1332 VREF_N 478 580 VSS! nfet_01v8 L=1.5e-07 W=1.5e-06 $X=73870 $Y=95990 $dt=15
M1333 VREF_N 480 581 VSS! nfet_01v8 L=1.5e-07 W=1.5e-06 $X=73870 $Y=104270 $dt=15
M1334 VREF_N 482 582 VSS! nfet_01v8 L=1.5e-07 W=1.5e-06 $X=73870 $Y=112550 $dt=15
M1335 VREF_N 484 583 VSS! nfet_01v8 L=1.5e-07 W=1.5e-06 $X=73870 $Y=120830 $dt=15
M1336 VREF_N 486 584 VSS! nfet_01v8 L=1.5e-07 W=1.5e-06 $X=73870 $Y=129110 $dt=15
M1337 VREF_N 488 585 VSS! nfet_01v8 L=1.5e-07 W=1.5e-06 $X=73870 $Y=137390 $dt=15
M1338 VREF_N 490 586 VSS! nfet_01v8 L=1.5e-07 W=1.5e-06 $X=73870 $Y=145670 $dt=15
M1339 VREF_N 492 587 VSS! nfet_01v8 L=1.5e-07 W=1.5e-06 $X=73870 $Y=153950 $dt=15
M1340 VREF_N 494 588 VSS! nfet_01v8 L=1.5e-07 W=1.5e-06 $X=73870 $Y=162230 $dt=15
M1341 438 534 VREF_P VSS! nfet_01v8 L=1.5e-07 W=1.5e-06 $X=75590 $Y=13190 $dt=15
M1342 439 536 VREF_P VSS! nfet_01v8 L=1.5e-07 W=1.5e-06 $X=75590 $Y=21470 $dt=15
M1343 440 538 VREF_P VSS! nfet_01v8 L=1.5e-07 W=1.5e-06 $X=75590 $Y=29750 $dt=15
M1344 441 540 VREF_P VSS! nfet_01v8 L=1.5e-07 W=1.5e-06 $X=75590 $Y=38030 $dt=15
M1345 442 542 VREF_P VSS! nfet_01v8 L=1.5e-07 W=1.5e-06 $X=75590 $Y=46310 $dt=15
M1346 443 544 VREF_P VSS! nfet_01v8 L=1.5e-07 W=1.5e-06 $X=75590 $Y=54590 $dt=15
M1347 444 546 VREF_P VSS! nfet_01v8 L=1.5e-07 W=1.5e-06 $X=75590 $Y=62870 $dt=15
M1348 445 548 VREF_P VSS! nfet_01v8 L=1.5e-07 W=1.5e-06 $X=75590 $Y=71150 $dt=15
M1349 446 550 VREF_P VSS! nfet_01v8 L=1.5e-07 W=1.5e-06 $X=75590 $Y=79430 $dt=15
M1350 447 552 VREF_P VSS! nfet_01v8 L=1.5e-07 W=1.5e-06 $X=75590 $Y=87710 $dt=15
M1351 448 554 VREF_P VSS! nfet_01v8 L=1.5e-07 W=1.5e-06 $X=75590 $Y=95990 $dt=15
M1352 449 556 VREF_P VSS! nfet_01v8 L=1.5e-07 W=1.5e-06 $X=75590 $Y=104270 $dt=15
M1353 450 558 VREF_P VSS! nfet_01v8 L=1.5e-07 W=1.5e-06 $X=75590 $Y=112550 $dt=15
M1354 451 560 VREF_P VSS! nfet_01v8 L=1.5e-07 W=1.5e-06 $X=75590 $Y=120830 $dt=15
M1355 452 562 VREF_P VSS! nfet_01v8 L=1.5e-07 W=1.5e-06 $X=75590 $Y=129110 $dt=15
M1356 453 564 VREF_P VSS! nfet_01v8 L=1.5e-07 W=1.5e-06 $X=75590 $Y=137390 $dt=15
M1357 454 566 VREF_P VSS! nfet_01v8 L=1.5e-07 W=1.5e-06 $X=75590 $Y=145670 $dt=15
M1358 455 568 VREF_P VSS! nfet_01v8 L=1.5e-07 W=1.5e-06 $X=75590 $Y=153950 $dt=15
M1359 456 570 VREF_P VSS! nfet_01v8 L=1.5e-07 W=1.5e-06 $X=75590 $Y=162230 $dt=15
M1360 438 514 438 VSS! nfet_01v8 L=1.5e-07 W=1.5e-06 $X=76020 $Y=13190 $dt=15
M1361 439 515 439 VSS! nfet_01v8 L=1.5e-07 W=1.5e-06 $X=76020 $Y=21470 $dt=15
M1362 440 516 440 VSS! nfet_01v8 L=1.5e-07 W=1.5e-06 $X=76020 $Y=29750 $dt=15
M1363 441 517 441 VSS! nfet_01v8 L=1.5e-07 W=1.5e-06 $X=76020 $Y=38030 $dt=15
M1364 442 518 442 VSS! nfet_01v8 L=1.5e-07 W=1.5e-06 $X=76020 $Y=46310 $dt=15
M1365 443 519 443 VSS! nfet_01v8 L=1.5e-07 W=1.5e-06 $X=76020 $Y=54590 $dt=15
M1366 444 520 444 VSS! nfet_01v8 L=1.5e-07 W=1.5e-06 $X=76020 $Y=62870 $dt=15
M1367 445 521 445 VSS! nfet_01v8 L=1.5e-07 W=1.5e-06 $X=76020 $Y=71150 $dt=15
M1368 446 522 446 VSS! nfet_01v8 L=1.5e-07 W=1.5e-06 $X=76020 $Y=79430 $dt=15
M1369 447 523 447 VSS! nfet_01v8 L=1.5e-07 W=1.5e-06 $X=76020 $Y=87710 $dt=15
M1370 448 524 448 VSS! nfet_01v8 L=1.5e-07 W=1.5e-06 $X=76020 $Y=95990 $dt=15
M1371 449 525 449 VSS! nfet_01v8 L=1.5e-07 W=1.5e-06 $X=76020 $Y=104270 $dt=15
M1372 450 526 450 VSS! nfet_01v8 L=1.5e-07 W=1.5e-06 $X=76020 $Y=112550 $dt=15
M1373 451 527 451 VSS! nfet_01v8 L=1.5e-07 W=1.5e-06 $X=76020 $Y=120830 $dt=15
M1374 452 528 452 VSS! nfet_01v8 L=1.5e-07 W=1.5e-06 $X=76020 $Y=129110 $dt=15
M1375 453 529 453 VSS! nfet_01v8 L=1.5e-07 W=1.5e-06 $X=76020 $Y=137390 $dt=15
M1376 454 530 454 VSS! nfet_01v8 L=1.5e-07 W=1.5e-06 $X=76020 $Y=145670 $dt=15
M1377 455 531 455 VSS! nfet_01v8 L=1.5e-07 W=1.5e-06 $X=76020 $Y=153950 $dt=15
M1378 456 532 456 VSS! nfet_01v8 L=1.5e-07 W=1.5e-06 $X=76020 $Y=162230 $dt=15
M1379 438 495 VIN VSS! nfet_01v8 L=1.5e-07 W=1.5e-06 $X=81720 $Y=13190 $dt=15
M1380 439 496 VIN VSS! nfet_01v8 L=1.5e-07 W=1.5e-06 $X=81720 $Y=21470 $dt=15
M1381 440 497 VIN VSS! nfet_01v8 L=1.5e-07 W=1.5e-06 $X=81720 $Y=29750 $dt=15
M1382 441 498 VIN VSS! nfet_01v8 L=1.5e-07 W=1.5e-06 $X=81720 $Y=38030 $dt=15
M1383 442 499 VIN VSS! nfet_01v8 L=1.5e-07 W=1.5e-06 $X=81720 $Y=46310 $dt=15
M1384 443 500 VIN VSS! nfet_01v8 L=1.5e-07 W=1.5e-06 $X=81720 $Y=54590 $dt=15
M1385 444 501 VIN VSS! nfet_01v8 L=1.5e-07 W=1.5e-06 $X=81720 $Y=62870 $dt=15
M1386 445 502 VIN VSS! nfet_01v8 L=1.5e-07 W=1.5e-06 $X=81720 $Y=71150 $dt=15
M1387 446 503 VIN VSS! nfet_01v8 L=1.5e-07 W=1.5e-06 $X=81720 $Y=79430 $dt=15
M1388 447 504 VIN VSS! nfet_01v8 L=1.5e-07 W=1.5e-06 $X=81720 $Y=87710 $dt=15
M1389 448 505 VIN VSS! nfet_01v8 L=1.5e-07 W=1.5e-06 $X=81720 $Y=95990 $dt=15
M1390 449 506 VIN VSS! nfet_01v8 L=1.5e-07 W=1.5e-06 $X=81720 $Y=104270 $dt=15
M1391 450 507 VIN VSS! nfet_01v8 L=1.5e-07 W=1.5e-06 $X=81720 $Y=112550 $dt=15
M1392 451 508 VIN VSS! nfet_01v8 L=1.5e-07 W=1.5e-06 $X=81720 $Y=120830 $dt=15
M1393 452 509 VIN VSS! nfet_01v8 L=1.5e-07 W=1.5e-06 $X=81720 $Y=129110 $dt=15
M1394 453 510 VIN VSS! nfet_01v8 L=1.5e-07 W=1.5e-06 $X=81720 $Y=137390 $dt=15
M1395 454 511 VIN VSS! nfet_01v8 L=1.5e-07 W=1.5e-06 $X=81720 $Y=145670 $dt=15
M1396 455 512 VIN VSS! nfet_01v8 L=1.5e-07 W=1.5e-06 $X=81720 $Y=153950 $dt=15
M1397 456 513 VIN VSS! nfet_01v8 L=1.5e-07 W=1.5e-06 $X=81720 $Y=162230 $dt=15
M1398 VREF_N 458 438 VSS! nfet_01v8 L=1.5e-07 W=1.5e-06 $X=82150 $Y=13190 $dt=15
M1399 VREF_N 460 439 VSS! nfet_01v8 L=1.5e-07 W=1.5e-06 $X=82150 $Y=21470 $dt=15
M1400 VREF_N 462 440 VSS! nfet_01v8 L=1.5e-07 W=1.5e-06 $X=82150 $Y=29750 $dt=15
M1401 VREF_N 464 441 VSS! nfet_01v8 L=1.5e-07 W=1.5e-06 $X=82150 $Y=38030 $dt=15
M1402 VREF_N 466 442 VSS! nfet_01v8 L=1.5e-07 W=1.5e-06 $X=82150 $Y=46310 $dt=15
M1403 VREF_N 468 443 VSS! nfet_01v8 L=1.5e-07 W=1.5e-06 $X=82150 $Y=54590 $dt=15
M1404 VREF_N 470 444 VSS! nfet_01v8 L=1.5e-07 W=1.5e-06 $X=82150 $Y=62870 $dt=15
M1405 VREF_N 472 445 VSS! nfet_01v8 L=1.5e-07 W=1.5e-06 $X=82150 $Y=71150 $dt=15
M1406 VREF_N 474 446 VSS! nfet_01v8 L=1.5e-07 W=1.5e-06 $X=82150 $Y=79430 $dt=15
M1407 VREF_N 476 447 VSS! nfet_01v8 L=1.5e-07 W=1.5e-06 $X=82150 $Y=87710 $dt=15
M1408 VREF_N 478 448 VSS! nfet_01v8 L=1.5e-07 W=1.5e-06 $X=82150 $Y=95990 $dt=15
M1409 VREF_N 480 449 VSS! nfet_01v8 L=1.5e-07 W=1.5e-06 $X=82150 $Y=104270 $dt=15
M1410 VREF_N 482 450 VSS! nfet_01v8 L=1.5e-07 W=1.5e-06 $X=82150 $Y=112550 $dt=15
M1411 VREF_N 484 451 VSS! nfet_01v8 L=1.5e-07 W=1.5e-06 $X=82150 $Y=120830 $dt=15
M1412 VREF_N 486 452 VSS! nfet_01v8 L=1.5e-07 W=1.5e-06 $X=82150 $Y=129110 $dt=15
M1413 VREF_N 488 453 VSS! nfet_01v8 L=1.5e-07 W=1.5e-06 $X=82150 $Y=137390 $dt=15
M1414 VREF_N 490 454 VSS! nfet_01v8 L=1.5e-07 W=1.5e-06 $X=82150 $Y=145670 $dt=15
M1415 VREF_N 492 455 VSS! nfet_01v8 L=1.5e-07 W=1.5e-06 $X=82150 $Y=153950 $dt=15
M1416 VREF_N 494 456 VSS! nfet_01v8 L=1.5e-07 W=1.5e-06 $X=82150 $Y=162230 $dt=15
M1417 419 156 VREF_P VSS! nfet_01v8 L=1.5e-07 W=1.5e-06 $X=83870 $Y=13190 $dt=15
M1418 420 157 VREF_P VSS! nfet_01v8 L=1.5e-07 W=1.5e-06 $X=83870 $Y=21470 $dt=15
M1419 421 158 VREF_P VSS! nfet_01v8 L=1.5e-07 W=1.5e-06 $X=83870 $Y=29750 $dt=15
M1420 422 159 VREF_P VSS! nfet_01v8 L=1.5e-07 W=1.5e-06 $X=83870 $Y=38030 $dt=15
M1421 423 160 VREF_P VSS! nfet_01v8 L=1.5e-07 W=1.5e-06 $X=83870 $Y=46310 $dt=15
M1422 424 161 VREF_P VSS! nfet_01v8 L=1.5e-07 W=1.5e-06 $X=83870 $Y=54590 $dt=15
M1423 425 162 VREF_P VSS! nfet_01v8 L=1.5e-07 W=1.5e-06 $X=83870 $Y=62870 $dt=15
M1424 426 163 VREF_P VSS! nfet_01v8 L=1.5e-07 W=1.5e-06 $X=83870 $Y=71150 $dt=15
M1425 427 164 VREF_P VSS! nfet_01v8 L=1.5e-07 W=1.5e-06 $X=83870 $Y=79430 $dt=15
M1426 428 165 VREF_P VSS! nfet_01v8 L=1.5e-07 W=1.5e-06 $X=83870 $Y=87710 $dt=15
M1427 429 166 VREF_P VSS! nfet_01v8 L=1.5e-07 W=1.5e-06 $X=83870 $Y=95990 $dt=15
M1428 430 167 VREF_P VSS! nfet_01v8 L=1.5e-07 W=1.5e-06 $X=83870 $Y=104270 $dt=15
M1429 431 168 VREF_P VSS! nfet_01v8 L=1.5e-07 W=1.5e-06 $X=83870 $Y=112550 $dt=15
M1430 432 169 VREF_P VSS! nfet_01v8 L=1.5e-07 W=1.5e-06 $X=83870 $Y=120830 $dt=15
M1431 433 170 VREF_P VSS! nfet_01v8 L=1.5e-07 W=1.5e-06 $X=83870 $Y=129110 $dt=15
M1432 434 171 VREF_P VSS! nfet_01v8 L=1.5e-07 W=1.5e-06 $X=83870 $Y=137390 $dt=15
M1433 435 172 VREF_P VSS! nfet_01v8 L=1.5e-07 W=1.5e-06 $X=83870 $Y=145670 $dt=15
M1434 436 173 VREF_P VSS! nfet_01v8 L=1.5e-07 W=1.5e-06 $X=83870 $Y=153950 $dt=15
M1435 437 174 VREF_P VSS! nfet_01v8 L=1.5e-07 W=1.5e-06 $X=83870 $Y=162230 $dt=15
M1436 419 289 419 VSS! nfet_01v8 L=1.5e-07 W=1.5e-06 $X=84300 $Y=13190 $dt=15
M1437 420 290 420 VSS! nfet_01v8 L=1.5e-07 W=1.5e-06 $X=84300 $Y=21470 $dt=15
M1438 421 291 421 VSS! nfet_01v8 L=1.5e-07 W=1.5e-06 $X=84300 $Y=29750 $dt=15
M1439 422 292 422 VSS! nfet_01v8 L=1.5e-07 W=1.5e-06 $X=84300 $Y=38030 $dt=15
M1440 423 293 423 VSS! nfet_01v8 L=1.5e-07 W=1.5e-06 $X=84300 $Y=46310 $dt=15
M1441 424 294 424 VSS! nfet_01v8 L=1.5e-07 W=1.5e-06 $X=84300 $Y=54590 $dt=15
M1442 425 295 425 VSS! nfet_01v8 L=1.5e-07 W=1.5e-06 $X=84300 $Y=62870 $dt=15
M1443 426 296 426 VSS! nfet_01v8 L=1.5e-07 W=1.5e-06 $X=84300 $Y=71150 $dt=15
M1444 427 297 427 VSS! nfet_01v8 L=1.5e-07 W=1.5e-06 $X=84300 $Y=79430 $dt=15
M1445 428 298 428 VSS! nfet_01v8 L=1.5e-07 W=1.5e-06 $X=84300 $Y=87710 $dt=15
M1446 429 299 429 VSS! nfet_01v8 L=1.5e-07 W=1.5e-06 $X=84300 $Y=95990 $dt=15
M1447 430 300 430 VSS! nfet_01v8 L=1.5e-07 W=1.5e-06 $X=84300 $Y=104270 $dt=15
M1448 431 301 431 VSS! nfet_01v8 L=1.5e-07 W=1.5e-06 $X=84300 $Y=112550 $dt=15
M1449 432 302 432 VSS! nfet_01v8 L=1.5e-07 W=1.5e-06 $X=84300 $Y=120830 $dt=15
M1450 433 303 433 VSS! nfet_01v8 L=1.5e-07 W=1.5e-06 $X=84300 $Y=129110 $dt=15
M1451 434 304 434 VSS! nfet_01v8 L=1.5e-07 W=1.5e-06 $X=84300 $Y=137390 $dt=15
M1452 435 305 435 VSS! nfet_01v8 L=1.5e-07 W=1.5e-06 $X=84300 $Y=145670 $dt=15
M1453 436 306 436 VSS! nfet_01v8 L=1.5e-07 W=1.5e-06 $X=84300 $Y=153950 $dt=15
M1454 437 307 437 VSS! nfet_01v8 L=1.5e-07 W=1.5e-06 $X=84300 $Y=162230 $dt=15
M1455 419 270 VIN VSS! nfet_01v8 L=1.5e-07 W=1.5e-06 $X=90000 $Y=13190 $dt=15
M1456 420 271 VIN VSS! nfet_01v8 L=1.5e-07 W=1.5e-06 $X=90000 $Y=21470 $dt=15
M1457 421 272 VIN VSS! nfet_01v8 L=1.5e-07 W=1.5e-06 $X=90000 $Y=29750 $dt=15
M1458 422 273 VIN VSS! nfet_01v8 L=1.5e-07 W=1.5e-06 $X=90000 $Y=38030 $dt=15
M1459 423 274 VIN VSS! nfet_01v8 L=1.5e-07 W=1.5e-06 $X=90000 $Y=46310 $dt=15
M1460 424 275 VIN VSS! nfet_01v8 L=1.5e-07 W=1.5e-06 $X=90000 $Y=54590 $dt=15
M1461 425 276 VIN VSS! nfet_01v8 L=1.5e-07 W=1.5e-06 $X=90000 $Y=62870 $dt=15
M1462 426 277 VIN VSS! nfet_01v8 L=1.5e-07 W=1.5e-06 $X=90000 $Y=71150 $dt=15
M1463 427 278 VIN VSS! nfet_01v8 L=1.5e-07 W=1.5e-06 $X=90000 $Y=79430 $dt=15
M1464 428 279 VIN VSS! nfet_01v8 L=1.5e-07 W=1.5e-06 $X=90000 $Y=87710 $dt=15
M1465 429 280 VIN VSS! nfet_01v8 L=1.5e-07 W=1.5e-06 $X=90000 $Y=95990 $dt=15
M1466 430 281 VIN VSS! nfet_01v8 L=1.5e-07 W=1.5e-06 $X=90000 $Y=104270 $dt=15
M1467 431 282 VIN VSS! nfet_01v8 L=1.5e-07 W=1.5e-06 $X=90000 $Y=112550 $dt=15
M1468 432 283 VIN VSS! nfet_01v8 L=1.5e-07 W=1.5e-06 $X=90000 $Y=120830 $dt=15
M1469 433 284 VIN VSS! nfet_01v8 L=1.5e-07 W=1.5e-06 $X=90000 $Y=129110 $dt=15
M1470 434 285 VIN VSS! nfet_01v8 L=1.5e-07 W=1.5e-06 $X=90000 $Y=137390 $dt=15
M1471 435 286 VIN VSS! nfet_01v8 L=1.5e-07 W=1.5e-06 $X=90000 $Y=145670 $dt=15
M1472 436 287 VIN VSS! nfet_01v8 L=1.5e-07 W=1.5e-06 $X=90000 $Y=153950 $dt=15
M1473 437 288 VIN VSS! nfet_01v8 L=1.5e-07 W=1.5e-06 $X=90000 $Y=162230 $dt=15
M1474 VREF_N 232 419 VSS! nfet_01v8 L=1.5e-07 W=1.5e-06 $X=90430 $Y=13190 $dt=15
M1475 VREF_N 233 420 VSS! nfet_01v8 L=1.5e-07 W=1.5e-06 $X=90430 $Y=21470 $dt=15
M1476 VREF_N 234 421 VSS! nfet_01v8 L=1.5e-07 W=1.5e-06 $X=90430 $Y=29750 $dt=15
M1477 VREF_N 235 422 VSS! nfet_01v8 L=1.5e-07 W=1.5e-06 $X=90430 $Y=38030 $dt=15
M1478 VREF_N 236 423 VSS! nfet_01v8 L=1.5e-07 W=1.5e-06 $X=90430 $Y=46310 $dt=15
M1479 VREF_N 237 424 VSS! nfet_01v8 L=1.5e-07 W=1.5e-06 $X=90430 $Y=54590 $dt=15
M1480 VREF_N 238 425 VSS! nfet_01v8 L=1.5e-07 W=1.5e-06 $X=90430 $Y=62870 $dt=15
M1481 VREF_N 239 426 VSS! nfet_01v8 L=1.5e-07 W=1.5e-06 $X=90430 $Y=71150 $dt=15
M1482 VREF_N 240 427 VSS! nfet_01v8 L=1.5e-07 W=1.5e-06 $X=90430 $Y=79430 $dt=15
M1483 VREF_N 241 428 VSS! nfet_01v8 L=1.5e-07 W=1.5e-06 $X=90430 $Y=87710 $dt=15
M1484 VREF_N 242 429 VSS! nfet_01v8 L=1.5e-07 W=1.5e-06 $X=90430 $Y=95990 $dt=15
M1485 VREF_N 243 430 VSS! nfet_01v8 L=1.5e-07 W=1.5e-06 $X=90430 $Y=104270 $dt=15
M1486 VREF_N 244 431 VSS! nfet_01v8 L=1.5e-07 W=1.5e-06 $X=90430 $Y=112550 $dt=15
M1487 VREF_N 245 432 VSS! nfet_01v8 L=1.5e-07 W=1.5e-06 $X=90430 $Y=120830 $dt=15
M1488 VREF_N 246 433 VSS! nfet_01v8 L=1.5e-07 W=1.5e-06 $X=90430 $Y=129110 $dt=15
M1489 VREF_N 247 434 VSS! nfet_01v8 L=1.5e-07 W=1.5e-06 $X=90430 $Y=137390 $dt=15
M1490 VREF_N 248 435 VSS! nfet_01v8 L=1.5e-07 W=1.5e-06 $X=90430 $Y=145670 $dt=15
M1491 VREF_N 249 436 VSS! nfet_01v8 L=1.5e-07 W=1.5e-06 $X=90430 $Y=153950 $dt=15
M1492 VREF_N 250 437 VSS! nfet_01v8 L=1.5e-07 W=1.5e-06 $X=90430 $Y=162230 $dt=15
M1493 401 156 VREF_P VSS! nfet_01v8 L=1.5e-07 W=1.5e-06 $X=92150 $Y=13190 $dt=15
M1494 402 157 VREF_P VSS! nfet_01v8 L=1.5e-07 W=1.5e-06 $X=92150 $Y=21470 $dt=15
M1495 403 158 VREF_P VSS! nfet_01v8 L=1.5e-07 W=1.5e-06 $X=92150 $Y=29750 $dt=15
M1496 404 159 VREF_P VSS! nfet_01v8 L=1.5e-07 W=1.5e-06 $X=92150 $Y=38030 $dt=15
M1497 405 160 VREF_P VSS! nfet_01v8 L=1.5e-07 W=1.5e-06 $X=92150 $Y=46310 $dt=15
M1498 406 161 VREF_P VSS! nfet_01v8 L=1.5e-07 W=1.5e-06 $X=92150 $Y=54590 $dt=15
M1499 407 162 VREF_P VSS! nfet_01v8 L=1.5e-07 W=1.5e-06 $X=92150 $Y=62870 $dt=15
M1500 408 163 VREF_P VSS! nfet_01v8 L=1.5e-07 W=1.5e-06 $X=92150 $Y=71150 $dt=15
M1501 409 164 VREF_P VSS! nfet_01v8 L=1.5e-07 W=1.5e-06 $X=92150 $Y=79430 $dt=15
M1502 VSS! VDD! VSS! VSS! nfet_01v8 L=5.8e-07 W=1.5e-06 $X=92150 $Y=87710 $dt=15
M1503 410 166 VREF_P VSS! nfet_01v8 L=1.5e-07 W=1.5e-06 $X=92150 $Y=95990 $dt=15
M1504 411 167 VREF_P VSS! nfet_01v8 L=1.5e-07 W=1.5e-06 $X=92150 $Y=104270 $dt=15
M1505 412 168 VREF_P VSS! nfet_01v8 L=1.5e-07 W=1.5e-06 $X=92150 $Y=112550 $dt=15
M1506 413 169 VREF_P VSS! nfet_01v8 L=1.5e-07 W=1.5e-06 $X=92150 $Y=120830 $dt=15
M1507 414 170 VREF_P VSS! nfet_01v8 L=1.5e-07 W=1.5e-06 $X=92150 $Y=129110 $dt=15
M1508 415 171 VREF_P VSS! nfet_01v8 L=1.5e-07 W=1.5e-06 $X=92150 $Y=137390 $dt=15
M1509 416 172 VREF_P VSS! nfet_01v8 L=1.5e-07 W=1.5e-06 $X=92150 $Y=145670 $dt=15
M1510 417 173 VREF_P VSS! nfet_01v8 L=1.5e-07 W=1.5e-06 $X=92150 $Y=153950 $dt=15
M1511 418 174 VREF_P VSS! nfet_01v8 L=1.5e-07 W=1.5e-06 $X=92150 $Y=162230 $dt=15
M1512 401 289 401 VSS! nfet_01v8 L=1.5e-07 W=1.5e-06 $X=92580 $Y=13190 $dt=15
M1513 402 290 402 VSS! nfet_01v8 L=1.5e-07 W=1.5e-06 $X=92580 $Y=21470 $dt=15
M1514 403 291 403 VSS! nfet_01v8 L=1.5e-07 W=1.5e-06 $X=92580 $Y=29750 $dt=15
M1515 404 292 404 VSS! nfet_01v8 L=1.5e-07 W=1.5e-06 $X=92580 $Y=38030 $dt=15
M1516 405 293 405 VSS! nfet_01v8 L=1.5e-07 W=1.5e-06 $X=92580 $Y=46310 $dt=15
M1517 406 294 406 VSS! nfet_01v8 L=1.5e-07 W=1.5e-06 $X=92580 $Y=54590 $dt=15
M1518 407 295 407 VSS! nfet_01v8 L=1.5e-07 W=1.5e-06 $X=92580 $Y=62870 $dt=15
M1519 408 296 408 VSS! nfet_01v8 L=1.5e-07 W=1.5e-06 $X=92580 $Y=71150 $dt=15
M1520 409 297 409 VSS! nfet_01v8 L=1.5e-07 W=1.5e-06 $X=92580 $Y=79430 $dt=15
M1521 410 299 410 VSS! nfet_01v8 L=1.5e-07 W=1.5e-06 $X=92580 $Y=95990 $dt=15
M1522 411 300 411 VSS! nfet_01v8 L=1.5e-07 W=1.5e-06 $X=92580 $Y=104270 $dt=15
M1523 412 301 412 VSS! nfet_01v8 L=1.5e-07 W=1.5e-06 $X=92580 $Y=112550 $dt=15
M1524 413 302 413 VSS! nfet_01v8 L=1.5e-07 W=1.5e-06 $X=92580 $Y=120830 $dt=15
M1525 414 303 414 VSS! nfet_01v8 L=1.5e-07 W=1.5e-06 $X=92580 $Y=129110 $dt=15
M1526 415 304 415 VSS! nfet_01v8 L=1.5e-07 W=1.5e-06 $X=92580 $Y=137390 $dt=15
M1527 416 305 416 VSS! nfet_01v8 L=1.5e-07 W=1.5e-06 $X=92580 $Y=145670 $dt=15
M1528 417 306 417 VSS! nfet_01v8 L=1.5e-07 W=1.5e-06 $X=92580 $Y=153950 $dt=15
M1529 418 307 418 VSS! nfet_01v8 L=1.5e-07 W=1.5e-06 $X=92580 $Y=162230 $dt=15
M1530 VSS! VDD! VSS! VSS! nfet_01v8 L=5.8e-07 W=1.5e-06 $X=98270 $Y=87710 $dt=15
M1531 401 270 VIN VSS! nfet_01v8 L=1.5e-07 W=1.5e-06 $X=98280 $Y=13190 $dt=15
M1532 402 271 VIN VSS! nfet_01v8 L=1.5e-07 W=1.5e-06 $X=98280 $Y=21470 $dt=15
M1533 403 272 VIN VSS! nfet_01v8 L=1.5e-07 W=1.5e-06 $X=98280 $Y=29750 $dt=15
M1534 404 273 VIN VSS! nfet_01v8 L=1.5e-07 W=1.5e-06 $X=98280 $Y=38030 $dt=15
M1535 405 274 VIN VSS! nfet_01v8 L=1.5e-07 W=1.5e-06 $X=98280 $Y=46310 $dt=15
M1536 406 275 VIN VSS! nfet_01v8 L=1.5e-07 W=1.5e-06 $X=98280 $Y=54590 $dt=15
M1537 407 276 VIN VSS! nfet_01v8 L=1.5e-07 W=1.5e-06 $X=98280 $Y=62870 $dt=15
M1538 408 277 VIN VSS! nfet_01v8 L=1.5e-07 W=1.5e-06 $X=98280 $Y=71150 $dt=15
M1539 409 278 VIN VSS! nfet_01v8 L=1.5e-07 W=1.5e-06 $X=98280 $Y=79430 $dt=15
M1540 410 280 VIN VSS! nfet_01v8 L=1.5e-07 W=1.5e-06 $X=98280 $Y=95990 $dt=15
M1541 411 281 VIN VSS! nfet_01v8 L=1.5e-07 W=1.5e-06 $X=98280 $Y=104270 $dt=15
M1542 412 282 VIN VSS! nfet_01v8 L=1.5e-07 W=1.5e-06 $X=98280 $Y=112550 $dt=15
M1543 413 283 VIN VSS! nfet_01v8 L=1.5e-07 W=1.5e-06 $X=98280 $Y=120830 $dt=15
M1544 414 284 VIN VSS! nfet_01v8 L=1.5e-07 W=1.5e-06 $X=98280 $Y=129110 $dt=15
M1545 415 285 VIN VSS! nfet_01v8 L=1.5e-07 W=1.5e-06 $X=98280 $Y=137390 $dt=15
M1546 416 286 VIN VSS! nfet_01v8 L=1.5e-07 W=1.5e-06 $X=98280 $Y=145670 $dt=15
M1547 417 287 VIN VSS! nfet_01v8 L=1.5e-07 W=1.5e-06 $X=98280 $Y=153950 $dt=15
M1548 418 288 VIN VSS! nfet_01v8 L=1.5e-07 W=1.5e-06 $X=98280 $Y=162230 $dt=15
M1549 VREF_N 232 401 VSS! nfet_01v8 L=1.5e-07 W=1.5e-06 $X=98710 $Y=13190 $dt=15
M1550 VREF_N 233 402 VSS! nfet_01v8 L=1.5e-07 W=1.5e-06 $X=98710 $Y=21470 $dt=15
M1551 VREF_N 234 403 VSS! nfet_01v8 L=1.5e-07 W=1.5e-06 $X=98710 $Y=29750 $dt=15
M1552 VREF_N 235 404 VSS! nfet_01v8 L=1.5e-07 W=1.5e-06 $X=98710 $Y=38030 $dt=15
M1553 VREF_N 236 405 VSS! nfet_01v8 L=1.5e-07 W=1.5e-06 $X=98710 $Y=46310 $dt=15
M1554 VREF_N 237 406 VSS! nfet_01v8 L=1.5e-07 W=1.5e-06 $X=98710 $Y=54590 $dt=15
M1555 VREF_N 238 407 VSS! nfet_01v8 L=1.5e-07 W=1.5e-06 $X=98710 $Y=62870 $dt=15
M1556 VREF_N 239 408 VSS! nfet_01v8 L=1.5e-07 W=1.5e-06 $X=98710 $Y=71150 $dt=15
M1557 VREF_N 240 409 VSS! nfet_01v8 L=1.5e-07 W=1.5e-06 $X=98710 $Y=79430 $dt=15
M1558 VREF_N 242 410 VSS! nfet_01v8 L=1.5e-07 W=1.5e-06 $X=98710 $Y=95990 $dt=15
M1559 VREF_N 243 411 VSS! nfet_01v8 L=1.5e-07 W=1.5e-06 $X=98710 $Y=104270 $dt=15
M1560 VREF_N 244 412 VSS! nfet_01v8 L=1.5e-07 W=1.5e-06 $X=98710 $Y=112550 $dt=15
M1561 VREF_N 245 413 VSS! nfet_01v8 L=1.5e-07 W=1.5e-06 $X=98710 $Y=120830 $dt=15
M1562 VREF_N 246 414 VSS! nfet_01v8 L=1.5e-07 W=1.5e-06 $X=98710 $Y=129110 $dt=15
M1563 VREF_N 247 415 VSS! nfet_01v8 L=1.5e-07 W=1.5e-06 $X=98710 $Y=137390 $dt=15
M1564 VREF_N 248 416 VSS! nfet_01v8 L=1.5e-07 W=1.5e-06 $X=98710 $Y=145670 $dt=15
M1565 VREF_N 249 417 VSS! nfet_01v8 L=1.5e-07 W=1.5e-06 $X=98710 $Y=153950 $dt=15
M1566 VREF_N 250 418 VSS! nfet_01v8 L=1.5e-07 W=1.5e-06 $X=98710 $Y=162230 $dt=15
M1567 384 156 VREF_P VSS! nfet_01v8 L=1.5e-07 W=1.5e-06 $X=100430 $Y=13190 $dt=15
M1568 385 157 VREF_P VSS! nfet_01v8 L=1.5e-07 W=1.5e-06 $X=100430 $Y=21470 $dt=15
M1569 386 158 VREF_P VSS! nfet_01v8 L=1.5e-07 W=1.5e-06 $X=100430 $Y=29750 $dt=15
M1570 387 159 VREF_P VSS! nfet_01v8 L=1.5e-07 W=1.5e-06 $X=100430 $Y=38030 $dt=15
M1571 388 160 VREF_P VSS! nfet_01v8 L=1.5e-07 W=1.5e-06 $X=100430 $Y=46310 $dt=15
M1572 389 161 VREF_P VSS! nfet_01v8 L=1.5e-07 W=1.5e-06 $X=100430 $Y=54590 $dt=15
M1573 390 162 VREF_P VSS! nfet_01v8 L=1.5e-07 W=1.5e-06 $X=100430 $Y=62870 $dt=15
M1574 391 163 VREF_P VSS! nfet_01v8 L=1.5e-07 W=1.5e-06 $X=100430 $Y=71150 $dt=15
M1575 392 164 VREF_P VSS! nfet_01v8 L=1.5e-07 W=1.5e-06 $X=100430 $Y=79430 $dt=15
M1576 VSS! VDD! VSS! VSS! nfet_01v8 L=5.8e-07 W=1.5e-06 $X=100430 $Y=87710 $dt=15
M1577 VSS! VDD! VSS! VSS! nfet_01v8 L=5.8e-07 W=1.5e-06 $X=100430 $Y=95990 $dt=15
M1578 393 167 VREF_P VSS! nfet_01v8 L=1.5e-07 W=1.5e-06 $X=100430 $Y=104270 $dt=15
M1579 394 168 VREF_P VSS! nfet_01v8 L=1.5e-07 W=1.5e-06 $X=100430 $Y=112550 $dt=15
M1580 395 169 VREF_P VSS! nfet_01v8 L=1.5e-07 W=1.5e-06 $X=100430 $Y=120830 $dt=15
M1581 396 170 VREF_P VSS! nfet_01v8 L=1.5e-07 W=1.5e-06 $X=100430 $Y=129110 $dt=15
M1582 397 171 VREF_P VSS! nfet_01v8 L=1.5e-07 W=1.5e-06 $X=100430 $Y=137390 $dt=15
M1583 398 172 VREF_P VSS! nfet_01v8 L=1.5e-07 W=1.5e-06 $X=100430 $Y=145670 $dt=15
M1584 399 173 VREF_P VSS! nfet_01v8 L=1.5e-07 W=1.5e-06 $X=100430 $Y=153950 $dt=15
M1585 400 174 VREF_P VSS! nfet_01v8 L=1.5e-07 W=1.5e-06 $X=100430 $Y=162230 $dt=15
M1586 384 289 384 VSS! nfet_01v8 L=1.5e-07 W=1.5e-06 $X=100860 $Y=13190 $dt=15
M1587 385 290 385 VSS! nfet_01v8 L=1.5e-07 W=1.5e-06 $X=100860 $Y=21470 $dt=15
M1588 386 291 386 VSS! nfet_01v8 L=1.5e-07 W=1.5e-06 $X=100860 $Y=29750 $dt=15
M1589 387 292 387 VSS! nfet_01v8 L=1.5e-07 W=1.5e-06 $X=100860 $Y=38030 $dt=15
M1590 388 293 388 VSS! nfet_01v8 L=1.5e-07 W=1.5e-06 $X=100860 $Y=46310 $dt=15
M1591 389 294 389 VSS! nfet_01v8 L=1.5e-07 W=1.5e-06 $X=100860 $Y=54590 $dt=15
M1592 390 295 390 VSS! nfet_01v8 L=1.5e-07 W=1.5e-06 $X=100860 $Y=62870 $dt=15
M1593 391 296 391 VSS! nfet_01v8 L=1.5e-07 W=1.5e-06 $X=100860 $Y=71150 $dt=15
M1594 392 297 392 VSS! nfet_01v8 L=1.5e-07 W=1.5e-06 $X=100860 $Y=79430 $dt=15
M1595 393 300 393 VSS! nfet_01v8 L=1.5e-07 W=1.5e-06 $X=100860 $Y=104270 $dt=15
M1596 394 301 394 VSS! nfet_01v8 L=1.5e-07 W=1.5e-06 $X=100860 $Y=112550 $dt=15
M1597 395 302 395 VSS! nfet_01v8 L=1.5e-07 W=1.5e-06 $X=100860 $Y=120830 $dt=15
M1598 396 303 396 VSS! nfet_01v8 L=1.5e-07 W=1.5e-06 $X=100860 $Y=129110 $dt=15
M1599 397 304 397 VSS! nfet_01v8 L=1.5e-07 W=1.5e-06 $X=100860 $Y=137390 $dt=15
M1600 398 305 398 VSS! nfet_01v8 L=1.5e-07 W=1.5e-06 $X=100860 $Y=145670 $dt=15
M1601 399 306 399 VSS! nfet_01v8 L=1.5e-07 W=1.5e-06 $X=100860 $Y=153950 $dt=15
M1602 400 307 400 VSS! nfet_01v8 L=1.5e-07 W=1.5e-06 $X=100860 $Y=162230 $dt=15
M1603 VSS! VDD! VSS! VSS! nfet_01v8 L=5.8e-07 W=1.5e-06 $X=106550 $Y=87710 $dt=15
M1604 VSS! VDD! VSS! VSS! nfet_01v8 L=5.8e-07 W=1.5e-06 $X=106550 $Y=95990 $dt=15
M1605 384 270 VIN VSS! nfet_01v8 L=1.5e-07 W=1.5e-06 $X=106560 $Y=13190 $dt=15
M1606 385 271 VIN VSS! nfet_01v8 L=1.5e-07 W=1.5e-06 $X=106560 $Y=21470 $dt=15
M1607 386 272 VIN VSS! nfet_01v8 L=1.5e-07 W=1.5e-06 $X=106560 $Y=29750 $dt=15
M1608 387 273 VIN VSS! nfet_01v8 L=1.5e-07 W=1.5e-06 $X=106560 $Y=38030 $dt=15
M1609 388 274 VIN VSS! nfet_01v8 L=1.5e-07 W=1.5e-06 $X=106560 $Y=46310 $dt=15
M1610 389 275 VIN VSS! nfet_01v8 L=1.5e-07 W=1.5e-06 $X=106560 $Y=54590 $dt=15
M1611 390 276 VIN VSS! nfet_01v8 L=1.5e-07 W=1.5e-06 $X=106560 $Y=62870 $dt=15
M1612 391 277 VIN VSS! nfet_01v8 L=1.5e-07 W=1.5e-06 $X=106560 $Y=71150 $dt=15
M1613 392 278 VIN VSS! nfet_01v8 L=1.5e-07 W=1.5e-06 $X=106560 $Y=79430 $dt=15
M1614 393 281 VIN VSS! nfet_01v8 L=1.5e-07 W=1.5e-06 $X=106560 $Y=104270 $dt=15
M1615 394 282 VIN VSS! nfet_01v8 L=1.5e-07 W=1.5e-06 $X=106560 $Y=112550 $dt=15
M1616 395 283 VIN VSS! nfet_01v8 L=1.5e-07 W=1.5e-06 $X=106560 $Y=120830 $dt=15
M1617 396 284 VIN VSS! nfet_01v8 L=1.5e-07 W=1.5e-06 $X=106560 $Y=129110 $dt=15
M1618 397 285 VIN VSS! nfet_01v8 L=1.5e-07 W=1.5e-06 $X=106560 $Y=137390 $dt=15
M1619 398 286 VIN VSS! nfet_01v8 L=1.5e-07 W=1.5e-06 $X=106560 $Y=145670 $dt=15
M1620 399 287 VIN VSS! nfet_01v8 L=1.5e-07 W=1.5e-06 $X=106560 $Y=153950 $dt=15
M1621 400 288 VIN VSS! nfet_01v8 L=1.5e-07 W=1.5e-06 $X=106560 $Y=162230 $dt=15
M1622 VREF_N 232 384 VSS! nfet_01v8 L=1.5e-07 W=1.5e-06 $X=106990 $Y=13190 $dt=15
M1623 VREF_N 233 385 VSS! nfet_01v8 L=1.5e-07 W=1.5e-06 $X=106990 $Y=21470 $dt=15
M1624 VREF_N 234 386 VSS! nfet_01v8 L=1.5e-07 W=1.5e-06 $X=106990 $Y=29750 $dt=15
M1625 VREF_N 235 387 VSS! nfet_01v8 L=1.5e-07 W=1.5e-06 $X=106990 $Y=38030 $dt=15
M1626 VREF_N 236 388 VSS! nfet_01v8 L=1.5e-07 W=1.5e-06 $X=106990 $Y=46310 $dt=15
M1627 VREF_N 237 389 VSS! nfet_01v8 L=1.5e-07 W=1.5e-06 $X=106990 $Y=54590 $dt=15
M1628 VREF_N 238 390 VSS! nfet_01v8 L=1.5e-07 W=1.5e-06 $X=106990 $Y=62870 $dt=15
M1629 VREF_N 239 391 VSS! nfet_01v8 L=1.5e-07 W=1.5e-06 $X=106990 $Y=71150 $dt=15
M1630 VREF_N 240 392 VSS! nfet_01v8 L=1.5e-07 W=1.5e-06 $X=106990 $Y=79430 $dt=15
M1631 VREF_N 243 393 VSS! nfet_01v8 L=1.5e-07 W=1.5e-06 $X=106990 $Y=104270 $dt=15
M1632 VREF_N 244 394 VSS! nfet_01v8 L=1.5e-07 W=1.5e-06 $X=106990 $Y=112550 $dt=15
M1633 VREF_N 245 395 VSS! nfet_01v8 L=1.5e-07 W=1.5e-06 $X=106990 $Y=120830 $dt=15
M1634 VREF_N 246 396 VSS! nfet_01v8 L=1.5e-07 W=1.5e-06 $X=106990 $Y=129110 $dt=15
M1635 VREF_N 247 397 VSS! nfet_01v8 L=1.5e-07 W=1.5e-06 $X=106990 $Y=137390 $dt=15
M1636 VREF_N 248 398 VSS! nfet_01v8 L=1.5e-07 W=1.5e-06 $X=106990 $Y=145670 $dt=15
M1637 VREF_N 249 399 VSS! nfet_01v8 L=1.5e-07 W=1.5e-06 $X=106990 $Y=153950 $dt=15
M1638 VREF_N 250 400 VSS! nfet_01v8 L=1.5e-07 W=1.5e-06 $X=106990 $Y=162230 $dt=15
M1639 367 156 VREF_P VSS! nfet_01v8 L=1.5e-07 W=1.5e-06 $X=108710 $Y=13190 $dt=15
M1640 368 157 VREF_P VSS! nfet_01v8 L=1.5e-07 W=1.5e-06 $X=108710 $Y=21470 $dt=15
M1641 369 158 VREF_P VSS! nfet_01v8 L=1.5e-07 W=1.5e-06 $X=108710 $Y=29750 $dt=15
M1642 370 159 VREF_P VSS! nfet_01v8 L=1.5e-07 W=1.5e-06 $X=108710 $Y=38030 $dt=15
M1643 371 160 VREF_P VSS! nfet_01v8 L=1.5e-07 W=1.5e-06 $X=108710 $Y=46310 $dt=15
M1644 372 161 VREF_P VSS! nfet_01v8 L=1.5e-07 W=1.5e-06 $X=108710 $Y=54590 $dt=15
M1645 373 162 VREF_P VSS! nfet_01v8 L=1.5e-07 W=1.5e-06 $X=108710 $Y=62870 $dt=15
M1646 374 163 VREF_P VSS! nfet_01v8 L=1.5e-07 W=1.5e-06 $X=108710 $Y=71150 $dt=15
M1647 375 164 VREF_P VSS! nfet_01v8 L=1.5e-07 W=1.5e-06 $X=108710 $Y=79430 $dt=15
M1648 VSS! VDD! VSS! VSS! nfet_01v8 L=5.8e-07 W=1.5e-06 $X=108710 $Y=87710 $dt=15
M1649 VSS! VDD! VSS! VSS! nfet_01v8 L=5.8e-07 W=1.5e-06 $X=108710 $Y=95990 $dt=15
M1650 376 167 VREF_P VSS! nfet_01v8 L=1.5e-07 W=1.5e-06 $X=108710 $Y=104270 $dt=15
M1651 377 168 VREF_P VSS! nfet_01v8 L=1.5e-07 W=1.5e-06 $X=108710 $Y=112550 $dt=15
M1652 378 169 VREF_P VSS! nfet_01v8 L=1.5e-07 W=1.5e-06 $X=108710 $Y=120830 $dt=15
M1653 379 170 VREF_P VSS! nfet_01v8 L=1.5e-07 W=1.5e-06 $X=108710 $Y=129110 $dt=15
M1654 380 171 VREF_P VSS! nfet_01v8 L=1.5e-07 W=1.5e-06 $X=108710 $Y=137390 $dt=15
M1655 381 172 VREF_P VSS! nfet_01v8 L=1.5e-07 W=1.5e-06 $X=108710 $Y=145670 $dt=15
M1656 382 173 VREF_P VSS! nfet_01v8 L=1.5e-07 W=1.5e-06 $X=108710 $Y=153950 $dt=15
M1657 383 174 VREF_P VSS! nfet_01v8 L=1.5e-07 W=1.5e-06 $X=108710 $Y=162230 $dt=15
M1658 367 289 367 VSS! nfet_01v8 L=1.5e-07 W=1.5e-06 $X=109140 $Y=13190 $dt=15
M1659 368 290 368 VSS! nfet_01v8 L=1.5e-07 W=1.5e-06 $X=109140 $Y=21470 $dt=15
M1660 369 291 369 VSS! nfet_01v8 L=1.5e-07 W=1.5e-06 $X=109140 $Y=29750 $dt=15
M1661 370 292 370 VSS! nfet_01v8 L=1.5e-07 W=1.5e-06 $X=109140 $Y=38030 $dt=15
M1662 371 293 371 VSS! nfet_01v8 L=1.5e-07 W=1.5e-06 $X=109140 $Y=46310 $dt=15
M1663 372 294 372 VSS! nfet_01v8 L=1.5e-07 W=1.5e-06 $X=109140 $Y=54590 $dt=15
M1664 373 295 373 VSS! nfet_01v8 L=1.5e-07 W=1.5e-06 $X=109140 $Y=62870 $dt=15
M1665 374 296 374 VSS! nfet_01v8 L=1.5e-07 W=1.5e-06 $X=109140 $Y=71150 $dt=15
M1666 375 297 375 VSS! nfet_01v8 L=1.5e-07 W=1.5e-06 $X=109140 $Y=79430 $dt=15
M1667 376 300 376 VSS! nfet_01v8 L=1.5e-07 W=1.5e-06 $X=109140 $Y=104270 $dt=15
M1668 377 301 377 VSS! nfet_01v8 L=1.5e-07 W=1.5e-06 $X=109140 $Y=112550 $dt=15
M1669 378 302 378 VSS! nfet_01v8 L=1.5e-07 W=1.5e-06 $X=109140 $Y=120830 $dt=15
M1670 379 303 379 VSS! nfet_01v8 L=1.5e-07 W=1.5e-06 $X=109140 $Y=129110 $dt=15
M1671 380 304 380 VSS! nfet_01v8 L=1.5e-07 W=1.5e-06 $X=109140 $Y=137390 $dt=15
M1672 381 305 381 VSS! nfet_01v8 L=1.5e-07 W=1.5e-06 $X=109140 $Y=145670 $dt=15
M1673 382 306 382 VSS! nfet_01v8 L=1.5e-07 W=1.5e-06 $X=109140 $Y=153950 $dt=15
M1674 383 307 383 VSS! nfet_01v8 L=1.5e-07 W=1.5e-06 $X=109140 $Y=162230 $dt=15
M1675 VSS! VDD! VSS! VSS! nfet_01v8 L=5.8e-07 W=1.5e-06 $X=114830 $Y=87710 $dt=15
M1676 VSS! VDD! VSS! VSS! nfet_01v8 L=5.8e-07 W=1.5e-06 $X=114830 $Y=95990 $dt=15
M1677 367 270 VIN VSS! nfet_01v8 L=1.5e-07 W=1.5e-06 $X=114840 $Y=13190 $dt=15
M1678 368 271 VIN VSS! nfet_01v8 L=1.5e-07 W=1.5e-06 $X=114840 $Y=21470 $dt=15
M1679 369 272 VIN VSS! nfet_01v8 L=1.5e-07 W=1.5e-06 $X=114840 $Y=29750 $dt=15
M1680 370 273 VIN VSS! nfet_01v8 L=1.5e-07 W=1.5e-06 $X=114840 $Y=38030 $dt=15
M1681 371 274 VIN VSS! nfet_01v8 L=1.5e-07 W=1.5e-06 $X=114840 $Y=46310 $dt=15
M1682 372 275 VIN VSS! nfet_01v8 L=1.5e-07 W=1.5e-06 $X=114840 $Y=54590 $dt=15
M1683 373 276 VIN VSS! nfet_01v8 L=1.5e-07 W=1.5e-06 $X=114840 $Y=62870 $dt=15
M1684 374 277 VIN VSS! nfet_01v8 L=1.5e-07 W=1.5e-06 $X=114840 $Y=71150 $dt=15
M1685 375 278 VIN VSS! nfet_01v8 L=1.5e-07 W=1.5e-06 $X=114840 $Y=79430 $dt=15
M1686 376 281 VIN VSS! nfet_01v8 L=1.5e-07 W=1.5e-06 $X=114840 $Y=104270 $dt=15
M1687 377 282 VIN VSS! nfet_01v8 L=1.5e-07 W=1.5e-06 $X=114840 $Y=112550 $dt=15
M1688 378 283 VIN VSS! nfet_01v8 L=1.5e-07 W=1.5e-06 $X=114840 $Y=120830 $dt=15
M1689 379 284 VIN VSS! nfet_01v8 L=1.5e-07 W=1.5e-06 $X=114840 $Y=129110 $dt=15
M1690 380 285 VIN VSS! nfet_01v8 L=1.5e-07 W=1.5e-06 $X=114840 $Y=137390 $dt=15
M1691 381 286 VIN VSS! nfet_01v8 L=1.5e-07 W=1.5e-06 $X=114840 $Y=145670 $dt=15
M1692 382 287 VIN VSS! nfet_01v8 L=1.5e-07 W=1.5e-06 $X=114840 $Y=153950 $dt=15
M1693 383 288 VIN VSS! nfet_01v8 L=1.5e-07 W=1.5e-06 $X=114840 $Y=162230 $dt=15
M1694 VREF_N 232 367 VSS! nfet_01v8 L=1.5e-07 W=1.5e-06 $X=115270 $Y=13190 $dt=15
M1695 VREF_N 233 368 VSS! nfet_01v8 L=1.5e-07 W=1.5e-06 $X=115270 $Y=21470 $dt=15
M1696 VREF_N 234 369 VSS! nfet_01v8 L=1.5e-07 W=1.5e-06 $X=115270 $Y=29750 $dt=15
M1697 VREF_N 235 370 VSS! nfet_01v8 L=1.5e-07 W=1.5e-06 $X=115270 $Y=38030 $dt=15
M1698 VREF_N 236 371 VSS! nfet_01v8 L=1.5e-07 W=1.5e-06 $X=115270 $Y=46310 $dt=15
M1699 VREF_N 237 372 VSS! nfet_01v8 L=1.5e-07 W=1.5e-06 $X=115270 $Y=54590 $dt=15
M1700 VREF_N 238 373 VSS! nfet_01v8 L=1.5e-07 W=1.5e-06 $X=115270 $Y=62870 $dt=15
M1701 VREF_N 239 374 VSS! nfet_01v8 L=1.5e-07 W=1.5e-06 $X=115270 $Y=71150 $dt=15
M1702 VREF_N 240 375 VSS! nfet_01v8 L=1.5e-07 W=1.5e-06 $X=115270 $Y=79430 $dt=15
M1703 VREF_N 243 376 VSS! nfet_01v8 L=1.5e-07 W=1.5e-06 $X=115270 $Y=104270 $dt=15
M1704 VREF_N 244 377 VSS! nfet_01v8 L=1.5e-07 W=1.5e-06 $X=115270 $Y=112550 $dt=15
M1705 VREF_N 245 378 VSS! nfet_01v8 L=1.5e-07 W=1.5e-06 $X=115270 $Y=120830 $dt=15
M1706 VREF_N 246 379 VSS! nfet_01v8 L=1.5e-07 W=1.5e-06 $X=115270 $Y=129110 $dt=15
M1707 VREF_N 247 380 VSS! nfet_01v8 L=1.5e-07 W=1.5e-06 $X=115270 $Y=137390 $dt=15
M1708 VREF_N 248 381 VSS! nfet_01v8 L=1.5e-07 W=1.5e-06 $X=115270 $Y=145670 $dt=15
M1709 VREF_N 249 382 VSS! nfet_01v8 L=1.5e-07 W=1.5e-06 $X=115270 $Y=153950 $dt=15
M1710 VREF_N 250 383 VSS! nfet_01v8 L=1.5e-07 W=1.5e-06 $X=115270 $Y=162230 $dt=15
M1711 353 156 VREF_P VSS! nfet_01v8 L=1.5e-07 W=1.5e-06 $X=116990 $Y=13190 $dt=15
M1712 354 157 VREF_P VSS! nfet_01v8 L=1.5e-07 W=1.5e-06 $X=116990 $Y=21470 $dt=15
M1713 355 158 VREF_P VSS! nfet_01v8 L=1.5e-07 W=1.5e-06 $X=116990 $Y=29750 $dt=15
M1714 356 159 VREF_P VSS! nfet_01v8 L=1.5e-07 W=1.5e-06 $X=116990 $Y=38030 $dt=15
M1715 357 160 VREF_P VSS! nfet_01v8 L=1.5e-07 W=1.5e-06 $X=116990 $Y=46310 $dt=15
M1716 358 161 VREF_P VSS! nfet_01v8 L=1.5e-07 W=1.5e-06 $X=116990 $Y=54590 $dt=15
M1717 359 162 VREF_P VSS! nfet_01v8 L=1.5e-07 W=1.5e-06 $X=116990 $Y=62870 $dt=15
M1718 VSS! VDD! VSS! VSS! nfet_01v8 L=5.8e-07 W=1.5e-06 $X=116990 $Y=71150 $dt=15
M1719 VSS! VDD! VSS! VSS! nfet_01v8 L=5.8e-07 W=1.5e-06 $X=116990 $Y=79430 $dt=15
M1720 VSS! VDD! VSS! VSS! nfet_01v8 L=5.8e-07 W=1.5e-06 $X=116990 $Y=87710 $dt=15
M1721 VSS! VDD! VSS! VSS! nfet_01v8 L=5.8e-07 W=1.5e-06 $X=116990 $Y=95990 $dt=15
M1722 VSS! VDD! VSS! VSS! nfet_01v8 L=5.8e-07 W=1.5e-06 $X=116990 $Y=104270 $dt=15
M1723 360 168 VREF_P VSS! nfet_01v8 L=1.5e-07 W=1.5e-06 $X=116990 $Y=112550 $dt=15
M1724 361 169 VREF_P VSS! nfet_01v8 L=1.5e-07 W=1.5e-06 $X=116990 $Y=120830 $dt=15
M1725 362 170 VREF_P VSS! nfet_01v8 L=1.5e-07 W=1.5e-06 $X=116990 $Y=129110 $dt=15
M1726 363 171 VREF_P VSS! nfet_01v8 L=1.5e-07 W=1.5e-06 $X=116990 $Y=137390 $dt=15
M1727 364 172 VREF_P VSS! nfet_01v8 L=1.5e-07 W=1.5e-06 $X=116990 $Y=145670 $dt=15
M1728 365 173 VREF_P VSS! nfet_01v8 L=1.5e-07 W=1.5e-06 $X=116990 $Y=153950 $dt=15
M1729 366 174 VREF_P VSS! nfet_01v8 L=1.5e-07 W=1.5e-06 $X=116990 $Y=162230 $dt=15
M1730 353 289 353 VSS! nfet_01v8 L=1.5e-07 W=1.5e-06 $X=117420 $Y=13190 $dt=15
M1731 354 290 354 VSS! nfet_01v8 L=1.5e-07 W=1.5e-06 $X=117420 $Y=21470 $dt=15
M1732 355 291 355 VSS! nfet_01v8 L=1.5e-07 W=1.5e-06 $X=117420 $Y=29750 $dt=15
M1733 356 292 356 VSS! nfet_01v8 L=1.5e-07 W=1.5e-06 $X=117420 $Y=38030 $dt=15
M1734 357 293 357 VSS! nfet_01v8 L=1.5e-07 W=1.5e-06 $X=117420 $Y=46310 $dt=15
M1735 358 294 358 VSS! nfet_01v8 L=1.5e-07 W=1.5e-06 $X=117420 $Y=54590 $dt=15
M1736 359 295 359 VSS! nfet_01v8 L=1.5e-07 W=1.5e-06 $X=117420 $Y=62870 $dt=15
M1737 360 301 360 VSS! nfet_01v8 L=1.5e-07 W=1.5e-06 $X=117420 $Y=112550 $dt=15
M1738 361 302 361 VSS! nfet_01v8 L=1.5e-07 W=1.5e-06 $X=117420 $Y=120830 $dt=15
M1739 362 303 362 VSS! nfet_01v8 L=1.5e-07 W=1.5e-06 $X=117420 $Y=129110 $dt=15
M1740 363 304 363 VSS! nfet_01v8 L=1.5e-07 W=1.5e-06 $X=117420 $Y=137390 $dt=15
M1741 364 305 364 VSS! nfet_01v8 L=1.5e-07 W=1.5e-06 $X=117420 $Y=145670 $dt=15
M1742 365 306 365 VSS! nfet_01v8 L=1.5e-07 W=1.5e-06 $X=117420 $Y=153950 $dt=15
M1743 366 307 366 VSS! nfet_01v8 L=1.5e-07 W=1.5e-06 $X=117420 $Y=162230 $dt=15
M1744 VSS! VDD! VSS! VSS! nfet_01v8 L=5.8e-07 W=1.5e-06 $X=123110 $Y=71150 $dt=15
M1745 VSS! VDD! VSS! VSS! nfet_01v8 L=5.8e-07 W=1.5e-06 $X=123110 $Y=79430 $dt=15
M1746 VSS! VDD! VSS! VSS! nfet_01v8 L=5.8e-07 W=1.5e-06 $X=123110 $Y=87710 $dt=15
M1747 VSS! VDD! VSS! VSS! nfet_01v8 L=5.8e-07 W=1.5e-06 $X=123110 $Y=95990 $dt=15
M1748 VSS! VDD! VSS! VSS! nfet_01v8 L=5.8e-07 W=1.5e-06 $X=123110 $Y=104270 $dt=15
M1749 353 270 VIN VSS! nfet_01v8 L=1.5e-07 W=1.5e-06 $X=123120 $Y=13190 $dt=15
M1750 354 271 VIN VSS! nfet_01v8 L=1.5e-07 W=1.5e-06 $X=123120 $Y=21470 $dt=15
M1751 355 272 VIN VSS! nfet_01v8 L=1.5e-07 W=1.5e-06 $X=123120 $Y=29750 $dt=15
M1752 356 273 VIN VSS! nfet_01v8 L=1.5e-07 W=1.5e-06 $X=123120 $Y=38030 $dt=15
M1753 357 274 VIN VSS! nfet_01v8 L=1.5e-07 W=1.5e-06 $X=123120 $Y=46310 $dt=15
M1754 358 275 VIN VSS! nfet_01v8 L=1.5e-07 W=1.5e-06 $X=123120 $Y=54590 $dt=15
M1755 359 276 VIN VSS! nfet_01v8 L=1.5e-07 W=1.5e-06 $X=123120 $Y=62870 $dt=15
M1756 360 282 VIN VSS! nfet_01v8 L=1.5e-07 W=1.5e-06 $X=123120 $Y=112550 $dt=15
M1757 361 283 VIN VSS! nfet_01v8 L=1.5e-07 W=1.5e-06 $X=123120 $Y=120830 $dt=15
M1758 362 284 VIN VSS! nfet_01v8 L=1.5e-07 W=1.5e-06 $X=123120 $Y=129110 $dt=15
M1759 363 285 VIN VSS! nfet_01v8 L=1.5e-07 W=1.5e-06 $X=123120 $Y=137390 $dt=15
M1760 364 286 VIN VSS! nfet_01v8 L=1.5e-07 W=1.5e-06 $X=123120 $Y=145670 $dt=15
M1761 365 287 VIN VSS! nfet_01v8 L=1.5e-07 W=1.5e-06 $X=123120 $Y=153950 $dt=15
M1762 366 288 VIN VSS! nfet_01v8 L=1.5e-07 W=1.5e-06 $X=123120 $Y=162230 $dt=15
M1763 VREF_N 232 353 VSS! nfet_01v8 L=1.5e-07 W=1.5e-06 $X=123550 $Y=13190 $dt=15
M1764 VREF_N 233 354 VSS! nfet_01v8 L=1.5e-07 W=1.5e-06 $X=123550 $Y=21470 $dt=15
M1765 VREF_N 234 355 VSS! nfet_01v8 L=1.5e-07 W=1.5e-06 $X=123550 $Y=29750 $dt=15
M1766 VREF_N 235 356 VSS! nfet_01v8 L=1.5e-07 W=1.5e-06 $X=123550 $Y=38030 $dt=15
M1767 VREF_N 236 357 VSS! nfet_01v8 L=1.5e-07 W=1.5e-06 $X=123550 $Y=46310 $dt=15
M1768 VREF_N 237 358 VSS! nfet_01v8 L=1.5e-07 W=1.5e-06 $X=123550 $Y=54590 $dt=15
M1769 VREF_N 238 359 VSS! nfet_01v8 L=1.5e-07 W=1.5e-06 $X=123550 $Y=62870 $dt=15
M1770 VREF_N 244 360 VSS! nfet_01v8 L=1.5e-07 W=1.5e-06 $X=123550 $Y=112550 $dt=15
M1771 VREF_N 245 361 VSS! nfet_01v8 L=1.5e-07 W=1.5e-06 $X=123550 $Y=120830 $dt=15
M1772 VREF_N 246 362 VSS! nfet_01v8 L=1.5e-07 W=1.5e-06 $X=123550 $Y=129110 $dt=15
M1773 VREF_N 247 363 VSS! nfet_01v8 L=1.5e-07 W=1.5e-06 $X=123550 $Y=137390 $dt=15
M1774 VREF_N 248 364 VSS! nfet_01v8 L=1.5e-07 W=1.5e-06 $X=123550 $Y=145670 $dt=15
M1775 VREF_N 249 365 VSS! nfet_01v8 L=1.5e-07 W=1.5e-06 $X=123550 $Y=153950 $dt=15
M1776 VREF_N 250 366 VSS! nfet_01v8 L=1.5e-07 W=1.5e-06 $X=123550 $Y=162230 $dt=15
M1777 339 156 VREF_P VSS! nfet_01v8 L=1.5e-07 W=1.5e-06 $X=125270 $Y=13190 $dt=15
M1778 340 157 VREF_P VSS! nfet_01v8 L=1.5e-07 W=1.5e-06 $X=125270 $Y=21470 $dt=15
M1779 341 158 VREF_P VSS! nfet_01v8 L=1.5e-07 W=1.5e-06 $X=125270 $Y=29750 $dt=15
M1780 342 159 VREF_P VSS! nfet_01v8 L=1.5e-07 W=1.5e-06 $X=125270 $Y=38030 $dt=15
M1781 343 160 VREF_P VSS! nfet_01v8 L=1.5e-07 W=1.5e-06 $X=125270 $Y=46310 $dt=15
M1782 344 161 VREF_P VSS! nfet_01v8 L=1.5e-07 W=1.5e-06 $X=125270 $Y=54590 $dt=15
M1783 345 162 VREF_P VSS! nfet_01v8 L=1.5e-07 W=1.5e-06 $X=125270 $Y=62870 $dt=15
M1784 VSS! VDD! VSS! VSS! nfet_01v8 L=5.8e-07 W=1.5e-06 $X=125270 $Y=71150 $dt=15
M1785 VSS! VDD! VSS! VSS! nfet_01v8 L=5.8e-07 W=1.5e-06 $X=125270 $Y=79430 $dt=15
M1786 VSS! VDD! VSS! VSS! nfet_01v8 L=5.8e-07 W=1.5e-06 $X=125270 $Y=87710 $dt=15
M1787 VSS! VDD! VSS! VSS! nfet_01v8 L=5.8e-07 W=1.5e-06 $X=125270 $Y=95990 $dt=15
M1788 VSS! VDD! VSS! VSS! nfet_01v8 L=5.8e-07 W=1.5e-06 $X=125270 $Y=104270 $dt=15
M1789 346 168 VREF_P VSS! nfet_01v8 L=1.5e-07 W=1.5e-06 $X=125270 $Y=112550 $dt=15
M1790 347 169 VREF_P VSS! nfet_01v8 L=1.5e-07 W=1.5e-06 $X=125270 $Y=120830 $dt=15
M1791 348 170 VREF_P VSS! nfet_01v8 L=1.5e-07 W=1.5e-06 $X=125270 $Y=129110 $dt=15
M1792 349 171 VREF_P VSS! nfet_01v8 L=1.5e-07 W=1.5e-06 $X=125270 $Y=137390 $dt=15
M1793 350 172 VREF_P VSS! nfet_01v8 L=1.5e-07 W=1.5e-06 $X=125270 $Y=145670 $dt=15
M1794 351 173 VREF_P VSS! nfet_01v8 L=1.5e-07 W=1.5e-06 $X=125270 $Y=153950 $dt=15
M1795 352 174 VREF_P VSS! nfet_01v8 L=1.5e-07 W=1.5e-06 $X=125270 $Y=162230 $dt=15
M1796 339 289 339 VSS! nfet_01v8 L=1.5e-07 W=1.5e-06 $X=125700 $Y=13190 $dt=15
M1797 340 290 340 VSS! nfet_01v8 L=1.5e-07 W=1.5e-06 $X=125700 $Y=21470 $dt=15
M1798 341 291 341 VSS! nfet_01v8 L=1.5e-07 W=1.5e-06 $X=125700 $Y=29750 $dt=15
M1799 342 292 342 VSS! nfet_01v8 L=1.5e-07 W=1.5e-06 $X=125700 $Y=38030 $dt=15
M1800 343 293 343 VSS! nfet_01v8 L=1.5e-07 W=1.5e-06 $X=125700 $Y=46310 $dt=15
M1801 344 294 344 VSS! nfet_01v8 L=1.5e-07 W=1.5e-06 $X=125700 $Y=54590 $dt=15
M1802 345 295 345 VSS! nfet_01v8 L=1.5e-07 W=1.5e-06 $X=125700 $Y=62870 $dt=15
M1803 346 301 346 VSS! nfet_01v8 L=1.5e-07 W=1.5e-06 $X=125700 $Y=112550 $dt=15
M1804 347 302 347 VSS! nfet_01v8 L=1.5e-07 W=1.5e-06 $X=125700 $Y=120830 $dt=15
M1805 348 303 348 VSS! nfet_01v8 L=1.5e-07 W=1.5e-06 $X=125700 $Y=129110 $dt=15
M1806 349 304 349 VSS! nfet_01v8 L=1.5e-07 W=1.5e-06 $X=125700 $Y=137390 $dt=15
M1807 350 305 350 VSS! nfet_01v8 L=1.5e-07 W=1.5e-06 $X=125700 $Y=145670 $dt=15
M1808 351 306 351 VSS! nfet_01v8 L=1.5e-07 W=1.5e-06 $X=125700 $Y=153950 $dt=15
M1809 352 307 352 VSS! nfet_01v8 L=1.5e-07 W=1.5e-06 $X=125700 $Y=162230 $dt=15
M1810 VSS! VDD! VSS! VSS! nfet_01v8 L=5.8e-07 W=1.5e-06 $X=131390 $Y=71150 $dt=15
M1811 VSS! VDD! VSS! VSS! nfet_01v8 L=5.8e-07 W=1.5e-06 $X=131390 $Y=79430 $dt=15
M1812 VSS! VDD! VSS! VSS! nfet_01v8 L=5.8e-07 W=1.5e-06 $X=131390 $Y=87710 $dt=15
M1813 VSS! VDD! VSS! VSS! nfet_01v8 L=5.8e-07 W=1.5e-06 $X=131390 $Y=95990 $dt=15
M1814 VSS! VDD! VSS! VSS! nfet_01v8 L=5.8e-07 W=1.5e-06 $X=131390 $Y=104270 $dt=15
M1815 339 270 VIN VSS! nfet_01v8 L=1.5e-07 W=1.5e-06 $X=131400 $Y=13190 $dt=15
M1816 340 271 VIN VSS! nfet_01v8 L=1.5e-07 W=1.5e-06 $X=131400 $Y=21470 $dt=15
M1817 341 272 VIN VSS! nfet_01v8 L=1.5e-07 W=1.5e-06 $X=131400 $Y=29750 $dt=15
M1818 342 273 VIN VSS! nfet_01v8 L=1.5e-07 W=1.5e-06 $X=131400 $Y=38030 $dt=15
M1819 343 274 VIN VSS! nfet_01v8 L=1.5e-07 W=1.5e-06 $X=131400 $Y=46310 $dt=15
M1820 344 275 VIN VSS! nfet_01v8 L=1.5e-07 W=1.5e-06 $X=131400 $Y=54590 $dt=15
M1821 345 276 VIN VSS! nfet_01v8 L=1.5e-07 W=1.5e-06 $X=131400 $Y=62870 $dt=15
M1822 346 282 VIN VSS! nfet_01v8 L=1.5e-07 W=1.5e-06 $X=131400 $Y=112550 $dt=15
M1823 347 283 VIN VSS! nfet_01v8 L=1.5e-07 W=1.5e-06 $X=131400 $Y=120830 $dt=15
M1824 348 284 VIN VSS! nfet_01v8 L=1.5e-07 W=1.5e-06 $X=131400 $Y=129110 $dt=15
M1825 349 285 VIN VSS! nfet_01v8 L=1.5e-07 W=1.5e-06 $X=131400 $Y=137390 $dt=15
M1826 350 286 VIN VSS! nfet_01v8 L=1.5e-07 W=1.5e-06 $X=131400 $Y=145670 $dt=15
M1827 351 287 VIN VSS! nfet_01v8 L=1.5e-07 W=1.5e-06 $X=131400 $Y=153950 $dt=15
M1828 352 288 VIN VSS! nfet_01v8 L=1.5e-07 W=1.5e-06 $X=131400 $Y=162230 $dt=15
M1829 VREF_N 232 339 VSS! nfet_01v8 L=1.5e-07 W=1.5e-06 $X=131830 $Y=13190 $dt=15
M1830 VREF_N 233 340 VSS! nfet_01v8 L=1.5e-07 W=1.5e-06 $X=131830 $Y=21470 $dt=15
M1831 VREF_N 234 341 VSS! nfet_01v8 L=1.5e-07 W=1.5e-06 $X=131830 $Y=29750 $dt=15
M1832 VREF_N 235 342 VSS! nfet_01v8 L=1.5e-07 W=1.5e-06 $X=131830 $Y=38030 $dt=15
M1833 VREF_N 236 343 VSS! nfet_01v8 L=1.5e-07 W=1.5e-06 $X=131830 $Y=46310 $dt=15
M1834 VREF_N 237 344 VSS! nfet_01v8 L=1.5e-07 W=1.5e-06 $X=131830 $Y=54590 $dt=15
M1835 VREF_N 238 345 VSS! nfet_01v8 L=1.5e-07 W=1.5e-06 $X=131830 $Y=62870 $dt=15
M1836 VREF_N 244 346 VSS! nfet_01v8 L=1.5e-07 W=1.5e-06 $X=131830 $Y=112550 $dt=15
M1837 VREF_N 245 347 VSS! nfet_01v8 L=1.5e-07 W=1.5e-06 $X=131830 $Y=120830 $dt=15
M1838 VREF_N 246 348 VSS! nfet_01v8 L=1.5e-07 W=1.5e-06 $X=131830 $Y=129110 $dt=15
M1839 VREF_N 247 349 VSS! nfet_01v8 L=1.5e-07 W=1.5e-06 $X=131830 $Y=137390 $dt=15
M1840 VREF_N 248 350 VSS! nfet_01v8 L=1.5e-07 W=1.5e-06 $X=131830 $Y=145670 $dt=15
M1841 VREF_N 249 351 VSS! nfet_01v8 L=1.5e-07 W=1.5e-06 $X=131830 $Y=153950 $dt=15
M1842 VREF_N 250 352 VSS! nfet_01v8 L=1.5e-07 W=1.5e-06 $X=131830 $Y=162230 $dt=15
M1843 325 156 VREF_P VSS! nfet_01v8 L=1.5e-07 W=1.5e-06 $X=133550 $Y=13190 $dt=15
M1844 326 157 VREF_P VSS! nfet_01v8 L=1.5e-07 W=1.5e-06 $X=133550 $Y=21470 $dt=15
M1845 327 158 VREF_P VSS! nfet_01v8 L=1.5e-07 W=1.5e-06 $X=133550 $Y=29750 $dt=15
M1846 328 159 VREF_P VSS! nfet_01v8 L=1.5e-07 W=1.5e-06 $X=133550 $Y=38030 $dt=15
M1847 329 160 VREF_P VSS! nfet_01v8 L=1.5e-07 W=1.5e-06 $X=133550 $Y=46310 $dt=15
M1848 330 161 VREF_P VSS! nfet_01v8 L=1.5e-07 W=1.5e-06 $X=133550 $Y=54590 $dt=15
M1849 331 162 VREF_P VSS! nfet_01v8 L=1.5e-07 W=1.5e-06 $X=133550 $Y=62870 $dt=15
M1850 VSS! VDD! VSS! VSS! nfet_01v8 L=5.8e-07 W=1.5e-06 $X=133550 $Y=71150 $dt=15
M1851 VSS! VDD! VSS! VSS! nfet_01v8 L=5.8e-07 W=1.5e-06 $X=133550 $Y=79430 $dt=15
M1852 VSS! VDD! VSS! VSS! nfet_01v8 L=5.8e-07 W=1.5e-06 $X=133550 $Y=87710 $dt=15
M1853 VSS! VDD! VSS! VSS! nfet_01v8 L=5.8e-07 W=1.5e-06 $X=133550 $Y=95990 $dt=15
M1854 VSS! VDD! VSS! VSS! nfet_01v8 L=5.8e-07 W=1.5e-06 $X=133550 $Y=104270 $dt=15
M1855 332 168 VREF_P VSS! nfet_01v8 L=1.5e-07 W=1.5e-06 $X=133550 $Y=112550 $dt=15
M1856 333 169 VREF_P VSS! nfet_01v8 L=1.5e-07 W=1.5e-06 $X=133550 $Y=120830 $dt=15
M1857 334 170 VREF_P VSS! nfet_01v8 L=1.5e-07 W=1.5e-06 $X=133550 $Y=129110 $dt=15
M1858 335 171 VREF_P VSS! nfet_01v8 L=1.5e-07 W=1.5e-06 $X=133550 $Y=137390 $dt=15
M1859 336 172 VREF_P VSS! nfet_01v8 L=1.5e-07 W=1.5e-06 $X=133550 $Y=145670 $dt=15
M1860 337 173 VREF_P VSS! nfet_01v8 L=1.5e-07 W=1.5e-06 $X=133550 $Y=153950 $dt=15
M1861 338 174 VREF_P VSS! nfet_01v8 L=1.5e-07 W=1.5e-06 $X=133550 $Y=162230 $dt=15
M1862 325 289 325 VSS! nfet_01v8 L=1.5e-07 W=1.5e-06 $X=133980 $Y=13190 $dt=15
M1863 326 290 326 VSS! nfet_01v8 L=1.5e-07 W=1.5e-06 $X=133980 $Y=21470 $dt=15
M1864 327 291 327 VSS! nfet_01v8 L=1.5e-07 W=1.5e-06 $X=133980 $Y=29750 $dt=15
M1865 328 292 328 VSS! nfet_01v8 L=1.5e-07 W=1.5e-06 $X=133980 $Y=38030 $dt=15
M1866 329 293 329 VSS! nfet_01v8 L=1.5e-07 W=1.5e-06 $X=133980 $Y=46310 $dt=15
M1867 330 294 330 VSS! nfet_01v8 L=1.5e-07 W=1.5e-06 $X=133980 $Y=54590 $dt=15
M1868 331 295 331 VSS! nfet_01v8 L=1.5e-07 W=1.5e-06 $X=133980 $Y=62870 $dt=15
M1869 332 301 332 VSS! nfet_01v8 L=1.5e-07 W=1.5e-06 $X=133980 $Y=112550 $dt=15
M1870 333 302 333 VSS! nfet_01v8 L=1.5e-07 W=1.5e-06 $X=133980 $Y=120830 $dt=15
M1871 334 303 334 VSS! nfet_01v8 L=1.5e-07 W=1.5e-06 $X=133980 $Y=129110 $dt=15
M1872 335 304 335 VSS! nfet_01v8 L=1.5e-07 W=1.5e-06 $X=133980 $Y=137390 $dt=15
M1873 336 305 336 VSS! nfet_01v8 L=1.5e-07 W=1.5e-06 $X=133980 $Y=145670 $dt=15
M1874 337 306 337 VSS! nfet_01v8 L=1.5e-07 W=1.5e-06 $X=133980 $Y=153950 $dt=15
M1875 338 307 338 VSS! nfet_01v8 L=1.5e-07 W=1.5e-06 $X=133980 $Y=162230 $dt=15
M1876 VSS! VDD! VSS! VSS! nfet_01v8 L=5.8e-07 W=1.5e-06 $X=139670 $Y=71150 $dt=15
M1877 VSS! VDD! VSS! VSS! nfet_01v8 L=5.8e-07 W=1.5e-06 $X=139670 $Y=79430 $dt=15
M1878 VSS! VDD! VSS! VSS! nfet_01v8 L=5.8e-07 W=1.5e-06 $X=139670 $Y=87710 $dt=15
M1879 VSS! VDD! VSS! VSS! nfet_01v8 L=5.8e-07 W=1.5e-06 $X=139670 $Y=95990 $dt=15
M1880 VSS! VDD! VSS! VSS! nfet_01v8 L=5.8e-07 W=1.5e-06 $X=139670 $Y=104270 $dt=15
M1881 325 270 VIN VSS! nfet_01v8 L=1.5e-07 W=1.5e-06 $X=139680 $Y=13190 $dt=15
M1882 326 271 VIN VSS! nfet_01v8 L=1.5e-07 W=1.5e-06 $X=139680 $Y=21470 $dt=15
M1883 327 272 VIN VSS! nfet_01v8 L=1.5e-07 W=1.5e-06 $X=139680 $Y=29750 $dt=15
M1884 328 273 VIN VSS! nfet_01v8 L=1.5e-07 W=1.5e-06 $X=139680 $Y=38030 $dt=15
M1885 329 274 VIN VSS! nfet_01v8 L=1.5e-07 W=1.5e-06 $X=139680 $Y=46310 $dt=15
M1886 330 275 VIN VSS! nfet_01v8 L=1.5e-07 W=1.5e-06 $X=139680 $Y=54590 $dt=15
M1887 331 276 VIN VSS! nfet_01v8 L=1.5e-07 W=1.5e-06 $X=139680 $Y=62870 $dt=15
M1888 332 282 VIN VSS! nfet_01v8 L=1.5e-07 W=1.5e-06 $X=139680 $Y=112550 $dt=15
M1889 333 283 VIN VSS! nfet_01v8 L=1.5e-07 W=1.5e-06 $X=139680 $Y=120830 $dt=15
M1890 334 284 VIN VSS! nfet_01v8 L=1.5e-07 W=1.5e-06 $X=139680 $Y=129110 $dt=15
M1891 335 285 VIN VSS! nfet_01v8 L=1.5e-07 W=1.5e-06 $X=139680 $Y=137390 $dt=15
M1892 336 286 VIN VSS! nfet_01v8 L=1.5e-07 W=1.5e-06 $X=139680 $Y=145670 $dt=15
M1893 337 287 VIN VSS! nfet_01v8 L=1.5e-07 W=1.5e-06 $X=139680 $Y=153950 $dt=15
M1894 338 288 VIN VSS! nfet_01v8 L=1.5e-07 W=1.5e-06 $X=139680 $Y=162230 $dt=15
M1895 VREF_N 232 325 VSS! nfet_01v8 L=1.5e-07 W=1.5e-06 $X=140110 $Y=13190 $dt=15
M1896 VREF_N 233 326 VSS! nfet_01v8 L=1.5e-07 W=1.5e-06 $X=140110 $Y=21470 $dt=15
M1897 VREF_N 234 327 VSS! nfet_01v8 L=1.5e-07 W=1.5e-06 $X=140110 $Y=29750 $dt=15
M1898 VREF_N 235 328 VSS! nfet_01v8 L=1.5e-07 W=1.5e-06 $X=140110 $Y=38030 $dt=15
M1899 VREF_N 236 329 VSS! nfet_01v8 L=1.5e-07 W=1.5e-06 $X=140110 $Y=46310 $dt=15
M1900 VREF_N 237 330 VSS! nfet_01v8 L=1.5e-07 W=1.5e-06 $X=140110 $Y=54590 $dt=15
M1901 VREF_N 238 331 VSS! nfet_01v8 L=1.5e-07 W=1.5e-06 $X=140110 $Y=62870 $dt=15
M1902 VREF_N 244 332 VSS! nfet_01v8 L=1.5e-07 W=1.5e-06 $X=140110 $Y=112550 $dt=15
M1903 VREF_N 245 333 VSS! nfet_01v8 L=1.5e-07 W=1.5e-06 $X=140110 $Y=120830 $dt=15
M1904 VREF_N 246 334 VSS! nfet_01v8 L=1.5e-07 W=1.5e-06 $X=140110 $Y=129110 $dt=15
M1905 VREF_N 247 335 VSS! nfet_01v8 L=1.5e-07 W=1.5e-06 $X=140110 $Y=137390 $dt=15
M1906 VREF_N 248 336 VSS! nfet_01v8 L=1.5e-07 W=1.5e-06 $X=140110 $Y=145670 $dt=15
M1907 VREF_N 249 337 VSS! nfet_01v8 L=1.5e-07 W=1.5e-06 $X=140110 $Y=153950 $dt=15
M1908 VREF_N 250 338 VSS! nfet_01v8 L=1.5e-07 W=1.5e-06 $X=140110 $Y=162230 $dt=15
M1909 310 156 VREF_P VSS! nfet_01v8 L=1.5e-07 W=1.5e-06 $X=141830 $Y=13190 $dt=15
M1910 311 157 VREF_P VSS! nfet_01v8 L=1.5e-07 W=1.5e-06 $X=141830 $Y=21470 $dt=15
M1911 312 158 VREF_P VSS! nfet_01v8 L=1.5e-07 W=1.5e-06 $X=141830 $Y=29750 $dt=15
M1912 313 159 VREF_P VSS! nfet_01v8 L=1.5e-07 W=1.5e-06 $X=141830 $Y=38030 $dt=15
M1913 314 160 VREF_P VSS! nfet_01v8 L=1.5e-07 W=1.5e-06 $X=141830 $Y=46310 $dt=15
M1914 315 161 VREF_P VSS! nfet_01v8 L=1.5e-07 W=1.5e-06 $X=141830 $Y=54590 $dt=15
M1915 316 162 VREF_P VSS! nfet_01v8 L=1.5e-07 W=1.5e-06 $X=141830 $Y=62870 $dt=15
M1916 VSS! VDD! VSS! VSS! nfet_01v8 L=5.8e-07 W=1.5e-06 $X=141830 $Y=71150 $dt=15
M1917 VSS! VDD! VSS! VSS! nfet_01v8 L=5.8e-07 W=1.5e-06 $X=141830 $Y=79430 $dt=15
M1918 VSS! VDD! VSS! VSS! nfet_01v8 L=5.8e-07 W=1.5e-06 $X=141830 $Y=87710 $dt=15
M1919 VSS! VDD! VSS! VSS! nfet_01v8 L=5.8e-07 W=1.5e-06 $X=141830 $Y=95990 $dt=15
M1920 VSS! VDD! VSS! VSS! nfet_01v8 L=5.8e-07 W=1.5e-06 $X=141830 $Y=104270 $dt=15
M1921 317 168 VREF_P VSS! nfet_01v8 L=1.5e-07 W=1.5e-06 $X=141830 $Y=112550 $dt=15
M1922 318 169 VREF_P VSS! nfet_01v8 L=1.5e-07 W=1.5e-06 $X=141830 $Y=120830 $dt=15
M1923 319 170 VREF_P VSS! nfet_01v8 L=1.5e-07 W=1.5e-06 $X=141830 $Y=129110 $dt=15
M1924 320 171 VREF_P VSS! nfet_01v8 L=1.5e-07 W=1.5e-06 $X=141830 $Y=137390 $dt=15
M1925 321 172 VREF_P VSS! nfet_01v8 L=1.5e-07 W=1.5e-06 $X=141830 $Y=145670 $dt=15
M1926 322 173 VREF_P VSS! nfet_01v8 L=1.5e-07 W=1.5e-06 $X=141830 $Y=153950 $dt=15
M1927 323 174 VREF_P VSS! nfet_01v8 L=1.5e-07 W=1.5e-06 $X=141830 $Y=162230 $dt=15
M1928 310 289 310 VSS! nfet_01v8 L=1.5e-07 W=1.5e-06 $X=142260 $Y=13190 $dt=15
M1929 311 290 311 VSS! nfet_01v8 L=1.5e-07 W=1.5e-06 $X=142260 $Y=21470 $dt=15
M1930 312 291 312 VSS! nfet_01v8 L=1.5e-07 W=1.5e-06 $X=142260 $Y=29750 $dt=15
M1931 313 292 313 VSS! nfet_01v8 L=1.5e-07 W=1.5e-06 $X=142260 $Y=38030 $dt=15
M1932 314 293 314 VSS! nfet_01v8 L=1.5e-07 W=1.5e-06 $X=142260 $Y=46310 $dt=15
M1933 315 294 315 VSS! nfet_01v8 L=1.5e-07 W=1.5e-06 $X=142260 $Y=54590 $dt=15
M1934 316 295 316 VSS! nfet_01v8 L=1.5e-07 W=1.5e-06 $X=142260 $Y=62870 $dt=15
M1935 317 301 317 VSS! nfet_01v8 L=1.5e-07 W=1.5e-06 $X=142260 $Y=112550 $dt=15
M1936 318 302 318 VSS! nfet_01v8 L=1.5e-07 W=1.5e-06 $X=142260 $Y=120830 $dt=15
M1937 319 303 319 VSS! nfet_01v8 L=1.5e-07 W=1.5e-06 $X=142260 $Y=129110 $dt=15
M1938 320 304 320 VSS! nfet_01v8 L=1.5e-07 W=1.5e-06 $X=142260 $Y=137390 $dt=15
M1939 321 305 321 VSS! nfet_01v8 L=1.5e-07 W=1.5e-06 $X=142260 $Y=145670 $dt=15
M1940 322 306 322 VSS! nfet_01v8 L=1.5e-07 W=1.5e-06 $X=142260 $Y=153950 $dt=15
M1941 323 307 323 VSS! nfet_01v8 L=1.5e-07 W=1.5e-06 $X=142260 $Y=162230 $dt=15
M1942 VSS! VDD! VSS! VSS! nfet_01v8 L=5.8e-07 W=1.5e-06 $X=147950 $Y=71150 $dt=15
M1943 VSS! VDD! VSS! VSS! nfet_01v8 L=5.8e-07 W=1.5e-06 $X=147950 $Y=79430 $dt=15
M1944 VSS! VDD! VSS! VSS! nfet_01v8 L=5.8e-07 W=1.5e-06 $X=147950 $Y=87710 $dt=15
M1945 VSS! VDD! VSS! VSS! nfet_01v8 L=5.8e-07 W=1.5e-06 $X=147950 $Y=95990 $dt=15
M1946 VSS! VDD! VSS! VSS! nfet_01v8 L=5.8e-07 W=1.5e-06 $X=147950 $Y=104270 $dt=15
M1947 310 270 VIN VSS! nfet_01v8 L=1.5e-07 W=1.5e-06 $X=147960 $Y=13190 $dt=15
M1948 311 271 VIN VSS! nfet_01v8 L=1.5e-07 W=1.5e-06 $X=147960 $Y=21470 $dt=15
M1949 312 272 VIN VSS! nfet_01v8 L=1.5e-07 W=1.5e-06 $X=147960 $Y=29750 $dt=15
M1950 313 273 VIN VSS! nfet_01v8 L=1.5e-07 W=1.5e-06 $X=147960 $Y=38030 $dt=15
M1951 314 274 VIN VSS! nfet_01v8 L=1.5e-07 W=1.5e-06 $X=147960 $Y=46310 $dt=15
M1952 315 275 VIN VSS! nfet_01v8 L=1.5e-07 W=1.5e-06 $X=147960 $Y=54590 $dt=15
M1953 316 276 VIN VSS! nfet_01v8 L=1.5e-07 W=1.5e-06 $X=147960 $Y=62870 $dt=15
M1954 317 282 VIN VSS! nfet_01v8 L=1.5e-07 W=1.5e-06 $X=147960 $Y=112550 $dt=15
M1955 318 283 VIN VSS! nfet_01v8 L=1.5e-07 W=1.5e-06 $X=147960 $Y=120830 $dt=15
M1956 319 284 VIN VSS! nfet_01v8 L=1.5e-07 W=1.5e-06 $X=147960 $Y=129110 $dt=15
M1957 320 285 VIN VSS! nfet_01v8 L=1.5e-07 W=1.5e-06 $X=147960 $Y=137390 $dt=15
M1958 321 286 VIN VSS! nfet_01v8 L=1.5e-07 W=1.5e-06 $X=147960 $Y=145670 $dt=15
M1959 322 287 VIN VSS! nfet_01v8 L=1.5e-07 W=1.5e-06 $X=147960 $Y=153950 $dt=15
M1960 323 288 VIN VSS! nfet_01v8 L=1.5e-07 W=1.5e-06 $X=147960 $Y=162230 $dt=15
M1961 VREF_N 232 310 VSS! nfet_01v8 L=1.5e-07 W=1.5e-06 $X=148390 $Y=13190 $dt=15
M1962 VREF_N 233 311 VSS! nfet_01v8 L=1.5e-07 W=1.5e-06 $X=148390 $Y=21470 $dt=15
M1963 VREF_N 234 312 VSS! nfet_01v8 L=1.5e-07 W=1.5e-06 $X=148390 $Y=29750 $dt=15
M1964 VREF_N 235 313 VSS! nfet_01v8 L=1.5e-07 W=1.5e-06 $X=148390 $Y=38030 $dt=15
M1965 VREF_N 236 314 VSS! nfet_01v8 L=1.5e-07 W=1.5e-06 $X=148390 $Y=46310 $dt=15
M1966 VREF_N 237 315 VSS! nfet_01v8 L=1.5e-07 W=1.5e-06 $X=148390 $Y=54590 $dt=15
M1967 VREF_N 238 316 VSS! nfet_01v8 L=1.5e-07 W=1.5e-06 $X=148390 $Y=62870 $dt=15
M1968 VREF_N 244 317 VSS! nfet_01v8 L=1.5e-07 W=1.5e-06 $X=148390 $Y=112550 $dt=15
M1969 VREF_N 245 318 VSS! nfet_01v8 L=1.5e-07 W=1.5e-06 $X=148390 $Y=120830 $dt=15
M1970 VREF_N 246 319 VSS! nfet_01v8 L=1.5e-07 W=1.5e-06 $X=148390 $Y=129110 $dt=15
M1971 VREF_N 247 320 VSS! nfet_01v8 L=1.5e-07 W=1.5e-06 $X=148390 $Y=137390 $dt=15
M1972 VREF_N 248 321 VSS! nfet_01v8 L=1.5e-07 W=1.5e-06 $X=148390 $Y=145670 $dt=15
M1973 VREF_N 249 322 VSS! nfet_01v8 L=1.5e-07 W=1.5e-06 $X=148390 $Y=153950 $dt=15
M1974 VREF_N 250 323 VSS! nfet_01v8 L=1.5e-07 W=1.5e-06 $X=148390 $Y=162230 $dt=15
M1975 289 118 VSS! VSS! nfet_01v8 L=1.5e-07 W=7.6e-07 $X=150530 $Y=11070 $dt=15
M1976 290 119 VSS! VSS! nfet_01v8 L=1.5e-07 W=7.6e-07 $X=150530 $Y=19350 $dt=15
M1977 291 120 VSS! VSS! nfet_01v8 L=1.5e-07 W=7.6e-07 $X=150530 $Y=27630 $dt=15
M1978 292 121 VSS! VSS! nfet_01v8 L=1.5e-07 W=7.6e-07 $X=150530 $Y=35910 $dt=15
M1979 293 122 VSS! VSS! nfet_01v8 L=1.5e-07 W=7.6e-07 $X=150530 $Y=44190 $dt=15
M1980 294 123 VSS! VSS! nfet_01v8 L=1.5e-07 W=7.6e-07 $X=150530 $Y=52470 $dt=15
M1981 295 124 VSS! VSS! nfet_01v8 L=1.5e-07 W=7.6e-07 $X=150530 $Y=60750 $dt=15
M1982 296 125 VSS! VSS! nfet_01v8 L=1.5e-07 W=7.6e-07 $X=150530 $Y=69030 $dt=15
M1983 297 126 VSS! VSS! nfet_01v8 L=1.5e-07 W=7.6e-07 $X=150530 $Y=77310 $dt=15
M1984 298 127 VSS! VSS! nfet_01v8 L=1.5e-07 W=7.6e-07 $X=150530 $Y=85590 $dt=15
M1985 299 128 VSS! VSS! nfet_01v8 L=1.5e-07 W=7.6e-07 $X=150530 $Y=93870 $dt=15
M1986 300 129 VSS! VSS! nfet_01v8 L=1.5e-07 W=7.6e-07 $X=150530 $Y=102150 $dt=15
M1987 301 130 VSS! VSS! nfet_01v8 L=1.5e-07 W=7.6e-07 $X=150530 $Y=110430 $dt=15
M1988 302 131 VSS! VSS! nfet_01v8 L=1.5e-07 W=7.6e-07 $X=150530 $Y=118710 $dt=15
M1989 303 132 VSS! VSS! nfet_01v8 L=1.5e-07 W=7.6e-07 $X=150530 $Y=126990 $dt=15
M1990 304 133 VSS! VSS! nfet_01v8 L=1.5e-07 W=7.6e-07 $X=150530 $Y=135270 $dt=15
M1991 305 134 VSS! VSS! nfet_01v8 L=1.5e-07 W=7.6e-07 $X=150530 $Y=143550 $dt=15
M1992 306 135 VSS! VSS! nfet_01v8 L=1.5e-07 W=7.6e-07 $X=150530 $Y=151830 $dt=15
M1993 307 136 VSS! VSS! nfet_01v8 L=1.5e-07 W=7.6e-07 $X=150530 $Y=160110 $dt=15
M1994 270 251 VSS! VSS! nfet_01v8 L=1.5e-07 W=7.6e-07 $X=150590 $Y=13010 $dt=15
M1995 271 252 VSS! VSS! nfet_01v8 L=1.5e-07 W=7.6e-07 $X=150590 $Y=21290 $dt=15
M1996 272 253 VSS! VSS! nfet_01v8 L=1.5e-07 W=7.6e-07 $X=150590 $Y=29570 $dt=15
M1997 273 254 VSS! VSS! nfet_01v8 L=1.5e-07 W=7.6e-07 $X=150590 $Y=37850 $dt=15
M1998 274 255 VSS! VSS! nfet_01v8 L=1.5e-07 W=7.6e-07 $X=150590 $Y=46130 $dt=15
M1999 275 256 VSS! VSS! nfet_01v8 L=1.5e-07 W=7.6e-07 $X=150590 $Y=54410 $dt=15
M2000 276 257 VSS! VSS! nfet_01v8 L=1.5e-07 W=7.6e-07 $X=150590 $Y=62690 $dt=15
M2001 277 258 VSS! VSS! nfet_01v8 L=1.5e-07 W=7.6e-07 $X=150590 $Y=70970 $dt=15
M2002 278 259 VSS! VSS! nfet_01v8 L=1.5e-07 W=7.6e-07 $X=150590 $Y=79250 $dt=15
M2003 279 260 VSS! VSS! nfet_01v8 L=1.5e-07 W=7.6e-07 $X=150590 $Y=87530 $dt=15
M2004 280 261 VSS! VSS! nfet_01v8 L=1.5e-07 W=7.6e-07 $X=150590 $Y=95810 $dt=15
M2005 281 262 VSS! VSS! nfet_01v8 L=1.5e-07 W=7.6e-07 $X=150590 $Y=104090 $dt=15
M2006 282 263 VSS! VSS! nfet_01v8 L=1.5e-07 W=7.6e-07 $X=150590 $Y=112370 $dt=15
M2007 283 264 VSS! VSS! nfet_01v8 L=1.5e-07 W=7.6e-07 $X=150590 $Y=120650 $dt=15
M2008 284 265 VSS! VSS! nfet_01v8 L=1.5e-07 W=7.6e-07 $X=150590 $Y=128930 $dt=15
M2009 285 266 VSS! VSS! nfet_01v8 L=1.5e-07 W=7.6e-07 $X=150590 $Y=137210 $dt=15
M2010 286 267 VSS! VSS! nfet_01v8 L=1.5e-07 W=7.6e-07 $X=150590 $Y=145490 $dt=15
M2011 287 268 VSS! VSS! nfet_01v8 L=1.5e-07 W=7.6e-07 $X=150590 $Y=153770 $dt=15
M2012 288 269 VSS! VSS! nfet_01v8 L=1.5e-07 W=7.6e-07 $X=150590 $Y=162050 $dt=15
M2013 VSS! 118 289 VSS! nfet_01v8 L=1.5e-07 W=7.6e-07 $X=150960 $Y=11070 $dt=15
M2014 VSS! 119 290 VSS! nfet_01v8 L=1.5e-07 W=7.6e-07 $X=150960 $Y=19350 $dt=15
M2015 VSS! 120 291 VSS! nfet_01v8 L=1.5e-07 W=7.6e-07 $X=150960 $Y=27630 $dt=15
M2016 VSS! 121 292 VSS! nfet_01v8 L=1.5e-07 W=7.6e-07 $X=150960 $Y=35910 $dt=15
M2017 VSS! 122 293 VSS! nfet_01v8 L=1.5e-07 W=7.6e-07 $X=150960 $Y=44190 $dt=15
M2018 VSS! 123 294 VSS! nfet_01v8 L=1.5e-07 W=7.6e-07 $X=150960 $Y=52470 $dt=15
M2019 VSS! 124 295 VSS! nfet_01v8 L=1.5e-07 W=7.6e-07 $X=150960 $Y=60750 $dt=15
M2020 VSS! 125 296 VSS! nfet_01v8 L=1.5e-07 W=7.6e-07 $X=150960 $Y=69030 $dt=15
M2021 VSS! 126 297 VSS! nfet_01v8 L=1.5e-07 W=7.6e-07 $X=150960 $Y=77310 $dt=15
M2022 VSS! 127 298 VSS! nfet_01v8 L=1.5e-07 W=7.6e-07 $X=150960 $Y=85590 $dt=15
M2023 VSS! 128 299 VSS! nfet_01v8 L=1.5e-07 W=7.6e-07 $X=150960 $Y=93870 $dt=15
M2024 VSS! 129 300 VSS! nfet_01v8 L=1.5e-07 W=7.6e-07 $X=150960 $Y=102150 $dt=15
M2025 VSS! 130 301 VSS! nfet_01v8 L=1.5e-07 W=7.6e-07 $X=150960 $Y=110430 $dt=15
M2026 VSS! 131 302 VSS! nfet_01v8 L=1.5e-07 W=7.6e-07 $X=150960 $Y=118710 $dt=15
M2027 VSS! 132 303 VSS! nfet_01v8 L=1.5e-07 W=7.6e-07 $X=150960 $Y=126990 $dt=15
M2028 VSS! 133 304 VSS! nfet_01v8 L=1.5e-07 W=7.6e-07 $X=150960 $Y=135270 $dt=15
M2029 VSS! 134 305 VSS! nfet_01v8 L=1.5e-07 W=7.6e-07 $X=150960 $Y=143550 $dt=15
M2030 VSS! 135 306 VSS! nfet_01v8 L=1.5e-07 W=7.6e-07 $X=150960 $Y=151830 $dt=15
M2031 VSS! 136 307 VSS! nfet_01v8 L=1.5e-07 W=7.6e-07 $X=150960 $Y=160110 $dt=15
M2032 VSS! 251 270 VSS! nfet_01v8 L=1.5e-07 W=7.6e-07 $X=151020 $Y=13010 $dt=15
M2033 VSS! 252 271 VSS! nfet_01v8 L=1.5e-07 W=7.6e-07 $X=151020 $Y=21290 $dt=15
M2034 VSS! 253 272 VSS! nfet_01v8 L=1.5e-07 W=7.6e-07 $X=151020 $Y=29570 $dt=15
M2035 VSS! 254 273 VSS! nfet_01v8 L=1.5e-07 W=7.6e-07 $X=151020 $Y=37850 $dt=15
M2036 VSS! 255 274 VSS! nfet_01v8 L=1.5e-07 W=7.6e-07 $X=151020 $Y=46130 $dt=15
M2037 VSS! 256 275 VSS! nfet_01v8 L=1.5e-07 W=7.6e-07 $X=151020 $Y=54410 $dt=15
M2038 VSS! 257 276 VSS! nfet_01v8 L=1.5e-07 W=7.6e-07 $X=151020 $Y=62690 $dt=15
M2039 VSS! 258 277 VSS! nfet_01v8 L=1.5e-07 W=7.6e-07 $X=151020 $Y=70970 $dt=15
M2040 VSS! 259 278 VSS! nfet_01v8 L=1.5e-07 W=7.6e-07 $X=151020 $Y=79250 $dt=15
M2041 VSS! 260 279 VSS! nfet_01v8 L=1.5e-07 W=7.6e-07 $X=151020 $Y=87530 $dt=15
M2042 VSS! 261 280 VSS! nfet_01v8 L=1.5e-07 W=7.6e-07 $X=151020 $Y=95810 $dt=15
M2043 VSS! 262 281 VSS! nfet_01v8 L=1.5e-07 W=7.6e-07 $X=151020 $Y=104090 $dt=15
M2044 VSS! 263 282 VSS! nfet_01v8 L=1.5e-07 W=7.6e-07 $X=151020 $Y=112370 $dt=15
M2045 VSS! 264 283 VSS! nfet_01v8 L=1.5e-07 W=7.6e-07 $X=151020 $Y=120650 $dt=15
M2046 VSS! 265 284 VSS! nfet_01v8 L=1.5e-07 W=7.6e-07 $X=151020 $Y=128930 $dt=15
M2047 VSS! 266 285 VSS! nfet_01v8 L=1.5e-07 W=7.6e-07 $X=151020 $Y=137210 $dt=15
M2048 VSS! 267 286 VSS! nfet_01v8 L=1.5e-07 W=7.6e-07 $X=151020 $Y=145490 $dt=15
M2049 VSS! 268 287 VSS! nfet_01v8 L=1.5e-07 W=7.6e-07 $X=151020 $Y=153770 $dt=15
M2050 VSS! 269 288 VSS! nfet_01v8 L=1.5e-07 W=7.6e-07 $X=151020 $Y=162050 $dt=15
M2051 289 118 VSS! VSS! nfet_01v8 L=1.5e-07 W=7.6e-07 $X=151390 $Y=11070 $dt=15
M2052 290 119 VSS! VSS! nfet_01v8 L=1.5e-07 W=7.6e-07 $X=151390 $Y=19350 $dt=15
M2053 291 120 VSS! VSS! nfet_01v8 L=1.5e-07 W=7.6e-07 $X=151390 $Y=27630 $dt=15
M2054 292 121 VSS! VSS! nfet_01v8 L=1.5e-07 W=7.6e-07 $X=151390 $Y=35910 $dt=15
M2055 293 122 VSS! VSS! nfet_01v8 L=1.5e-07 W=7.6e-07 $X=151390 $Y=44190 $dt=15
M2056 294 123 VSS! VSS! nfet_01v8 L=1.5e-07 W=7.6e-07 $X=151390 $Y=52470 $dt=15
M2057 295 124 VSS! VSS! nfet_01v8 L=1.5e-07 W=7.6e-07 $X=151390 $Y=60750 $dt=15
M2058 296 125 VSS! VSS! nfet_01v8 L=1.5e-07 W=7.6e-07 $X=151390 $Y=69030 $dt=15
M2059 297 126 VSS! VSS! nfet_01v8 L=1.5e-07 W=7.6e-07 $X=151390 $Y=77310 $dt=15
M2060 298 127 VSS! VSS! nfet_01v8 L=1.5e-07 W=7.6e-07 $X=151390 $Y=85590 $dt=15
M2061 299 128 VSS! VSS! nfet_01v8 L=1.5e-07 W=7.6e-07 $X=151390 $Y=93870 $dt=15
M2062 300 129 VSS! VSS! nfet_01v8 L=1.5e-07 W=7.6e-07 $X=151390 $Y=102150 $dt=15
M2063 301 130 VSS! VSS! nfet_01v8 L=1.5e-07 W=7.6e-07 $X=151390 $Y=110430 $dt=15
M2064 302 131 VSS! VSS! nfet_01v8 L=1.5e-07 W=7.6e-07 $X=151390 $Y=118710 $dt=15
M2065 303 132 VSS! VSS! nfet_01v8 L=1.5e-07 W=7.6e-07 $X=151390 $Y=126990 $dt=15
M2066 304 133 VSS! VSS! nfet_01v8 L=1.5e-07 W=7.6e-07 $X=151390 $Y=135270 $dt=15
M2067 305 134 VSS! VSS! nfet_01v8 L=1.5e-07 W=7.6e-07 $X=151390 $Y=143550 $dt=15
M2068 306 135 VSS! VSS! nfet_01v8 L=1.5e-07 W=7.6e-07 $X=151390 $Y=151830 $dt=15
M2069 307 136 VSS! VSS! nfet_01v8 L=1.5e-07 W=7.6e-07 $X=151390 $Y=160110 $dt=15
M2070 270 251 VSS! VSS! nfet_01v8 L=1.5e-07 W=7.6e-07 $X=151450 $Y=13010 $dt=15
M2071 271 252 VSS! VSS! nfet_01v8 L=1.5e-07 W=7.6e-07 $X=151450 $Y=21290 $dt=15
M2072 272 253 VSS! VSS! nfet_01v8 L=1.5e-07 W=7.6e-07 $X=151450 $Y=29570 $dt=15
M2073 273 254 VSS! VSS! nfet_01v8 L=1.5e-07 W=7.6e-07 $X=151450 $Y=37850 $dt=15
M2074 274 255 VSS! VSS! nfet_01v8 L=1.5e-07 W=7.6e-07 $X=151450 $Y=46130 $dt=15
M2075 275 256 VSS! VSS! nfet_01v8 L=1.5e-07 W=7.6e-07 $X=151450 $Y=54410 $dt=15
M2076 276 257 VSS! VSS! nfet_01v8 L=1.5e-07 W=7.6e-07 $X=151450 $Y=62690 $dt=15
M2077 277 258 VSS! VSS! nfet_01v8 L=1.5e-07 W=7.6e-07 $X=151450 $Y=70970 $dt=15
M2078 278 259 VSS! VSS! nfet_01v8 L=1.5e-07 W=7.6e-07 $X=151450 $Y=79250 $dt=15
M2079 279 260 VSS! VSS! nfet_01v8 L=1.5e-07 W=7.6e-07 $X=151450 $Y=87530 $dt=15
M2080 280 261 VSS! VSS! nfet_01v8 L=1.5e-07 W=7.6e-07 $X=151450 $Y=95810 $dt=15
M2081 281 262 VSS! VSS! nfet_01v8 L=1.5e-07 W=7.6e-07 $X=151450 $Y=104090 $dt=15
M2082 282 263 VSS! VSS! nfet_01v8 L=1.5e-07 W=7.6e-07 $X=151450 $Y=112370 $dt=15
M2083 283 264 VSS! VSS! nfet_01v8 L=1.5e-07 W=7.6e-07 $X=151450 $Y=120650 $dt=15
M2084 284 265 VSS! VSS! nfet_01v8 L=1.5e-07 W=7.6e-07 $X=151450 $Y=128930 $dt=15
M2085 285 266 VSS! VSS! nfet_01v8 L=1.5e-07 W=7.6e-07 $X=151450 $Y=137210 $dt=15
M2086 286 267 VSS! VSS! nfet_01v8 L=1.5e-07 W=7.6e-07 $X=151450 $Y=145490 $dt=15
M2087 287 268 VSS! VSS! nfet_01v8 L=1.5e-07 W=7.6e-07 $X=151450 $Y=153770 $dt=15
M2088 288 269 VSS! VSS! nfet_01v8 L=1.5e-07 W=7.6e-07 $X=151450 $Y=162050 $dt=15
M2089 VSS! 118 289 VSS! nfet_01v8 L=1.5e-07 W=7.6e-07 $X=151820 $Y=11070 $dt=15
M2090 VSS! 119 290 VSS! nfet_01v8 L=1.5e-07 W=7.6e-07 $X=151820 $Y=19350 $dt=15
M2091 VSS! 120 291 VSS! nfet_01v8 L=1.5e-07 W=7.6e-07 $X=151820 $Y=27630 $dt=15
M2092 VSS! 121 292 VSS! nfet_01v8 L=1.5e-07 W=7.6e-07 $X=151820 $Y=35910 $dt=15
M2093 VSS! 122 293 VSS! nfet_01v8 L=1.5e-07 W=7.6e-07 $X=151820 $Y=44190 $dt=15
M2094 VSS! 123 294 VSS! nfet_01v8 L=1.5e-07 W=7.6e-07 $X=151820 $Y=52470 $dt=15
M2095 VSS! 124 295 VSS! nfet_01v8 L=1.5e-07 W=7.6e-07 $X=151820 $Y=60750 $dt=15
M2096 VSS! 125 296 VSS! nfet_01v8 L=1.5e-07 W=7.6e-07 $X=151820 $Y=69030 $dt=15
M2097 VSS! 126 297 VSS! nfet_01v8 L=1.5e-07 W=7.6e-07 $X=151820 $Y=77310 $dt=15
M2098 VSS! 127 298 VSS! nfet_01v8 L=1.5e-07 W=7.6e-07 $X=151820 $Y=85590 $dt=15
M2099 VSS! 128 299 VSS! nfet_01v8 L=1.5e-07 W=7.6e-07 $X=151820 $Y=93870 $dt=15
M2100 VSS! 129 300 VSS! nfet_01v8 L=1.5e-07 W=7.6e-07 $X=151820 $Y=102150 $dt=15
M2101 VSS! 130 301 VSS! nfet_01v8 L=1.5e-07 W=7.6e-07 $X=151820 $Y=110430 $dt=15
M2102 VSS! 131 302 VSS! nfet_01v8 L=1.5e-07 W=7.6e-07 $X=151820 $Y=118710 $dt=15
M2103 VSS! 132 303 VSS! nfet_01v8 L=1.5e-07 W=7.6e-07 $X=151820 $Y=126990 $dt=15
M2104 VSS! 133 304 VSS! nfet_01v8 L=1.5e-07 W=7.6e-07 $X=151820 $Y=135270 $dt=15
M2105 VSS! 134 305 VSS! nfet_01v8 L=1.5e-07 W=7.6e-07 $X=151820 $Y=143550 $dt=15
M2106 VSS! 135 306 VSS! nfet_01v8 L=1.5e-07 W=7.6e-07 $X=151820 $Y=151830 $dt=15
M2107 VSS! 136 307 VSS! nfet_01v8 L=1.5e-07 W=7.6e-07 $X=151820 $Y=160110 $dt=15
M2108 VSS! 251 270 VSS! nfet_01v8 L=1.5e-07 W=7.6e-07 $X=151880 $Y=13010 $dt=15
M2109 VSS! 252 271 VSS! nfet_01v8 L=1.5e-07 W=7.6e-07 $X=151880 $Y=21290 $dt=15
M2110 VSS! 253 272 VSS! nfet_01v8 L=1.5e-07 W=7.6e-07 $X=151880 $Y=29570 $dt=15
M2111 VSS! 254 273 VSS! nfet_01v8 L=1.5e-07 W=7.6e-07 $X=151880 $Y=37850 $dt=15
M2112 VSS! 255 274 VSS! nfet_01v8 L=1.5e-07 W=7.6e-07 $X=151880 $Y=46130 $dt=15
M2113 VSS! 256 275 VSS! nfet_01v8 L=1.5e-07 W=7.6e-07 $X=151880 $Y=54410 $dt=15
M2114 VSS! 257 276 VSS! nfet_01v8 L=1.5e-07 W=7.6e-07 $X=151880 $Y=62690 $dt=15
M2115 VSS! 258 277 VSS! nfet_01v8 L=1.5e-07 W=7.6e-07 $X=151880 $Y=70970 $dt=15
M2116 VSS! 259 278 VSS! nfet_01v8 L=1.5e-07 W=7.6e-07 $X=151880 $Y=79250 $dt=15
M2117 VSS! 260 279 VSS! nfet_01v8 L=1.5e-07 W=7.6e-07 $X=151880 $Y=87530 $dt=15
M2118 VSS! 261 280 VSS! nfet_01v8 L=1.5e-07 W=7.6e-07 $X=151880 $Y=95810 $dt=15
M2119 VSS! 262 281 VSS! nfet_01v8 L=1.5e-07 W=7.6e-07 $X=151880 $Y=104090 $dt=15
M2120 VSS! 263 282 VSS! nfet_01v8 L=1.5e-07 W=7.6e-07 $X=151880 $Y=112370 $dt=15
M2121 VSS! 264 283 VSS! nfet_01v8 L=1.5e-07 W=7.6e-07 $X=151880 $Y=120650 $dt=15
M2122 VSS! 265 284 VSS! nfet_01v8 L=1.5e-07 W=7.6e-07 $X=151880 $Y=128930 $dt=15
M2123 VSS! 266 285 VSS! nfet_01v8 L=1.5e-07 W=7.6e-07 $X=151880 $Y=137210 $dt=15
M2124 VSS! 267 286 VSS! nfet_01v8 L=1.5e-07 W=7.6e-07 $X=151880 $Y=145490 $dt=15
M2125 VSS! 268 287 VSS! nfet_01v8 L=1.5e-07 W=7.6e-07 $X=151880 $Y=153770 $dt=15
M2126 VSS! 269 288 VSS! nfet_01v8 L=1.5e-07 W=7.6e-07 $X=151880 $Y=162050 $dt=15
M2127 289 118 VSS! VSS! nfet_01v8 L=1.5e-07 W=7.6e-07 $X=152250 $Y=11070 $dt=15
M2128 290 119 VSS! VSS! nfet_01v8 L=1.5e-07 W=7.6e-07 $X=152250 $Y=19350 $dt=15
M2129 291 120 VSS! VSS! nfet_01v8 L=1.5e-07 W=7.6e-07 $X=152250 $Y=27630 $dt=15
M2130 292 121 VSS! VSS! nfet_01v8 L=1.5e-07 W=7.6e-07 $X=152250 $Y=35910 $dt=15
M2131 293 122 VSS! VSS! nfet_01v8 L=1.5e-07 W=7.6e-07 $X=152250 $Y=44190 $dt=15
M2132 294 123 VSS! VSS! nfet_01v8 L=1.5e-07 W=7.6e-07 $X=152250 $Y=52470 $dt=15
M2133 295 124 VSS! VSS! nfet_01v8 L=1.5e-07 W=7.6e-07 $X=152250 $Y=60750 $dt=15
M2134 296 125 VSS! VSS! nfet_01v8 L=1.5e-07 W=7.6e-07 $X=152250 $Y=69030 $dt=15
M2135 297 126 VSS! VSS! nfet_01v8 L=1.5e-07 W=7.6e-07 $X=152250 $Y=77310 $dt=15
M2136 298 127 VSS! VSS! nfet_01v8 L=1.5e-07 W=7.6e-07 $X=152250 $Y=85590 $dt=15
M2137 299 128 VSS! VSS! nfet_01v8 L=1.5e-07 W=7.6e-07 $X=152250 $Y=93870 $dt=15
M2138 300 129 VSS! VSS! nfet_01v8 L=1.5e-07 W=7.6e-07 $X=152250 $Y=102150 $dt=15
M2139 301 130 VSS! VSS! nfet_01v8 L=1.5e-07 W=7.6e-07 $X=152250 $Y=110430 $dt=15
M2140 302 131 VSS! VSS! nfet_01v8 L=1.5e-07 W=7.6e-07 $X=152250 $Y=118710 $dt=15
M2141 303 132 VSS! VSS! nfet_01v8 L=1.5e-07 W=7.6e-07 $X=152250 $Y=126990 $dt=15
M2142 304 133 VSS! VSS! nfet_01v8 L=1.5e-07 W=7.6e-07 $X=152250 $Y=135270 $dt=15
M2143 305 134 VSS! VSS! nfet_01v8 L=1.5e-07 W=7.6e-07 $X=152250 $Y=143550 $dt=15
M2144 306 135 VSS! VSS! nfet_01v8 L=1.5e-07 W=7.6e-07 $X=152250 $Y=151830 $dt=15
M2145 307 136 VSS! VSS! nfet_01v8 L=1.5e-07 W=7.6e-07 $X=152250 $Y=160110 $dt=15
M2146 270 251 VSS! VSS! nfet_01v8 L=1.5e-07 W=7.6e-07 $X=152310 $Y=13010 $dt=15
M2147 271 252 VSS! VSS! nfet_01v8 L=1.5e-07 W=7.6e-07 $X=152310 $Y=21290 $dt=15
M2148 272 253 VSS! VSS! nfet_01v8 L=1.5e-07 W=7.6e-07 $X=152310 $Y=29570 $dt=15
M2149 273 254 VSS! VSS! nfet_01v8 L=1.5e-07 W=7.6e-07 $X=152310 $Y=37850 $dt=15
M2150 274 255 VSS! VSS! nfet_01v8 L=1.5e-07 W=7.6e-07 $X=152310 $Y=46130 $dt=15
M2151 275 256 VSS! VSS! nfet_01v8 L=1.5e-07 W=7.6e-07 $X=152310 $Y=54410 $dt=15
M2152 276 257 VSS! VSS! nfet_01v8 L=1.5e-07 W=7.6e-07 $X=152310 $Y=62690 $dt=15
M2153 277 258 VSS! VSS! nfet_01v8 L=1.5e-07 W=7.6e-07 $X=152310 $Y=70970 $dt=15
M2154 278 259 VSS! VSS! nfet_01v8 L=1.5e-07 W=7.6e-07 $X=152310 $Y=79250 $dt=15
M2155 279 260 VSS! VSS! nfet_01v8 L=1.5e-07 W=7.6e-07 $X=152310 $Y=87530 $dt=15
M2156 280 261 VSS! VSS! nfet_01v8 L=1.5e-07 W=7.6e-07 $X=152310 $Y=95810 $dt=15
M2157 281 262 VSS! VSS! nfet_01v8 L=1.5e-07 W=7.6e-07 $X=152310 $Y=104090 $dt=15
M2158 282 263 VSS! VSS! nfet_01v8 L=1.5e-07 W=7.6e-07 $X=152310 $Y=112370 $dt=15
M2159 283 264 VSS! VSS! nfet_01v8 L=1.5e-07 W=7.6e-07 $X=152310 $Y=120650 $dt=15
M2160 284 265 VSS! VSS! nfet_01v8 L=1.5e-07 W=7.6e-07 $X=152310 $Y=128930 $dt=15
M2161 285 266 VSS! VSS! nfet_01v8 L=1.5e-07 W=7.6e-07 $X=152310 $Y=137210 $dt=15
M2162 286 267 VSS! VSS! nfet_01v8 L=1.5e-07 W=7.6e-07 $X=152310 $Y=145490 $dt=15
M2163 287 268 VSS! VSS! nfet_01v8 L=1.5e-07 W=7.6e-07 $X=152310 $Y=153770 $dt=15
M2164 288 269 VSS! VSS! nfet_01v8 L=1.5e-07 W=7.6e-07 $X=152310 $Y=162050 $dt=15
M2165 VSS! 118 289 VSS! nfet_01v8 L=1.5e-07 W=7.6e-07 $X=152680 $Y=11070 $dt=15
M2166 VSS! 119 290 VSS! nfet_01v8 L=1.5e-07 W=7.6e-07 $X=152680 $Y=19350 $dt=15
M2167 VSS! 120 291 VSS! nfet_01v8 L=1.5e-07 W=7.6e-07 $X=152680 $Y=27630 $dt=15
M2168 VSS! 121 292 VSS! nfet_01v8 L=1.5e-07 W=7.6e-07 $X=152680 $Y=35910 $dt=15
M2169 VSS! 122 293 VSS! nfet_01v8 L=1.5e-07 W=7.6e-07 $X=152680 $Y=44190 $dt=15
M2170 VSS! 123 294 VSS! nfet_01v8 L=1.5e-07 W=7.6e-07 $X=152680 $Y=52470 $dt=15
M2171 VSS! 124 295 VSS! nfet_01v8 L=1.5e-07 W=7.6e-07 $X=152680 $Y=60750 $dt=15
M2172 VSS! 125 296 VSS! nfet_01v8 L=1.5e-07 W=7.6e-07 $X=152680 $Y=69030 $dt=15
M2173 VSS! 126 297 VSS! nfet_01v8 L=1.5e-07 W=7.6e-07 $X=152680 $Y=77310 $dt=15
M2174 VSS! 127 298 VSS! nfet_01v8 L=1.5e-07 W=7.6e-07 $X=152680 $Y=85590 $dt=15
M2175 VSS! 128 299 VSS! nfet_01v8 L=1.5e-07 W=7.6e-07 $X=152680 $Y=93870 $dt=15
M2176 VSS! 129 300 VSS! nfet_01v8 L=1.5e-07 W=7.6e-07 $X=152680 $Y=102150 $dt=15
M2177 VSS! 130 301 VSS! nfet_01v8 L=1.5e-07 W=7.6e-07 $X=152680 $Y=110430 $dt=15
M2178 VSS! 131 302 VSS! nfet_01v8 L=1.5e-07 W=7.6e-07 $X=152680 $Y=118710 $dt=15
M2179 VSS! 132 303 VSS! nfet_01v8 L=1.5e-07 W=7.6e-07 $X=152680 $Y=126990 $dt=15
M2180 VSS! 133 304 VSS! nfet_01v8 L=1.5e-07 W=7.6e-07 $X=152680 $Y=135270 $dt=15
M2181 VSS! 134 305 VSS! nfet_01v8 L=1.5e-07 W=7.6e-07 $X=152680 $Y=143550 $dt=15
M2182 VSS! 135 306 VSS! nfet_01v8 L=1.5e-07 W=7.6e-07 $X=152680 $Y=151830 $dt=15
M2183 VSS! 136 307 VSS! nfet_01v8 L=1.5e-07 W=7.6e-07 $X=152680 $Y=160110 $dt=15
M2184 VSS! 251 270 VSS! nfet_01v8 L=1.5e-07 W=7.6e-07 $X=152740 $Y=13010 $dt=15
M2185 VSS! 252 271 VSS! nfet_01v8 L=1.5e-07 W=7.6e-07 $X=152740 $Y=21290 $dt=15
M2186 VSS! 253 272 VSS! nfet_01v8 L=1.5e-07 W=7.6e-07 $X=152740 $Y=29570 $dt=15
M2187 VSS! 254 273 VSS! nfet_01v8 L=1.5e-07 W=7.6e-07 $X=152740 $Y=37850 $dt=15
M2188 VSS! 255 274 VSS! nfet_01v8 L=1.5e-07 W=7.6e-07 $X=152740 $Y=46130 $dt=15
M2189 VSS! 256 275 VSS! nfet_01v8 L=1.5e-07 W=7.6e-07 $X=152740 $Y=54410 $dt=15
M2190 VSS! 257 276 VSS! nfet_01v8 L=1.5e-07 W=7.6e-07 $X=152740 $Y=62690 $dt=15
M2191 VSS! 258 277 VSS! nfet_01v8 L=1.5e-07 W=7.6e-07 $X=152740 $Y=70970 $dt=15
M2192 VSS! 259 278 VSS! nfet_01v8 L=1.5e-07 W=7.6e-07 $X=152740 $Y=79250 $dt=15
M2193 VSS! 260 279 VSS! nfet_01v8 L=1.5e-07 W=7.6e-07 $X=152740 $Y=87530 $dt=15
M2194 VSS! 261 280 VSS! nfet_01v8 L=1.5e-07 W=7.6e-07 $X=152740 $Y=95810 $dt=15
M2195 VSS! 262 281 VSS! nfet_01v8 L=1.5e-07 W=7.6e-07 $X=152740 $Y=104090 $dt=15
M2196 VSS! 263 282 VSS! nfet_01v8 L=1.5e-07 W=7.6e-07 $X=152740 $Y=112370 $dt=15
M2197 VSS! 264 283 VSS! nfet_01v8 L=1.5e-07 W=7.6e-07 $X=152740 $Y=120650 $dt=15
M2198 VSS! 265 284 VSS! nfet_01v8 L=1.5e-07 W=7.6e-07 $X=152740 $Y=128930 $dt=15
M2199 VSS! 266 285 VSS! nfet_01v8 L=1.5e-07 W=7.6e-07 $X=152740 $Y=137210 $dt=15
M2200 VSS! 267 286 VSS! nfet_01v8 L=1.5e-07 W=7.6e-07 $X=152740 $Y=145490 $dt=15
M2201 VSS! 268 287 VSS! nfet_01v8 L=1.5e-07 W=7.6e-07 $X=152740 $Y=153770 $dt=15
M2202 VSS! 269 288 VSS! nfet_01v8 L=1.5e-07 W=7.6e-07 $X=152740 $Y=162050 $dt=15
M2203 289 118 VSS! VSS! nfet_01v8 L=1.5e-07 W=7.6e-07 $X=153110 $Y=11070 $dt=15
M2204 290 119 VSS! VSS! nfet_01v8 L=1.5e-07 W=7.6e-07 $X=153110 $Y=19350 $dt=15
M2205 291 120 VSS! VSS! nfet_01v8 L=1.5e-07 W=7.6e-07 $X=153110 $Y=27630 $dt=15
M2206 292 121 VSS! VSS! nfet_01v8 L=1.5e-07 W=7.6e-07 $X=153110 $Y=35910 $dt=15
M2207 293 122 VSS! VSS! nfet_01v8 L=1.5e-07 W=7.6e-07 $X=153110 $Y=44190 $dt=15
M2208 294 123 VSS! VSS! nfet_01v8 L=1.5e-07 W=7.6e-07 $X=153110 $Y=52470 $dt=15
M2209 295 124 VSS! VSS! nfet_01v8 L=1.5e-07 W=7.6e-07 $X=153110 $Y=60750 $dt=15
M2210 296 125 VSS! VSS! nfet_01v8 L=1.5e-07 W=7.6e-07 $X=153110 $Y=69030 $dt=15
M2211 297 126 VSS! VSS! nfet_01v8 L=1.5e-07 W=7.6e-07 $X=153110 $Y=77310 $dt=15
M2212 298 127 VSS! VSS! nfet_01v8 L=1.5e-07 W=7.6e-07 $X=153110 $Y=85590 $dt=15
M2213 299 128 VSS! VSS! nfet_01v8 L=1.5e-07 W=7.6e-07 $X=153110 $Y=93870 $dt=15
M2214 300 129 VSS! VSS! nfet_01v8 L=1.5e-07 W=7.6e-07 $X=153110 $Y=102150 $dt=15
M2215 301 130 VSS! VSS! nfet_01v8 L=1.5e-07 W=7.6e-07 $X=153110 $Y=110430 $dt=15
M2216 302 131 VSS! VSS! nfet_01v8 L=1.5e-07 W=7.6e-07 $X=153110 $Y=118710 $dt=15
M2217 303 132 VSS! VSS! nfet_01v8 L=1.5e-07 W=7.6e-07 $X=153110 $Y=126990 $dt=15
M2218 304 133 VSS! VSS! nfet_01v8 L=1.5e-07 W=7.6e-07 $X=153110 $Y=135270 $dt=15
M2219 305 134 VSS! VSS! nfet_01v8 L=1.5e-07 W=7.6e-07 $X=153110 $Y=143550 $dt=15
M2220 306 135 VSS! VSS! nfet_01v8 L=1.5e-07 W=7.6e-07 $X=153110 $Y=151830 $dt=15
M2221 307 136 VSS! VSS! nfet_01v8 L=1.5e-07 W=7.6e-07 $X=153110 $Y=160110 $dt=15
M2222 270 251 VSS! VSS! nfet_01v8 L=1.5e-07 W=7.6e-07 $X=153170 $Y=13010 $dt=15
M2223 271 252 VSS! VSS! nfet_01v8 L=1.5e-07 W=7.6e-07 $X=153170 $Y=21290 $dt=15
M2224 272 253 VSS! VSS! nfet_01v8 L=1.5e-07 W=7.6e-07 $X=153170 $Y=29570 $dt=15
M2225 273 254 VSS! VSS! nfet_01v8 L=1.5e-07 W=7.6e-07 $X=153170 $Y=37850 $dt=15
M2226 274 255 VSS! VSS! nfet_01v8 L=1.5e-07 W=7.6e-07 $X=153170 $Y=46130 $dt=15
M2227 275 256 VSS! VSS! nfet_01v8 L=1.5e-07 W=7.6e-07 $X=153170 $Y=54410 $dt=15
M2228 276 257 VSS! VSS! nfet_01v8 L=1.5e-07 W=7.6e-07 $X=153170 $Y=62690 $dt=15
M2229 277 258 VSS! VSS! nfet_01v8 L=1.5e-07 W=7.6e-07 $X=153170 $Y=70970 $dt=15
M2230 278 259 VSS! VSS! nfet_01v8 L=1.5e-07 W=7.6e-07 $X=153170 $Y=79250 $dt=15
M2231 279 260 VSS! VSS! nfet_01v8 L=1.5e-07 W=7.6e-07 $X=153170 $Y=87530 $dt=15
M2232 280 261 VSS! VSS! nfet_01v8 L=1.5e-07 W=7.6e-07 $X=153170 $Y=95810 $dt=15
M2233 281 262 VSS! VSS! nfet_01v8 L=1.5e-07 W=7.6e-07 $X=153170 $Y=104090 $dt=15
M2234 282 263 VSS! VSS! nfet_01v8 L=1.5e-07 W=7.6e-07 $X=153170 $Y=112370 $dt=15
M2235 283 264 VSS! VSS! nfet_01v8 L=1.5e-07 W=7.6e-07 $X=153170 $Y=120650 $dt=15
M2236 284 265 VSS! VSS! nfet_01v8 L=1.5e-07 W=7.6e-07 $X=153170 $Y=128930 $dt=15
M2237 285 266 VSS! VSS! nfet_01v8 L=1.5e-07 W=7.6e-07 $X=153170 $Y=137210 $dt=15
M2238 286 267 VSS! VSS! nfet_01v8 L=1.5e-07 W=7.6e-07 $X=153170 $Y=145490 $dt=15
M2239 287 268 VSS! VSS! nfet_01v8 L=1.5e-07 W=7.6e-07 $X=153170 $Y=153770 $dt=15
M2240 288 269 VSS! VSS! nfet_01v8 L=1.5e-07 W=7.6e-07 $X=153170 $Y=162050 $dt=15
M2241 VSS! 118 289 VSS! nfet_01v8 L=1.5e-07 W=7.6e-07 $X=153540 $Y=11070 $dt=15
M2242 VSS! 119 290 VSS! nfet_01v8 L=1.5e-07 W=7.6e-07 $X=153540 $Y=19350 $dt=15
M2243 VSS! 120 291 VSS! nfet_01v8 L=1.5e-07 W=7.6e-07 $X=153540 $Y=27630 $dt=15
M2244 VSS! 121 292 VSS! nfet_01v8 L=1.5e-07 W=7.6e-07 $X=153540 $Y=35910 $dt=15
M2245 VSS! 122 293 VSS! nfet_01v8 L=1.5e-07 W=7.6e-07 $X=153540 $Y=44190 $dt=15
M2246 VSS! 123 294 VSS! nfet_01v8 L=1.5e-07 W=7.6e-07 $X=153540 $Y=52470 $dt=15
M2247 VSS! 124 295 VSS! nfet_01v8 L=1.5e-07 W=7.6e-07 $X=153540 $Y=60750 $dt=15
M2248 VSS! 125 296 VSS! nfet_01v8 L=1.5e-07 W=7.6e-07 $X=153540 $Y=69030 $dt=15
M2249 VSS! 126 297 VSS! nfet_01v8 L=1.5e-07 W=7.6e-07 $X=153540 $Y=77310 $dt=15
M2250 VSS! 127 298 VSS! nfet_01v8 L=1.5e-07 W=7.6e-07 $X=153540 $Y=85590 $dt=15
M2251 VSS! 128 299 VSS! nfet_01v8 L=1.5e-07 W=7.6e-07 $X=153540 $Y=93870 $dt=15
M2252 VSS! 129 300 VSS! nfet_01v8 L=1.5e-07 W=7.6e-07 $X=153540 $Y=102150 $dt=15
M2253 VSS! 130 301 VSS! nfet_01v8 L=1.5e-07 W=7.6e-07 $X=153540 $Y=110430 $dt=15
M2254 VSS! 131 302 VSS! nfet_01v8 L=1.5e-07 W=7.6e-07 $X=153540 $Y=118710 $dt=15
M2255 VSS! 132 303 VSS! nfet_01v8 L=1.5e-07 W=7.6e-07 $X=153540 $Y=126990 $dt=15
M2256 VSS! 133 304 VSS! nfet_01v8 L=1.5e-07 W=7.6e-07 $X=153540 $Y=135270 $dt=15
M2257 VSS! 134 305 VSS! nfet_01v8 L=1.5e-07 W=7.6e-07 $X=153540 $Y=143550 $dt=15
M2258 VSS! 135 306 VSS! nfet_01v8 L=1.5e-07 W=7.6e-07 $X=153540 $Y=151830 $dt=15
M2259 VSS! 136 307 VSS! nfet_01v8 L=1.5e-07 W=7.6e-07 $X=153540 $Y=160110 $dt=15
M2260 VSS! 251 270 VSS! nfet_01v8 L=1.5e-07 W=7.6e-07 $X=153600 $Y=13010 $dt=15
M2261 VSS! 252 271 VSS! nfet_01v8 L=1.5e-07 W=7.6e-07 $X=153600 $Y=21290 $dt=15
M2262 VSS! 253 272 VSS! nfet_01v8 L=1.5e-07 W=7.6e-07 $X=153600 $Y=29570 $dt=15
M2263 VSS! 254 273 VSS! nfet_01v8 L=1.5e-07 W=7.6e-07 $X=153600 $Y=37850 $dt=15
M2264 VSS! 255 274 VSS! nfet_01v8 L=1.5e-07 W=7.6e-07 $X=153600 $Y=46130 $dt=15
M2265 VSS! 256 275 VSS! nfet_01v8 L=1.5e-07 W=7.6e-07 $X=153600 $Y=54410 $dt=15
M2266 VSS! 257 276 VSS! nfet_01v8 L=1.5e-07 W=7.6e-07 $X=153600 $Y=62690 $dt=15
M2267 VSS! 258 277 VSS! nfet_01v8 L=1.5e-07 W=7.6e-07 $X=153600 $Y=70970 $dt=15
M2268 VSS! 259 278 VSS! nfet_01v8 L=1.5e-07 W=7.6e-07 $X=153600 $Y=79250 $dt=15
M2269 VSS! 260 279 VSS! nfet_01v8 L=1.5e-07 W=7.6e-07 $X=153600 $Y=87530 $dt=15
M2270 VSS! 261 280 VSS! nfet_01v8 L=1.5e-07 W=7.6e-07 $X=153600 $Y=95810 $dt=15
M2271 VSS! 262 281 VSS! nfet_01v8 L=1.5e-07 W=7.6e-07 $X=153600 $Y=104090 $dt=15
M2272 VSS! 263 282 VSS! nfet_01v8 L=1.5e-07 W=7.6e-07 $X=153600 $Y=112370 $dt=15
M2273 VSS! 264 283 VSS! nfet_01v8 L=1.5e-07 W=7.6e-07 $X=153600 $Y=120650 $dt=15
M2274 VSS! 265 284 VSS! nfet_01v8 L=1.5e-07 W=7.6e-07 $X=153600 $Y=128930 $dt=15
M2275 VSS! 266 285 VSS! nfet_01v8 L=1.5e-07 W=7.6e-07 $X=153600 $Y=137210 $dt=15
M2276 VSS! 267 286 VSS! nfet_01v8 L=1.5e-07 W=7.6e-07 $X=153600 $Y=145490 $dt=15
M2277 VSS! 268 287 VSS! nfet_01v8 L=1.5e-07 W=7.6e-07 $X=153600 $Y=153770 $dt=15
M2278 VSS! 269 288 VSS! nfet_01v8 L=1.5e-07 W=7.6e-07 $X=153600 $Y=162050 $dt=15
M2279 251 118 VSS! VSS! nfet_01v8 L=1.5e-07 W=7.6e-07 $X=154030 $Y=13010 $dt=15
M2280 252 119 VSS! VSS! nfet_01v8 L=1.5e-07 W=7.6e-07 $X=154030 $Y=21290 $dt=15
M2281 253 120 VSS! VSS! nfet_01v8 L=1.5e-07 W=7.6e-07 $X=154030 $Y=29570 $dt=15
M2282 254 121 VSS! VSS! nfet_01v8 L=1.5e-07 W=7.6e-07 $X=154030 $Y=37850 $dt=15
M2283 255 122 VSS! VSS! nfet_01v8 L=1.5e-07 W=7.6e-07 $X=154030 $Y=46130 $dt=15
M2284 256 123 VSS! VSS! nfet_01v8 L=1.5e-07 W=7.6e-07 $X=154030 $Y=54410 $dt=15
M2285 257 124 VSS! VSS! nfet_01v8 L=1.5e-07 W=7.6e-07 $X=154030 $Y=62690 $dt=15
M2286 258 125 VSS! VSS! nfet_01v8 L=1.5e-07 W=7.6e-07 $X=154030 $Y=70970 $dt=15
M2287 259 126 VSS! VSS! nfet_01v8 L=1.5e-07 W=7.6e-07 $X=154030 $Y=79250 $dt=15
M2288 260 127 VSS! VSS! nfet_01v8 L=1.5e-07 W=7.6e-07 $X=154030 $Y=87530 $dt=15
M2289 261 128 VSS! VSS! nfet_01v8 L=1.5e-07 W=7.6e-07 $X=154030 $Y=95810 $dt=15
M2290 262 129 VSS! VSS! nfet_01v8 L=1.5e-07 W=7.6e-07 $X=154030 $Y=104090 $dt=15
M2291 263 130 VSS! VSS! nfet_01v8 L=1.5e-07 W=7.6e-07 $X=154030 $Y=112370 $dt=15
M2292 264 131 VSS! VSS! nfet_01v8 L=1.5e-07 W=7.6e-07 $X=154030 $Y=120650 $dt=15
M2293 265 132 VSS! VSS! nfet_01v8 L=1.5e-07 W=7.6e-07 $X=154030 $Y=128930 $dt=15
M2294 266 133 VSS! VSS! nfet_01v8 L=1.5e-07 W=7.6e-07 $X=154030 $Y=137210 $dt=15
M2295 267 134 VSS! VSS! nfet_01v8 L=1.5e-07 W=7.6e-07 $X=154030 $Y=145490 $dt=15
M2296 268 135 VSS! VSS! nfet_01v8 L=1.5e-07 W=7.6e-07 $X=154030 $Y=153770 $dt=15
M2297 269 136 VSS! VSS! nfet_01v8 L=1.5e-07 W=7.6e-07 $X=154030 $Y=162050 $dt=15
M2298 VSS! 118 251 VSS! nfet_01v8 L=1.5e-07 W=7.6e-07 $X=154460 $Y=13010 $dt=15
M2299 VSS! 119 252 VSS! nfet_01v8 L=1.5e-07 W=7.6e-07 $X=154460 $Y=21290 $dt=15
M2300 VSS! 120 253 VSS! nfet_01v8 L=1.5e-07 W=7.6e-07 $X=154460 $Y=29570 $dt=15
M2301 VSS! 121 254 VSS! nfet_01v8 L=1.5e-07 W=7.6e-07 $X=154460 $Y=37850 $dt=15
M2302 VSS! 122 255 VSS! nfet_01v8 L=1.5e-07 W=7.6e-07 $X=154460 $Y=46130 $dt=15
M2303 VSS! 123 256 VSS! nfet_01v8 L=1.5e-07 W=7.6e-07 $X=154460 $Y=54410 $dt=15
M2304 VSS! 124 257 VSS! nfet_01v8 L=1.5e-07 W=7.6e-07 $X=154460 $Y=62690 $dt=15
M2305 VSS! 125 258 VSS! nfet_01v8 L=1.5e-07 W=7.6e-07 $X=154460 $Y=70970 $dt=15
M2306 VSS! 126 259 VSS! nfet_01v8 L=1.5e-07 W=7.6e-07 $X=154460 $Y=79250 $dt=15
M2307 VSS! 127 260 VSS! nfet_01v8 L=1.5e-07 W=7.6e-07 $X=154460 $Y=87530 $dt=15
M2308 VSS! 128 261 VSS! nfet_01v8 L=1.5e-07 W=7.6e-07 $X=154460 $Y=95810 $dt=15
M2309 VSS! 129 262 VSS! nfet_01v8 L=1.5e-07 W=7.6e-07 $X=154460 $Y=104090 $dt=15
M2310 VSS! 130 263 VSS! nfet_01v8 L=1.5e-07 W=7.6e-07 $X=154460 $Y=112370 $dt=15
M2311 VSS! 131 264 VSS! nfet_01v8 L=1.5e-07 W=7.6e-07 $X=154460 $Y=120650 $dt=15
M2312 VSS! 132 265 VSS! nfet_01v8 L=1.5e-07 W=7.6e-07 $X=154460 $Y=128930 $dt=15
M2313 VSS! 133 266 VSS! nfet_01v8 L=1.5e-07 W=7.6e-07 $X=154460 $Y=137210 $dt=15
M2314 VSS! 134 267 VSS! nfet_01v8 L=1.5e-07 W=7.6e-07 $X=154460 $Y=145490 $dt=15
M2315 VSS! 135 268 VSS! nfet_01v8 L=1.5e-07 W=7.6e-07 $X=154460 $Y=153770 $dt=15
M2316 VSS! 136 269 VSS! nfet_01v8 L=1.5e-07 W=7.6e-07 $X=154460 $Y=162050 $dt=15
M2317 232 194 VSS! VSS! nfet_01v8 L=1.5e-07 W=7.6e-07 $X=155500 $Y=13010 $dt=15
M2318 233 195 VSS! VSS! nfet_01v8 L=1.5e-07 W=7.6e-07 $X=155500 $Y=21290 $dt=15
M2319 234 196 VSS! VSS! nfet_01v8 L=1.5e-07 W=7.6e-07 $X=155500 $Y=29570 $dt=15
M2320 235 197 VSS! VSS! nfet_01v8 L=1.5e-07 W=7.6e-07 $X=155500 $Y=37850 $dt=15
M2321 236 198 VSS! VSS! nfet_01v8 L=1.5e-07 W=7.6e-07 $X=155500 $Y=46130 $dt=15
M2322 237 199 VSS! VSS! nfet_01v8 L=1.5e-07 W=7.6e-07 $X=155500 $Y=54410 $dt=15
M2323 238 200 VSS! VSS! nfet_01v8 L=1.5e-07 W=7.6e-07 $X=155500 $Y=62690 $dt=15
M2324 239 201 VSS! VSS! nfet_01v8 L=1.5e-07 W=7.6e-07 $X=155500 $Y=70970 $dt=15
M2325 240 202 VSS! VSS! nfet_01v8 L=1.5e-07 W=7.6e-07 $X=155500 $Y=79250 $dt=15
M2326 241 203 VSS! VSS! nfet_01v8 L=1.5e-07 W=7.6e-07 $X=155500 $Y=87530 $dt=15
M2327 242 204 VSS! VSS! nfet_01v8 L=1.5e-07 W=7.6e-07 $X=155500 $Y=95810 $dt=15
M2328 243 205 VSS! VSS! nfet_01v8 L=1.5e-07 W=7.6e-07 $X=155500 $Y=104090 $dt=15
M2329 244 206 VSS! VSS! nfet_01v8 L=1.5e-07 W=7.6e-07 $X=155500 $Y=112370 $dt=15
M2330 245 207 VSS! VSS! nfet_01v8 L=1.5e-07 W=7.6e-07 $X=155500 $Y=120650 $dt=15
M2331 246 208 VSS! VSS! nfet_01v8 L=1.5e-07 W=7.6e-07 $X=155500 $Y=128930 $dt=15
M2332 247 209 VSS! VSS! nfet_01v8 L=1.5e-07 W=7.6e-07 $X=155500 $Y=137210 $dt=15
M2333 248 210 VSS! VSS! nfet_01v8 L=1.5e-07 W=7.6e-07 $X=155500 $Y=145490 $dt=15
M2334 249 211 VSS! VSS! nfet_01v8 L=1.5e-07 W=7.6e-07 $X=155500 $Y=153770 $dt=15
M2335 250 212 VSS! VSS! nfet_01v8 L=1.5e-07 W=7.6e-07 $X=155500 $Y=162050 $dt=15
M2336 213 99 VSS! VSS! nfet_01v8 L=1.5e-07 W=7.6e-07 $X=155930 $Y=11070 $dt=15
M2337 VSS! 194 232 VSS! nfet_01v8 L=1.5e-07 W=7.6e-07 $X=155930 $Y=13010 $dt=15
M2338 214 100 VSS! VSS! nfet_01v8 L=1.5e-07 W=7.6e-07 $X=155930 $Y=19350 $dt=15
M2339 VSS! 195 233 VSS! nfet_01v8 L=1.5e-07 W=7.6e-07 $X=155930 $Y=21290 $dt=15
M2340 215 101 VSS! VSS! nfet_01v8 L=1.5e-07 W=7.6e-07 $X=155930 $Y=27630 $dt=15
M2341 VSS! 196 234 VSS! nfet_01v8 L=1.5e-07 W=7.6e-07 $X=155930 $Y=29570 $dt=15
M2342 216 102 VSS! VSS! nfet_01v8 L=1.5e-07 W=7.6e-07 $X=155930 $Y=35910 $dt=15
M2343 VSS! 197 235 VSS! nfet_01v8 L=1.5e-07 W=7.6e-07 $X=155930 $Y=37850 $dt=15
M2344 217 103 VSS! VSS! nfet_01v8 L=1.5e-07 W=7.6e-07 $X=155930 $Y=44190 $dt=15
M2345 VSS! 198 236 VSS! nfet_01v8 L=1.5e-07 W=7.6e-07 $X=155930 $Y=46130 $dt=15
M2346 218 104 VSS! VSS! nfet_01v8 L=1.5e-07 W=7.6e-07 $X=155930 $Y=52470 $dt=15
M2347 VSS! 199 237 VSS! nfet_01v8 L=1.5e-07 W=7.6e-07 $X=155930 $Y=54410 $dt=15
M2348 219 105 VSS! VSS! nfet_01v8 L=1.5e-07 W=7.6e-07 $X=155930 $Y=60750 $dt=15
M2349 VSS! 200 238 VSS! nfet_01v8 L=1.5e-07 W=7.6e-07 $X=155930 $Y=62690 $dt=15
M2350 220 106 VSS! VSS! nfet_01v8 L=1.5e-07 W=7.6e-07 $X=155930 $Y=69030 $dt=15
M2351 VSS! 201 239 VSS! nfet_01v8 L=1.5e-07 W=7.6e-07 $X=155930 $Y=70970 $dt=15
M2352 221 107 VSS! VSS! nfet_01v8 L=1.5e-07 W=7.6e-07 $X=155930 $Y=77310 $dt=15
M2353 VSS! 202 240 VSS! nfet_01v8 L=1.5e-07 W=7.6e-07 $X=155930 $Y=79250 $dt=15
M2354 222 108 VSS! VSS! nfet_01v8 L=1.5e-07 W=7.6e-07 $X=155930 $Y=85590 $dt=15
M2355 VSS! 203 241 VSS! nfet_01v8 L=1.5e-07 W=7.6e-07 $X=155930 $Y=87530 $dt=15
M2356 223 109 VSS! VSS! nfet_01v8 L=1.5e-07 W=7.6e-07 $X=155930 $Y=93870 $dt=15
M2357 VSS! 204 242 VSS! nfet_01v8 L=1.5e-07 W=7.6e-07 $X=155930 $Y=95810 $dt=15
M2358 224 110 VSS! VSS! nfet_01v8 L=1.5e-07 W=7.6e-07 $X=155930 $Y=102150 $dt=15
M2359 VSS! 205 243 VSS! nfet_01v8 L=1.5e-07 W=7.6e-07 $X=155930 $Y=104090 $dt=15
M2360 225 111 VSS! VSS! nfet_01v8 L=1.5e-07 W=7.6e-07 $X=155930 $Y=110430 $dt=15
M2361 VSS! 206 244 VSS! nfet_01v8 L=1.5e-07 W=7.6e-07 $X=155930 $Y=112370 $dt=15
M2362 226 112 VSS! VSS! nfet_01v8 L=1.5e-07 W=7.6e-07 $X=155930 $Y=118710 $dt=15
M2363 VSS! 207 245 VSS! nfet_01v8 L=1.5e-07 W=7.6e-07 $X=155930 $Y=120650 $dt=15
M2364 227 113 VSS! VSS! nfet_01v8 L=1.5e-07 W=7.6e-07 $X=155930 $Y=126990 $dt=15
M2365 VSS! 208 246 VSS! nfet_01v8 L=1.5e-07 W=7.6e-07 $X=155930 $Y=128930 $dt=15
M2366 228 114 VSS! VSS! nfet_01v8 L=1.5e-07 W=7.6e-07 $X=155930 $Y=135270 $dt=15
M2367 VSS! 209 247 VSS! nfet_01v8 L=1.5e-07 W=7.6e-07 $X=155930 $Y=137210 $dt=15
M2368 229 115 VSS! VSS! nfet_01v8 L=1.5e-07 W=7.6e-07 $X=155930 $Y=143550 $dt=15
M2369 VSS! 210 248 VSS! nfet_01v8 L=1.5e-07 W=7.6e-07 $X=155930 $Y=145490 $dt=15
M2370 230 116 VSS! VSS! nfet_01v8 L=1.5e-07 W=7.6e-07 $X=155930 $Y=151830 $dt=15
M2371 VSS! 211 249 VSS! nfet_01v8 L=1.5e-07 W=7.6e-07 $X=155930 $Y=153770 $dt=15
M2372 231 117 VSS! VSS! nfet_01v8 L=1.5e-07 W=7.6e-07 $X=155930 $Y=160110 $dt=15
M2373 VSS! 212 250 VSS! nfet_01v8 L=1.5e-07 W=7.6e-07 $X=155930 $Y=162050 $dt=15
M2374 VSS! 99 213 VSS! nfet_01v8 L=1.5e-07 W=7.6e-07 $X=156360 $Y=11070 $dt=15
M2375 232 194 VSS! VSS! nfet_01v8 L=1.5e-07 W=7.6e-07 $X=156360 $Y=13010 $dt=15
M2376 VSS! 100 214 VSS! nfet_01v8 L=1.5e-07 W=7.6e-07 $X=156360 $Y=19350 $dt=15
M2377 233 195 VSS! VSS! nfet_01v8 L=1.5e-07 W=7.6e-07 $X=156360 $Y=21290 $dt=15
M2378 VSS! 101 215 VSS! nfet_01v8 L=1.5e-07 W=7.6e-07 $X=156360 $Y=27630 $dt=15
M2379 234 196 VSS! VSS! nfet_01v8 L=1.5e-07 W=7.6e-07 $X=156360 $Y=29570 $dt=15
M2380 VSS! 102 216 VSS! nfet_01v8 L=1.5e-07 W=7.6e-07 $X=156360 $Y=35910 $dt=15
M2381 235 197 VSS! VSS! nfet_01v8 L=1.5e-07 W=7.6e-07 $X=156360 $Y=37850 $dt=15
M2382 VSS! 103 217 VSS! nfet_01v8 L=1.5e-07 W=7.6e-07 $X=156360 $Y=44190 $dt=15
M2383 236 198 VSS! VSS! nfet_01v8 L=1.5e-07 W=7.6e-07 $X=156360 $Y=46130 $dt=15
M2384 VSS! 104 218 VSS! nfet_01v8 L=1.5e-07 W=7.6e-07 $X=156360 $Y=52470 $dt=15
M2385 237 199 VSS! VSS! nfet_01v8 L=1.5e-07 W=7.6e-07 $X=156360 $Y=54410 $dt=15
M2386 VSS! 105 219 VSS! nfet_01v8 L=1.5e-07 W=7.6e-07 $X=156360 $Y=60750 $dt=15
M2387 238 200 VSS! VSS! nfet_01v8 L=1.5e-07 W=7.6e-07 $X=156360 $Y=62690 $dt=15
M2388 VSS! 106 220 VSS! nfet_01v8 L=1.5e-07 W=7.6e-07 $X=156360 $Y=69030 $dt=15
M2389 239 201 VSS! VSS! nfet_01v8 L=1.5e-07 W=7.6e-07 $X=156360 $Y=70970 $dt=15
M2390 VSS! 107 221 VSS! nfet_01v8 L=1.5e-07 W=7.6e-07 $X=156360 $Y=77310 $dt=15
M2391 240 202 VSS! VSS! nfet_01v8 L=1.5e-07 W=7.6e-07 $X=156360 $Y=79250 $dt=15
M2392 VSS! 108 222 VSS! nfet_01v8 L=1.5e-07 W=7.6e-07 $X=156360 $Y=85590 $dt=15
M2393 241 203 VSS! VSS! nfet_01v8 L=1.5e-07 W=7.6e-07 $X=156360 $Y=87530 $dt=15
M2394 VSS! 109 223 VSS! nfet_01v8 L=1.5e-07 W=7.6e-07 $X=156360 $Y=93870 $dt=15
M2395 242 204 VSS! VSS! nfet_01v8 L=1.5e-07 W=7.6e-07 $X=156360 $Y=95810 $dt=15
M2396 VSS! 110 224 VSS! nfet_01v8 L=1.5e-07 W=7.6e-07 $X=156360 $Y=102150 $dt=15
M2397 243 205 VSS! VSS! nfet_01v8 L=1.5e-07 W=7.6e-07 $X=156360 $Y=104090 $dt=15
M2398 VSS! 111 225 VSS! nfet_01v8 L=1.5e-07 W=7.6e-07 $X=156360 $Y=110430 $dt=15
M2399 244 206 VSS! VSS! nfet_01v8 L=1.5e-07 W=7.6e-07 $X=156360 $Y=112370 $dt=15
M2400 VSS! 112 226 VSS! nfet_01v8 L=1.5e-07 W=7.6e-07 $X=156360 $Y=118710 $dt=15
M2401 245 207 VSS! VSS! nfet_01v8 L=1.5e-07 W=7.6e-07 $X=156360 $Y=120650 $dt=15
M2402 VSS! 113 227 VSS! nfet_01v8 L=1.5e-07 W=7.6e-07 $X=156360 $Y=126990 $dt=15
M2403 246 208 VSS! VSS! nfet_01v8 L=1.5e-07 W=7.6e-07 $X=156360 $Y=128930 $dt=15
M2404 VSS! 114 228 VSS! nfet_01v8 L=1.5e-07 W=7.6e-07 $X=156360 $Y=135270 $dt=15
M2405 247 209 VSS! VSS! nfet_01v8 L=1.5e-07 W=7.6e-07 $X=156360 $Y=137210 $dt=15
M2406 VSS! 115 229 VSS! nfet_01v8 L=1.5e-07 W=7.6e-07 $X=156360 $Y=143550 $dt=15
M2407 248 210 VSS! VSS! nfet_01v8 L=1.5e-07 W=7.6e-07 $X=156360 $Y=145490 $dt=15
M2408 VSS! 116 230 VSS! nfet_01v8 L=1.5e-07 W=7.6e-07 $X=156360 $Y=151830 $dt=15
M2409 249 211 VSS! VSS! nfet_01v8 L=1.5e-07 W=7.6e-07 $X=156360 $Y=153770 $dt=15
M2410 VSS! 117 231 VSS! nfet_01v8 L=1.5e-07 W=7.6e-07 $X=156360 $Y=160110 $dt=15
M2411 250 212 VSS! VSS! nfet_01v8 L=1.5e-07 W=7.6e-07 $X=156360 $Y=162050 $dt=15
M2412 213 99 VSS! VSS! nfet_01v8 L=1.5e-07 W=7.6e-07 $X=156790 $Y=11070 $dt=15
M2413 VSS! 194 232 VSS! nfet_01v8 L=1.5e-07 W=7.6e-07 $X=156790 $Y=13010 $dt=15
M2414 214 100 VSS! VSS! nfet_01v8 L=1.5e-07 W=7.6e-07 $X=156790 $Y=19350 $dt=15
M2415 VSS! 195 233 VSS! nfet_01v8 L=1.5e-07 W=7.6e-07 $X=156790 $Y=21290 $dt=15
M2416 215 101 VSS! VSS! nfet_01v8 L=1.5e-07 W=7.6e-07 $X=156790 $Y=27630 $dt=15
M2417 VSS! 196 234 VSS! nfet_01v8 L=1.5e-07 W=7.6e-07 $X=156790 $Y=29570 $dt=15
M2418 216 102 VSS! VSS! nfet_01v8 L=1.5e-07 W=7.6e-07 $X=156790 $Y=35910 $dt=15
M2419 VSS! 197 235 VSS! nfet_01v8 L=1.5e-07 W=7.6e-07 $X=156790 $Y=37850 $dt=15
M2420 217 103 VSS! VSS! nfet_01v8 L=1.5e-07 W=7.6e-07 $X=156790 $Y=44190 $dt=15
M2421 VSS! 198 236 VSS! nfet_01v8 L=1.5e-07 W=7.6e-07 $X=156790 $Y=46130 $dt=15
M2422 218 104 VSS! VSS! nfet_01v8 L=1.5e-07 W=7.6e-07 $X=156790 $Y=52470 $dt=15
M2423 VSS! 199 237 VSS! nfet_01v8 L=1.5e-07 W=7.6e-07 $X=156790 $Y=54410 $dt=15
M2424 219 105 VSS! VSS! nfet_01v8 L=1.5e-07 W=7.6e-07 $X=156790 $Y=60750 $dt=15
M2425 VSS! 200 238 VSS! nfet_01v8 L=1.5e-07 W=7.6e-07 $X=156790 $Y=62690 $dt=15
M2426 220 106 VSS! VSS! nfet_01v8 L=1.5e-07 W=7.6e-07 $X=156790 $Y=69030 $dt=15
M2427 VSS! 201 239 VSS! nfet_01v8 L=1.5e-07 W=7.6e-07 $X=156790 $Y=70970 $dt=15
M2428 221 107 VSS! VSS! nfet_01v8 L=1.5e-07 W=7.6e-07 $X=156790 $Y=77310 $dt=15
M2429 VSS! 202 240 VSS! nfet_01v8 L=1.5e-07 W=7.6e-07 $X=156790 $Y=79250 $dt=15
M2430 222 108 VSS! VSS! nfet_01v8 L=1.5e-07 W=7.6e-07 $X=156790 $Y=85590 $dt=15
M2431 VSS! 203 241 VSS! nfet_01v8 L=1.5e-07 W=7.6e-07 $X=156790 $Y=87530 $dt=15
M2432 223 109 VSS! VSS! nfet_01v8 L=1.5e-07 W=7.6e-07 $X=156790 $Y=93870 $dt=15
M2433 VSS! 204 242 VSS! nfet_01v8 L=1.5e-07 W=7.6e-07 $X=156790 $Y=95810 $dt=15
M2434 224 110 VSS! VSS! nfet_01v8 L=1.5e-07 W=7.6e-07 $X=156790 $Y=102150 $dt=15
M2435 VSS! 205 243 VSS! nfet_01v8 L=1.5e-07 W=7.6e-07 $X=156790 $Y=104090 $dt=15
M2436 225 111 VSS! VSS! nfet_01v8 L=1.5e-07 W=7.6e-07 $X=156790 $Y=110430 $dt=15
M2437 VSS! 206 244 VSS! nfet_01v8 L=1.5e-07 W=7.6e-07 $X=156790 $Y=112370 $dt=15
M2438 226 112 VSS! VSS! nfet_01v8 L=1.5e-07 W=7.6e-07 $X=156790 $Y=118710 $dt=15
M2439 VSS! 207 245 VSS! nfet_01v8 L=1.5e-07 W=7.6e-07 $X=156790 $Y=120650 $dt=15
M2440 227 113 VSS! VSS! nfet_01v8 L=1.5e-07 W=7.6e-07 $X=156790 $Y=126990 $dt=15
M2441 VSS! 208 246 VSS! nfet_01v8 L=1.5e-07 W=7.6e-07 $X=156790 $Y=128930 $dt=15
M2442 228 114 VSS! VSS! nfet_01v8 L=1.5e-07 W=7.6e-07 $X=156790 $Y=135270 $dt=15
M2443 VSS! 209 247 VSS! nfet_01v8 L=1.5e-07 W=7.6e-07 $X=156790 $Y=137210 $dt=15
M2444 229 115 VSS! VSS! nfet_01v8 L=1.5e-07 W=7.6e-07 $X=156790 $Y=143550 $dt=15
M2445 VSS! 210 248 VSS! nfet_01v8 L=1.5e-07 W=7.6e-07 $X=156790 $Y=145490 $dt=15
M2446 230 116 VSS! VSS! nfet_01v8 L=1.5e-07 W=7.6e-07 $X=156790 $Y=151830 $dt=15
M2447 VSS! 211 249 VSS! nfet_01v8 L=1.5e-07 W=7.6e-07 $X=156790 $Y=153770 $dt=15
M2448 231 117 VSS! VSS! nfet_01v8 L=1.5e-07 W=7.6e-07 $X=156790 $Y=160110 $dt=15
M2449 VSS! 212 250 VSS! nfet_01v8 L=1.5e-07 W=7.6e-07 $X=156790 $Y=162050 $dt=15
M2450 VSS! 99 213 VSS! nfet_01v8 L=1.5e-07 W=7.6e-07 $X=157220 $Y=11070 $dt=15
M2451 194 23 VSS! VSS! nfet_01v8 L=1.5e-07 W=7.6e-07 $X=157220 $Y=13010 $dt=15
M2452 VSS! 100 214 VSS! nfet_01v8 L=1.5e-07 W=7.6e-07 $X=157220 $Y=19350 $dt=15
M2453 195 24 VSS! VSS! nfet_01v8 L=1.5e-07 W=7.6e-07 $X=157220 $Y=21290 $dt=15
M2454 VSS! 101 215 VSS! nfet_01v8 L=1.5e-07 W=7.6e-07 $X=157220 $Y=27630 $dt=15
M2455 196 25 VSS! VSS! nfet_01v8 L=1.5e-07 W=7.6e-07 $X=157220 $Y=29570 $dt=15
M2456 VSS! 102 216 VSS! nfet_01v8 L=1.5e-07 W=7.6e-07 $X=157220 $Y=35910 $dt=15
M2457 197 26 VSS! VSS! nfet_01v8 L=1.5e-07 W=7.6e-07 $X=157220 $Y=37850 $dt=15
M2458 VSS! 103 217 VSS! nfet_01v8 L=1.5e-07 W=7.6e-07 $X=157220 $Y=44190 $dt=15
M2459 198 27 VSS! VSS! nfet_01v8 L=1.5e-07 W=7.6e-07 $X=157220 $Y=46130 $dt=15
M2460 VSS! 104 218 VSS! nfet_01v8 L=1.5e-07 W=7.6e-07 $X=157220 $Y=52470 $dt=15
M2461 199 28 VSS! VSS! nfet_01v8 L=1.5e-07 W=7.6e-07 $X=157220 $Y=54410 $dt=15
M2462 VSS! 105 219 VSS! nfet_01v8 L=1.5e-07 W=7.6e-07 $X=157220 $Y=60750 $dt=15
M2463 200 29 VSS! VSS! nfet_01v8 L=1.5e-07 W=7.6e-07 $X=157220 $Y=62690 $dt=15
M2464 VSS! 106 220 VSS! nfet_01v8 L=1.5e-07 W=7.6e-07 $X=157220 $Y=69030 $dt=15
M2465 201 30 VSS! VSS! nfet_01v8 L=1.5e-07 W=7.6e-07 $X=157220 $Y=70970 $dt=15
M2466 VSS! 107 221 VSS! nfet_01v8 L=1.5e-07 W=7.6e-07 $X=157220 $Y=77310 $dt=15
M2467 202 31 VSS! VSS! nfet_01v8 L=1.5e-07 W=7.6e-07 $X=157220 $Y=79250 $dt=15
M2468 VSS! 108 222 VSS! nfet_01v8 L=1.5e-07 W=7.6e-07 $X=157220 $Y=85590 $dt=15
M2469 203 32 VSS! VSS! nfet_01v8 L=1.5e-07 W=7.6e-07 $X=157220 $Y=87530 $dt=15
M2470 VSS! 109 223 VSS! nfet_01v8 L=1.5e-07 W=7.6e-07 $X=157220 $Y=93870 $dt=15
M2471 204 33 VSS! VSS! nfet_01v8 L=1.5e-07 W=7.6e-07 $X=157220 $Y=95810 $dt=15
M2472 VSS! 110 224 VSS! nfet_01v8 L=1.5e-07 W=7.6e-07 $X=157220 $Y=102150 $dt=15
M2473 205 34 VSS! VSS! nfet_01v8 L=1.5e-07 W=7.6e-07 $X=157220 $Y=104090 $dt=15
M2474 VSS! 111 225 VSS! nfet_01v8 L=1.5e-07 W=7.6e-07 $X=157220 $Y=110430 $dt=15
M2475 206 35 VSS! VSS! nfet_01v8 L=1.5e-07 W=7.6e-07 $X=157220 $Y=112370 $dt=15
M2476 VSS! 112 226 VSS! nfet_01v8 L=1.5e-07 W=7.6e-07 $X=157220 $Y=118710 $dt=15
M2477 207 36 VSS! VSS! nfet_01v8 L=1.5e-07 W=7.6e-07 $X=157220 $Y=120650 $dt=15
M2478 VSS! 113 227 VSS! nfet_01v8 L=1.5e-07 W=7.6e-07 $X=157220 $Y=126990 $dt=15
M2479 208 37 VSS! VSS! nfet_01v8 L=1.5e-07 W=7.6e-07 $X=157220 $Y=128930 $dt=15
M2480 VSS! 114 228 VSS! nfet_01v8 L=1.5e-07 W=7.6e-07 $X=157220 $Y=135270 $dt=15
M2481 209 38 VSS! VSS! nfet_01v8 L=1.5e-07 W=7.6e-07 $X=157220 $Y=137210 $dt=15
M2482 VSS! 115 229 VSS! nfet_01v8 L=1.5e-07 W=7.6e-07 $X=157220 $Y=143550 $dt=15
M2483 210 39 VSS! VSS! nfet_01v8 L=1.5e-07 W=7.6e-07 $X=157220 $Y=145490 $dt=15
M2484 VSS! 116 230 VSS! nfet_01v8 L=1.5e-07 W=7.6e-07 $X=157220 $Y=151830 $dt=15
M2485 211 40 VSS! VSS! nfet_01v8 L=1.5e-07 W=7.6e-07 $X=157220 $Y=153770 $dt=15
M2486 VSS! 117 231 VSS! nfet_01v8 L=1.5e-07 W=7.6e-07 $X=157220 $Y=160110 $dt=15
M2487 212 41 VSS! VSS! nfet_01v8 L=1.5e-07 W=7.6e-07 $X=157220 $Y=162050 $dt=15
M2488 175 23 VSS! VSS! nfet_01v8 L=1.5e-07 W=7.6e-07 $X=158230 $Y=11070 $dt=15
M2489 176 24 VSS! VSS! nfet_01v8 L=1.5e-07 W=7.6e-07 $X=158230 $Y=19350 $dt=15
M2490 177 25 VSS! VSS! nfet_01v8 L=1.5e-07 W=7.6e-07 $X=158230 $Y=27630 $dt=15
M2491 178 26 VSS! VSS! nfet_01v8 L=1.5e-07 W=7.6e-07 $X=158230 $Y=35910 $dt=15
M2492 179 27 VSS! VSS! nfet_01v8 L=1.5e-07 W=7.6e-07 $X=158230 $Y=44190 $dt=15
M2493 180 28 VSS! VSS! nfet_01v8 L=1.5e-07 W=7.6e-07 $X=158230 $Y=52470 $dt=15
M2494 181 29 VSS! VSS! nfet_01v8 L=1.5e-07 W=7.6e-07 $X=158230 $Y=60750 $dt=15
M2495 182 30 VSS! VSS! nfet_01v8 L=1.5e-07 W=7.6e-07 $X=158230 $Y=69030 $dt=15
M2496 183 31 VSS! VSS! nfet_01v8 L=1.5e-07 W=7.6e-07 $X=158230 $Y=77310 $dt=15
M2497 184 32 VSS! VSS! nfet_01v8 L=1.5e-07 W=7.6e-07 $X=158230 $Y=85590 $dt=15
M2498 185 33 VSS! VSS! nfet_01v8 L=1.5e-07 W=7.6e-07 $X=158230 $Y=93870 $dt=15
M2499 186 34 VSS! VSS! nfet_01v8 L=1.5e-07 W=7.6e-07 $X=158230 $Y=102150 $dt=15
M2500 187 35 VSS! VSS! nfet_01v8 L=1.5e-07 W=7.6e-07 $X=158230 $Y=110430 $dt=15
M2501 188 36 VSS! VSS! nfet_01v8 L=1.5e-07 W=7.6e-07 $X=158230 $Y=118710 $dt=15
M2502 189 37 VSS! VSS! nfet_01v8 L=1.5e-07 W=7.6e-07 $X=158230 $Y=126990 $dt=15
M2503 190 38 VSS! VSS! nfet_01v8 L=1.5e-07 W=7.6e-07 $X=158230 $Y=135270 $dt=15
M2504 191 39 VSS! VSS! nfet_01v8 L=1.5e-07 W=7.6e-07 $X=158230 $Y=143550 $dt=15
M2505 192 40 VSS! VSS! nfet_01v8 L=1.5e-07 W=7.6e-07 $X=158230 $Y=151830 $dt=15
M2506 193 41 VSS! VSS! nfet_01v8 L=1.5e-07 W=7.6e-07 $X=158230 $Y=160110 $dt=15
M2507 156 137 VSS! VSS! nfet_01v8 L=1.5e-07 W=7.6e-07 $X=158260 $Y=13010 $dt=15
M2508 157 138 VSS! VSS! nfet_01v8 L=1.5e-07 W=7.6e-07 $X=158260 $Y=21290 $dt=15
M2509 158 139 VSS! VSS! nfet_01v8 L=1.5e-07 W=7.6e-07 $X=158260 $Y=29570 $dt=15
M2510 159 140 VSS! VSS! nfet_01v8 L=1.5e-07 W=7.6e-07 $X=158260 $Y=37850 $dt=15
M2511 160 141 VSS! VSS! nfet_01v8 L=1.5e-07 W=7.6e-07 $X=158260 $Y=46130 $dt=15
M2512 161 142 VSS! VSS! nfet_01v8 L=1.5e-07 W=7.6e-07 $X=158260 $Y=54410 $dt=15
M2513 162 143 VSS! VSS! nfet_01v8 L=1.5e-07 W=7.6e-07 $X=158260 $Y=62690 $dt=15
M2514 163 144 VSS! VSS! nfet_01v8 L=1.5e-07 W=7.6e-07 $X=158260 $Y=70970 $dt=15
M2515 164 145 VSS! VSS! nfet_01v8 L=1.5e-07 W=7.6e-07 $X=158260 $Y=79250 $dt=15
M2516 165 146 VSS! VSS! nfet_01v8 L=1.5e-07 W=7.6e-07 $X=158260 $Y=87530 $dt=15
M2517 166 147 VSS! VSS! nfet_01v8 L=1.5e-07 W=7.6e-07 $X=158260 $Y=95810 $dt=15
M2518 167 148 VSS! VSS! nfet_01v8 L=1.5e-07 W=7.6e-07 $X=158260 $Y=104090 $dt=15
M2519 168 149 VSS! VSS! nfet_01v8 L=1.5e-07 W=7.6e-07 $X=158260 $Y=112370 $dt=15
M2520 169 150 VSS! VSS! nfet_01v8 L=1.5e-07 W=7.6e-07 $X=158260 $Y=120650 $dt=15
M2521 170 151 VSS! VSS! nfet_01v8 L=1.5e-07 W=7.6e-07 $X=158260 $Y=128930 $dt=15
M2522 171 152 VSS! VSS! nfet_01v8 L=1.5e-07 W=7.6e-07 $X=158260 $Y=137210 $dt=15
M2523 172 153 VSS! VSS! nfet_01v8 L=1.5e-07 W=7.6e-07 $X=158260 $Y=145490 $dt=15
M2524 173 154 VSS! VSS! nfet_01v8 L=1.5e-07 W=7.6e-07 $X=158260 $Y=153770 $dt=15
M2525 174 155 VSS! VSS! nfet_01v8 L=1.5e-07 W=7.6e-07 $X=158260 $Y=162050 $dt=15
M2526 VSS! 23 175 VSS! nfet_01v8 L=1.5e-07 W=7.6e-07 $X=158660 $Y=11070 $dt=15
M2527 VSS! 24 176 VSS! nfet_01v8 L=1.5e-07 W=7.6e-07 $X=158660 $Y=19350 $dt=15
M2528 VSS! 25 177 VSS! nfet_01v8 L=1.5e-07 W=7.6e-07 $X=158660 $Y=27630 $dt=15
M2529 VSS! 26 178 VSS! nfet_01v8 L=1.5e-07 W=7.6e-07 $X=158660 $Y=35910 $dt=15
M2530 VSS! 27 179 VSS! nfet_01v8 L=1.5e-07 W=7.6e-07 $X=158660 $Y=44190 $dt=15
M2531 VSS! 28 180 VSS! nfet_01v8 L=1.5e-07 W=7.6e-07 $X=158660 $Y=52470 $dt=15
M2532 VSS! 29 181 VSS! nfet_01v8 L=1.5e-07 W=7.6e-07 $X=158660 $Y=60750 $dt=15
M2533 VSS! 30 182 VSS! nfet_01v8 L=1.5e-07 W=7.6e-07 $X=158660 $Y=69030 $dt=15
M2534 VSS! 31 183 VSS! nfet_01v8 L=1.5e-07 W=7.6e-07 $X=158660 $Y=77310 $dt=15
M2535 VSS! 32 184 VSS! nfet_01v8 L=1.5e-07 W=7.6e-07 $X=158660 $Y=85590 $dt=15
M2536 VSS! 33 185 VSS! nfet_01v8 L=1.5e-07 W=7.6e-07 $X=158660 $Y=93870 $dt=15
M2537 VSS! 34 186 VSS! nfet_01v8 L=1.5e-07 W=7.6e-07 $X=158660 $Y=102150 $dt=15
M2538 VSS! 35 187 VSS! nfet_01v8 L=1.5e-07 W=7.6e-07 $X=158660 $Y=110430 $dt=15
M2539 VSS! 36 188 VSS! nfet_01v8 L=1.5e-07 W=7.6e-07 $X=158660 $Y=118710 $dt=15
M2540 VSS! 37 189 VSS! nfet_01v8 L=1.5e-07 W=7.6e-07 $X=158660 $Y=126990 $dt=15
M2541 VSS! 38 190 VSS! nfet_01v8 L=1.5e-07 W=7.6e-07 $X=158660 $Y=135270 $dt=15
M2542 VSS! 39 191 VSS! nfet_01v8 L=1.5e-07 W=7.6e-07 $X=158660 $Y=143550 $dt=15
M2543 VSS! 40 192 VSS! nfet_01v8 L=1.5e-07 W=7.6e-07 $X=158660 $Y=151830 $dt=15
M2544 VSS! 41 193 VSS! nfet_01v8 L=1.5e-07 W=7.6e-07 $X=158660 $Y=160110 $dt=15
M2545 VSS! 137 156 VSS! nfet_01v8 L=1.5e-07 W=7.6e-07 $X=158690 $Y=13010 $dt=15
M2546 VSS! 138 157 VSS! nfet_01v8 L=1.5e-07 W=7.6e-07 $X=158690 $Y=21290 $dt=15
M2547 VSS! 139 158 VSS! nfet_01v8 L=1.5e-07 W=7.6e-07 $X=158690 $Y=29570 $dt=15
M2548 VSS! 140 159 VSS! nfet_01v8 L=1.5e-07 W=7.6e-07 $X=158690 $Y=37850 $dt=15
M2549 VSS! 141 160 VSS! nfet_01v8 L=1.5e-07 W=7.6e-07 $X=158690 $Y=46130 $dt=15
M2550 VSS! 142 161 VSS! nfet_01v8 L=1.5e-07 W=7.6e-07 $X=158690 $Y=54410 $dt=15
M2551 VSS! 143 162 VSS! nfet_01v8 L=1.5e-07 W=7.6e-07 $X=158690 $Y=62690 $dt=15
M2552 VSS! 144 163 VSS! nfet_01v8 L=1.5e-07 W=7.6e-07 $X=158690 $Y=70970 $dt=15
M2553 VSS! 145 164 VSS! nfet_01v8 L=1.5e-07 W=7.6e-07 $X=158690 $Y=79250 $dt=15
M2554 VSS! 146 165 VSS! nfet_01v8 L=1.5e-07 W=7.6e-07 $X=158690 $Y=87530 $dt=15
M2555 VSS! 147 166 VSS! nfet_01v8 L=1.5e-07 W=7.6e-07 $X=158690 $Y=95810 $dt=15
M2556 VSS! 148 167 VSS! nfet_01v8 L=1.5e-07 W=7.6e-07 $X=158690 $Y=104090 $dt=15
M2557 VSS! 149 168 VSS! nfet_01v8 L=1.5e-07 W=7.6e-07 $X=158690 $Y=112370 $dt=15
M2558 VSS! 150 169 VSS! nfet_01v8 L=1.5e-07 W=7.6e-07 $X=158690 $Y=120650 $dt=15
M2559 VSS! 151 170 VSS! nfet_01v8 L=1.5e-07 W=7.6e-07 $X=158690 $Y=128930 $dt=15
M2560 VSS! 152 171 VSS! nfet_01v8 L=1.5e-07 W=7.6e-07 $X=158690 $Y=137210 $dt=15
M2561 VSS! 153 172 VSS! nfet_01v8 L=1.5e-07 W=7.6e-07 $X=158690 $Y=145490 $dt=15
M2562 VSS! 154 173 VSS! nfet_01v8 L=1.5e-07 W=7.6e-07 $X=158690 $Y=153770 $dt=15
M2563 VSS! 155 174 VSS! nfet_01v8 L=1.5e-07 W=7.6e-07 $X=158690 $Y=162050 $dt=15
M2564 175 23 VSS! VSS! nfet_01v8 L=1.5e-07 W=7.6e-07 $X=159090 $Y=11070 $dt=15
M2565 176 24 VSS! VSS! nfet_01v8 L=1.5e-07 W=7.6e-07 $X=159090 $Y=19350 $dt=15
M2566 177 25 VSS! VSS! nfet_01v8 L=1.5e-07 W=7.6e-07 $X=159090 $Y=27630 $dt=15
M2567 178 26 VSS! VSS! nfet_01v8 L=1.5e-07 W=7.6e-07 $X=159090 $Y=35910 $dt=15
M2568 179 27 VSS! VSS! nfet_01v8 L=1.5e-07 W=7.6e-07 $X=159090 $Y=44190 $dt=15
M2569 180 28 VSS! VSS! nfet_01v8 L=1.5e-07 W=7.6e-07 $X=159090 $Y=52470 $dt=15
M2570 181 29 VSS! VSS! nfet_01v8 L=1.5e-07 W=7.6e-07 $X=159090 $Y=60750 $dt=15
M2571 182 30 VSS! VSS! nfet_01v8 L=1.5e-07 W=7.6e-07 $X=159090 $Y=69030 $dt=15
M2572 183 31 VSS! VSS! nfet_01v8 L=1.5e-07 W=7.6e-07 $X=159090 $Y=77310 $dt=15
M2573 184 32 VSS! VSS! nfet_01v8 L=1.5e-07 W=7.6e-07 $X=159090 $Y=85590 $dt=15
M2574 185 33 VSS! VSS! nfet_01v8 L=1.5e-07 W=7.6e-07 $X=159090 $Y=93870 $dt=15
M2575 186 34 VSS! VSS! nfet_01v8 L=1.5e-07 W=7.6e-07 $X=159090 $Y=102150 $dt=15
M2576 187 35 VSS! VSS! nfet_01v8 L=1.5e-07 W=7.6e-07 $X=159090 $Y=110430 $dt=15
M2577 188 36 VSS! VSS! nfet_01v8 L=1.5e-07 W=7.6e-07 $X=159090 $Y=118710 $dt=15
M2578 189 37 VSS! VSS! nfet_01v8 L=1.5e-07 W=7.6e-07 $X=159090 $Y=126990 $dt=15
M2579 190 38 VSS! VSS! nfet_01v8 L=1.5e-07 W=7.6e-07 $X=159090 $Y=135270 $dt=15
M2580 191 39 VSS! VSS! nfet_01v8 L=1.5e-07 W=7.6e-07 $X=159090 $Y=143550 $dt=15
M2581 192 40 VSS! VSS! nfet_01v8 L=1.5e-07 W=7.6e-07 $X=159090 $Y=151830 $dt=15
M2582 193 41 VSS! VSS! nfet_01v8 L=1.5e-07 W=7.6e-07 $X=159090 $Y=160110 $dt=15
M2583 156 137 VSS! VSS! nfet_01v8 L=1.5e-07 W=7.6e-07 $X=159120 $Y=13010 $dt=15
M2584 157 138 VSS! VSS! nfet_01v8 L=1.5e-07 W=7.6e-07 $X=159120 $Y=21290 $dt=15
M2585 158 139 VSS! VSS! nfet_01v8 L=1.5e-07 W=7.6e-07 $X=159120 $Y=29570 $dt=15
M2586 159 140 VSS! VSS! nfet_01v8 L=1.5e-07 W=7.6e-07 $X=159120 $Y=37850 $dt=15
M2587 160 141 VSS! VSS! nfet_01v8 L=1.5e-07 W=7.6e-07 $X=159120 $Y=46130 $dt=15
M2588 161 142 VSS! VSS! nfet_01v8 L=1.5e-07 W=7.6e-07 $X=159120 $Y=54410 $dt=15
M2589 162 143 VSS! VSS! nfet_01v8 L=1.5e-07 W=7.6e-07 $X=159120 $Y=62690 $dt=15
M2590 163 144 VSS! VSS! nfet_01v8 L=1.5e-07 W=7.6e-07 $X=159120 $Y=70970 $dt=15
M2591 164 145 VSS! VSS! nfet_01v8 L=1.5e-07 W=7.6e-07 $X=159120 $Y=79250 $dt=15
M2592 165 146 VSS! VSS! nfet_01v8 L=1.5e-07 W=7.6e-07 $X=159120 $Y=87530 $dt=15
M2593 166 147 VSS! VSS! nfet_01v8 L=1.5e-07 W=7.6e-07 $X=159120 $Y=95810 $dt=15
M2594 167 148 VSS! VSS! nfet_01v8 L=1.5e-07 W=7.6e-07 $X=159120 $Y=104090 $dt=15
M2595 168 149 VSS! VSS! nfet_01v8 L=1.5e-07 W=7.6e-07 $X=159120 $Y=112370 $dt=15
M2596 169 150 VSS! VSS! nfet_01v8 L=1.5e-07 W=7.6e-07 $X=159120 $Y=120650 $dt=15
M2597 170 151 VSS! VSS! nfet_01v8 L=1.5e-07 W=7.6e-07 $X=159120 $Y=128930 $dt=15
M2598 171 152 VSS! VSS! nfet_01v8 L=1.5e-07 W=7.6e-07 $X=159120 $Y=137210 $dt=15
M2599 172 153 VSS! VSS! nfet_01v8 L=1.5e-07 W=7.6e-07 $X=159120 $Y=145490 $dt=15
M2600 173 154 VSS! VSS! nfet_01v8 L=1.5e-07 W=7.6e-07 $X=159120 $Y=153770 $dt=15
M2601 174 155 VSS! VSS! nfet_01v8 L=1.5e-07 W=7.6e-07 $X=159120 $Y=162050 $dt=15
M2602 VSS! 23 175 VSS! nfet_01v8 L=1.5e-07 W=7.6e-07 $X=159520 $Y=11070 $dt=15
M2603 VSS! 24 176 VSS! nfet_01v8 L=1.5e-07 W=7.6e-07 $X=159520 $Y=19350 $dt=15
M2604 VSS! 25 177 VSS! nfet_01v8 L=1.5e-07 W=7.6e-07 $X=159520 $Y=27630 $dt=15
M2605 VSS! 26 178 VSS! nfet_01v8 L=1.5e-07 W=7.6e-07 $X=159520 $Y=35910 $dt=15
M2606 VSS! 27 179 VSS! nfet_01v8 L=1.5e-07 W=7.6e-07 $X=159520 $Y=44190 $dt=15
M2607 VSS! 28 180 VSS! nfet_01v8 L=1.5e-07 W=7.6e-07 $X=159520 $Y=52470 $dt=15
M2608 VSS! 29 181 VSS! nfet_01v8 L=1.5e-07 W=7.6e-07 $X=159520 $Y=60750 $dt=15
M2609 VSS! 30 182 VSS! nfet_01v8 L=1.5e-07 W=7.6e-07 $X=159520 $Y=69030 $dt=15
M2610 VSS! 31 183 VSS! nfet_01v8 L=1.5e-07 W=7.6e-07 $X=159520 $Y=77310 $dt=15
M2611 VSS! 32 184 VSS! nfet_01v8 L=1.5e-07 W=7.6e-07 $X=159520 $Y=85590 $dt=15
M2612 VSS! 33 185 VSS! nfet_01v8 L=1.5e-07 W=7.6e-07 $X=159520 $Y=93870 $dt=15
M2613 VSS! 34 186 VSS! nfet_01v8 L=1.5e-07 W=7.6e-07 $X=159520 $Y=102150 $dt=15
M2614 VSS! 35 187 VSS! nfet_01v8 L=1.5e-07 W=7.6e-07 $X=159520 $Y=110430 $dt=15
M2615 VSS! 36 188 VSS! nfet_01v8 L=1.5e-07 W=7.6e-07 $X=159520 $Y=118710 $dt=15
M2616 VSS! 37 189 VSS! nfet_01v8 L=1.5e-07 W=7.6e-07 $X=159520 $Y=126990 $dt=15
M2617 VSS! 38 190 VSS! nfet_01v8 L=1.5e-07 W=7.6e-07 $X=159520 $Y=135270 $dt=15
M2618 VSS! 39 191 VSS! nfet_01v8 L=1.5e-07 W=7.6e-07 $X=159520 $Y=143550 $dt=15
M2619 VSS! 40 192 VSS! nfet_01v8 L=1.5e-07 W=7.6e-07 $X=159520 $Y=151830 $dt=15
M2620 VSS! 41 193 VSS! nfet_01v8 L=1.5e-07 W=7.6e-07 $X=159520 $Y=160110 $dt=15
M2621 VSS! 137 156 VSS! nfet_01v8 L=1.5e-07 W=7.6e-07 $X=159550 $Y=13010 $dt=15
M2622 VSS! 138 157 VSS! nfet_01v8 L=1.5e-07 W=7.6e-07 $X=159550 $Y=21290 $dt=15
M2623 VSS! 139 158 VSS! nfet_01v8 L=1.5e-07 W=7.6e-07 $X=159550 $Y=29570 $dt=15
M2624 VSS! 140 159 VSS! nfet_01v8 L=1.5e-07 W=7.6e-07 $X=159550 $Y=37850 $dt=15
M2625 VSS! 141 160 VSS! nfet_01v8 L=1.5e-07 W=7.6e-07 $X=159550 $Y=46130 $dt=15
M2626 VSS! 142 161 VSS! nfet_01v8 L=1.5e-07 W=7.6e-07 $X=159550 $Y=54410 $dt=15
M2627 VSS! 143 162 VSS! nfet_01v8 L=1.5e-07 W=7.6e-07 $X=159550 $Y=62690 $dt=15
M2628 VSS! 144 163 VSS! nfet_01v8 L=1.5e-07 W=7.6e-07 $X=159550 $Y=70970 $dt=15
M2629 VSS! 145 164 VSS! nfet_01v8 L=1.5e-07 W=7.6e-07 $X=159550 $Y=79250 $dt=15
M2630 VSS! 146 165 VSS! nfet_01v8 L=1.5e-07 W=7.6e-07 $X=159550 $Y=87530 $dt=15
M2631 VSS! 147 166 VSS! nfet_01v8 L=1.5e-07 W=7.6e-07 $X=159550 $Y=95810 $dt=15
M2632 VSS! 148 167 VSS! nfet_01v8 L=1.5e-07 W=7.6e-07 $X=159550 $Y=104090 $dt=15
M2633 VSS! 149 168 VSS! nfet_01v8 L=1.5e-07 W=7.6e-07 $X=159550 $Y=112370 $dt=15
M2634 VSS! 150 169 VSS! nfet_01v8 L=1.5e-07 W=7.6e-07 $X=159550 $Y=120650 $dt=15
M2635 VSS! 151 170 VSS! nfet_01v8 L=1.5e-07 W=7.6e-07 $X=159550 $Y=128930 $dt=15
M2636 VSS! 152 171 VSS! nfet_01v8 L=1.5e-07 W=7.6e-07 $X=159550 $Y=137210 $dt=15
M2637 VSS! 153 172 VSS! nfet_01v8 L=1.5e-07 W=7.6e-07 $X=159550 $Y=145490 $dt=15
M2638 VSS! 154 173 VSS! nfet_01v8 L=1.5e-07 W=7.6e-07 $X=159550 $Y=153770 $dt=15
M2639 VSS! 155 174 VSS! nfet_01v8 L=1.5e-07 W=7.6e-07 $X=159550 $Y=162050 $dt=15
M2640 137 99 VSS! VSS! nfet_01v8 L=1.5e-07 W=7.6e-07 $X=159980 $Y=13010 $dt=15
M2641 138 100 VSS! VSS! nfet_01v8 L=1.5e-07 W=7.6e-07 $X=159980 $Y=21290 $dt=15
M2642 139 101 VSS! VSS! nfet_01v8 L=1.5e-07 W=7.6e-07 $X=159980 $Y=29570 $dt=15
M2643 140 102 VSS! VSS! nfet_01v8 L=1.5e-07 W=7.6e-07 $X=159980 $Y=37850 $dt=15
M2644 141 103 VSS! VSS! nfet_01v8 L=1.5e-07 W=7.6e-07 $X=159980 $Y=46130 $dt=15
M2645 142 104 VSS! VSS! nfet_01v8 L=1.5e-07 W=7.6e-07 $X=159980 $Y=54410 $dt=15
M2646 143 105 VSS! VSS! nfet_01v8 L=1.5e-07 W=7.6e-07 $X=159980 $Y=62690 $dt=15
M2647 144 106 VSS! VSS! nfet_01v8 L=1.5e-07 W=7.6e-07 $X=159980 $Y=70970 $dt=15
M2648 145 107 VSS! VSS! nfet_01v8 L=1.5e-07 W=7.6e-07 $X=159980 $Y=79250 $dt=15
M2649 146 108 VSS! VSS! nfet_01v8 L=1.5e-07 W=7.6e-07 $X=159980 $Y=87530 $dt=15
M2650 147 109 VSS! VSS! nfet_01v8 L=1.5e-07 W=7.6e-07 $X=159980 $Y=95810 $dt=15
M2651 148 110 VSS! VSS! nfet_01v8 L=1.5e-07 W=7.6e-07 $X=159980 $Y=104090 $dt=15
M2652 149 111 VSS! VSS! nfet_01v8 L=1.5e-07 W=7.6e-07 $X=159980 $Y=112370 $dt=15
M2653 150 112 VSS! VSS! nfet_01v8 L=1.5e-07 W=7.6e-07 $X=159980 $Y=120650 $dt=15
M2654 151 113 VSS! VSS! nfet_01v8 L=1.5e-07 W=7.6e-07 $X=159980 $Y=128930 $dt=15
M2655 152 114 VSS! VSS! nfet_01v8 L=1.5e-07 W=7.6e-07 $X=159980 $Y=137210 $dt=15
M2656 153 115 VSS! VSS! nfet_01v8 L=1.5e-07 W=7.6e-07 $X=159980 $Y=145490 $dt=15
M2657 154 116 VSS! VSS! nfet_01v8 L=1.5e-07 W=7.6e-07 $X=159980 $Y=153770 $dt=15
M2658 155 117 VSS! VSS! nfet_01v8 L=1.5e-07 W=7.6e-07 $X=159980 $Y=162050 $dt=15
M2659 VSS! 80 118 VSS! nfet_01v8 L=1.5e-07 W=7.6e-07 $X=160900 $Y=11070 $dt=15
M2660 VSS! 81 119 VSS! nfet_01v8 L=1.5e-07 W=7.6e-07 $X=160900 $Y=19350 $dt=15
M2661 VSS! 82 120 VSS! nfet_01v8 L=1.5e-07 W=7.6e-07 $X=160900 $Y=27630 $dt=15
M2662 VSS! 83 121 VSS! nfet_01v8 L=1.5e-07 W=7.6e-07 $X=160900 $Y=35910 $dt=15
M2663 VSS! 84 122 VSS! nfet_01v8 L=1.5e-07 W=7.6e-07 $X=160900 $Y=44190 $dt=15
M2664 VSS! 85 123 VSS! nfet_01v8 L=1.5e-07 W=7.6e-07 $X=160900 $Y=52470 $dt=15
M2665 VSS! 86 124 VSS! nfet_01v8 L=1.5e-07 W=7.6e-07 $X=160900 $Y=60750 $dt=15
M2666 VSS! 87 125 VSS! nfet_01v8 L=1.5e-07 W=7.6e-07 $X=160900 $Y=69030 $dt=15
M2667 VSS! 88 126 VSS! nfet_01v8 L=1.5e-07 W=7.6e-07 $X=160900 $Y=77310 $dt=15
M2668 VSS! 89 127 VSS! nfet_01v8 L=1.5e-07 W=7.6e-07 $X=160900 $Y=85590 $dt=15
M2669 VSS! 90 128 VSS! nfet_01v8 L=1.5e-07 W=7.6e-07 $X=160900 $Y=93870 $dt=15
M2670 VSS! 91 129 VSS! nfet_01v8 L=1.5e-07 W=7.6e-07 $X=160900 $Y=102150 $dt=15
M2671 VSS! 92 130 VSS! nfet_01v8 L=1.5e-07 W=7.6e-07 $X=160900 $Y=110430 $dt=15
M2672 VSS! 93 131 VSS! nfet_01v8 L=1.5e-07 W=7.6e-07 $X=160900 $Y=118710 $dt=15
M2673 VSS! 94 132 VSS! nfet_01v8 L=1.5e-07 W=7.6e-07 $X=160900 $Y=126990 $dt=15
M2674 VSS! 95 133 VSS! nfet_01v8 L=1.5e-07 W=7.6e-07 $X=160900 $Y=135270 $dt=15
M2675 VSS! 96 134 VSS! nfet_01v8 L=1.5e-07 W=7.6e-07 $X=160900 $Y=143550 $dt=15
M2676 VSS! 97 135 VSS! nfet_01v8 L=1.5e-07 W=7.6e-07 $X=160900 $Y=151830 $dt=15
M2677 VSS! 98 136 VSS! nfet_01v8 L=1.5e-07 W=7.6e-07 $X=160900 $Y=160110 $dt=15
M2678 VSS! 61 99 VSS! nfet_01v8 L=1.5e-07 W=7.6e-07 $X=161360 $Y=13010 $dt=15
M2679 VSS! 62 100 VSS! nfet_01v8 L=1.5e-07 W=7.6e-07 $X=161360 $Y=21290 $dt=15
M2680 VSS! 63 101 VSS! nfet_01v8 L=1.5e-07 W=7.6e-07 $X=161360 $Y=29570 $dt=15
M2681 VSS! 64 102 VSS! nfet_01v8 L=1.5e-07 W=7.6e-07 $X=161360 $Y=37850 $dt=15
M2682 VSS! 65 103 VSS! nfet_01v8 L=1.5e-07 W=7.6e-07 $X=161360 $Y=46130 $dt=15
M2683 VSS! 66 104 VSS! nfet_01v8 L=1.5e-07 W=7.6e-07 $X=161360 $Y=54410 $dt=15
M2684 VSS! 67 105 VSS! nfet_01v8 L=1.5e-07 W=7.6e-07 $X=161360 $Y=62690 $dt=15
M2685 VSS! 68 106 VSS! nfet_01v8 L=1.5e-07 W=7.6e-07 $X=161360 $Y=70970 $dt=15
M2686 VSS! 69 107 VSS! nfet_01v8 L=1.5e-07 W=7.6e-07 $X=161360 $Y=79250 $dt=15
M2687 VSS! 70 108 VSS! nfet_01v8 L=1.5e-07 W=7.6e-07 $X=161360 $Y=87530 $dt=15
M2688 VSS! 71 109 VSS! nfet_01v8 L=1.5e-07 W=7.6e-07 $X=161360 $Y=95810 $dt=15
M2689 VSS! 72 110 VSS! nfet_01v8 L=1.5e-07 W=7.6e-07 $X=161360 $Y=104090 $dt=15
M2690 VSS! 73 111 VSS! nfet_01v8 L=1.5e-07 W=7.6e-07 $X=161360 $Y=112370 $dt=15
M2691 VSS! 74 112 VSS! nfet_01v8 L=1.5e-07 W=7.6e-07 $X=161360 $Y=120650 $dt=15
M2692 VSS! 75 113 VSS! nfet_01v8 L=1.5e-07 W=7.6e-07 $X=161360 $Y=128930 $dt=15
M2693 VSS! 76 114 VSS! nfet_01v8 L=1.5e-07 W=7.6e-07 $X=161360 $Y=137210 $dt=15
M2694 VSS! 77 115 VSS! nfet_01v8 L=1.5e-07 W=7.6e-07 $X=161360 $Y=145490 $dt=15
M2695 VSS! 78 116 VSS! nfet_01v8 L=1.5e-07 W=7.6e-07 $X=161360 $Y=153770 $dt=15
M2696 VSS! 79 117 VSS! nfet_01v8 L=1.5e-07 W=7.6e-07 $X=161360 $Y=162050 $dt=15
M2697 910 VREF_SEL_8<27> VSS! VSS! nfet_01v8 L=1.5e-07 W=4.25e-07 $X=161390 $Y=11405 $dt=15
M2698 911 VREF_SEL_8<26> VSS! VSS! nfet_01v8 L=1.5e-07 W=4.25e-07 $X=161390 $Y=19685 $dt=15
M2699 912 VREF_SEL_8<25> VSS! VSS! nfet_01v8 L=1.5e-07 W=4.25e-07 $X=161390 $Y=27965 $dt=15
M2700 913 VREF_SEL_8<24> VSS! VSS! nfet_01v8 L=1.5e-07 W=4.25e-07 $X=161390 $Y=36245 $dt=15
M2701 914 VREF_SEL_8<23> VSS! VSS! nfet_01v8 L=1.5e-07 W=4.25e-07 $X=161390 $Y=44525 $dt=15
M2702 915 VREF_SEL_8<22> VSS! VSS! nfet_01v8 L=1.5e-07 W=4.25e-07 $X=161390 $Y=52805 $dt=15
M2703 916 VREF_SEL_8<21> VSS! VSS! nfet_01v8 L=1.5e-07 W=4.25e-07 $X=161390 $Y=61085 $dt=15
M2704 917 VREF_SEL_4<6> VSS! VSS! nfet_01v8 L=1.5e-07 W=4.25e-07 $X=161390 $Y=69365 $dt=15
M2705 918 VREF_SEL_4<5> VSS! VSS! nfet_01v8 L=1.5e-07 W=4.25e-07 $X=161390 $Y=77645 $dt=15
M2706 919 VREF_SEL_1<1> VSS! VSS! nfet_01v8 L=1.5e-07 W=4.25e-07 $X=161390 $Y=85925 $dt=15
M2707 920 VREF_SEL_2 VSS! VSS! nfet_01v8 L=1.5e-07 W=4.25e-07 $X=161390 $Y=94205 $dt=15
M2708 921 VREF_SEL_4<4> VSS! VSS! nfet_01v8 L=1.5e-07 W=4.25e-07 $X=161390 $Y=102485 $dt=15
M2709 922 VREF_SEL_8<20> VSS! VSS! nfet_01v8 L=1.5e-07 W=4.25e-07 $X=161390 $Y=110765 $dt=15
M2710 923 VREF_SEL_8<19> VSS! VSS! nfet_01v8 L=1.5e-07 W=4.25e-07 $X=161390 $Y=119045 $dt=15
M2711 924 VREF_SEL_8<18> VSS! VSS! nfet_01v8 L=1.5e-07 W=4.25e-07 $X=161390 $Y=127325 $dt=15
M2712 925 VREF_SEL_8<17> VSS! VSS! nfet_01v8 L=1.5e-07 W=4.25e-07 $X=161390 $Y=135605 $dt=15
M2713 926 VREF_SEL_8<16> VSS! VSS! nfet_01v8 L=1.5e-07 W=4.25e-07 $X=161390 $Y=143885 $dt=15
M2714 927 VREF_SEL_8<15> VSS! VSS! nfet_01v8 L=1.5e-07 W=4.25e-07 $X=161390 $Y=152165 $dt=15
M2715 928 VREF_SEL_8<14> VSS! VSS! nfet_01v8 L=1.5e-07 W=4.25e-07 $X=161390 $Y=160445 $dt=15
M2716 80 SAMPLE 910 VSS! nfet_01v8 L=1.5e-07 W=4.25e-07 $X=161820 $Y=11405 $dt=15
M2717 81 SAMPLE 911 VSS! nfet_01v8 L=1.5e-07 W=4.25e-07 $X=161820 $Y=19685 $dt=15
M2718 82 SAMPLE 912 VSS! nfet_01v8 L=1.5e-07 W=4.25e-07 $X=161820 $Y=27965 $dt=15
M2719 83 SAMPLE 913 VSS! nfet_01v8 L=1.5e-07 W=4.25e-07 $X=161820 $Y=36245 $dt=15
M2720 84 SAMPLE 914 VSS! nfet_01v8 L=1.5e-07 W=4.25e-07 $X=161820 $Y=44525 $dt=15
M2721 85 SAMPLE 915 VSS! nfet_01v8 L=1.5e-07 W=4.25e-07 $X=161820 $Y=52805 $dt=15
M2722 86 SAMPLE 916 VSS! nfet_01v8 L=1.5e-07 W=4.25e-07 $X=161820 $Y=61085 $dt=15
M2723 87 SAMPLE 917 VSS! nfet_01v8 L=1.5e-07 W=4.25e-07 $X=161820 $Y=69365 $dt=15
M2724 88 SAMPLE 918 VSS! nfet_01v8 L=1.5e-07 W=4.25e-07 $X=161820 $Y=77645 $dt=15
M2725 89 SAMPLE 919 VSS! nfet_01v8 L=1.5e-07 W=4.25e-07 $X=161820 $Y=85925 $dt=15
M2726 90 SAMPLE 920 VSS! nfet_01v8 L=1.5e-07 W=4.25e-07 $X=161820 $Y=94205 $dt=15
M2727 91 SAMPLE 921 VSS! nfet_01v8 L=1.5e-07 W=4.25e-07 $X=161820 $Y=102485 $dt=15
M2728 92 SAMPLE 922 VSS! nfet_01v8 L=1.5e-07 W=4.25e-07 $X=161820 $Y=110765 $dt=15
M2729 93 SAMPLE 923 VSS! nfet_01v8 L=1.5e-07 W=4.25e-07 $X=161820 $Y=119045 $dt=15
M2730 94 SAMPLE 924 VSS! nfet_01v8 L=1.5e-07 W=4.25e-07 $X=161820 $Y=127325 $dt=15
M2731 95 SAMPLE 925 VSS! nfet_01v8 L=1.5e-07 W=4.25e-07 $X=161820 $Y=135605 $dt=15
M2732 96 SAMPLE 926 VSS! nfet_01v8 L=1.5e-07 W=4.25e-07 $X=161820 $Y=143885 $dt=15
M2733 97 SAMPLE 927 VSS! nfet_01v8 L=1.5e-07 W=4.25e-07 $X=161820 $Y=152165 $dt=15
M2734 98 SAMPLE 928 VSS! nfet_01v8 L=1.5e-07 W=4.25e-07 $X=161820 $Y=160445 $dt=15
M2735 891 VREF_SEL_8<27> VSS! VSS! nfet_01v8 L=1.5e-07 W=4.25e-07 $X=161850 $Y=13010 $dt=15
M2736 892 VREF_SEL_8<26> VSS! VSS! nfet_01v8 L=1.5e-07 W=4.25e-07 $X=161850 $Y=21290 $dt=15
M2737 893 VREF_SEL_8<25> VSS! VSS! nfet_01v8 L=1.5e-07 W=4.25e-07 $X=161850 $Y=29570 $dt=15
M2738 894 VREF_SEL_8<24> VSS! VSS! nfet_01v8 L=1.5e-07 W=4.25e-07 $X=161850 $Y=37850 $dt=15
M2739 895 VREF_SEL_8<23> VSS! VSS! nfet_01v8 L=1.5e-07 W=4.25e-07 $X=161850 $Y=46130 $dt=15
M2740 896 VREF_SEL_8<22> VSS! VSS! nfet_01v8 L=1.5e-07 W=4.25e-07 $X=161850 $Y=54410 $dt=15
M2741 897 VREF_SEL_8<21> VSS! VSS! nfet_01v8 L=1.5e-07 W=4.25e-07 $X=161850 $Y=62690 $dt=15
M2742 898 VREF_SEL_4<6> VSS! VSS! nfet_01v8 L=1.5e-07 W=4.25e-07 $X=161850 $Y=70970 $dt=15
M2743 899 VREF_SEL_4<5> VSS! VSS! nfet_01v8 L=1.5e-07 W=4.25e-07 $X=161850 $Y=79250 $dt=15
M2744 900 VREF_SEL_1<1> VSS! VSS! nfet_01v8 L=1.5e-07 W=4.25e-07 $X=161850 $Y=87530 $dt=15
M2745 901 VREF_SEL_2 VSS! VSS! nfet_01v8 L=1.5e-07 W=4.25e-07 $X=161850 $Y=95810 $dt=15
M2746 902 VREF_SEL_4<4> VSS! VSS! nfet_01v8 L=1.5e-07 W=4.25e-07 $X=161850 $Y=104090 $dt=15
M2747 903 VREF_SEL_8<20> VSS! VSS! nfet_01v8 L=1.5e-07 W=4.25e-07 $X=161850 $Y=112370 $dt=15
M2748 904 VREF_SEL_8<19> VSS! VSS! nfet_01v8 L=1.5e-07 W=4.25e-07 $X=161850 $Y=120650 $dt=15
M2749 905 VREF_SEL_8<18> VSS! VSS! nfet_01v8 L=1.5e-07 W=4.25e-07 $X=161850 $Y=128930 $dt=15
M2750 906 VREF_SEL_8<17> VSS! VSS! nfet_01v8 L=1.5e-07 W=4.25e-07 $X=161850 $Y=137210 $dt=15
M2751 907 VREF_SEL_8<16> VSS! VSS! nfet_01v8 L=1.5e-07 W=4.25e-07 $X=161850 $Y=145490 $dt=15
M2752 908 VREF_SEL_8<15> VSS! VSS! nfet_01v8 L=1.5e-07 W=4.25e-07 $X=161850 $Y=153770 $dt=15
M2753 909 VREF_SEL_8<14> VSS! VSS! nfet_01v8 L=1.5e-07 W=4.25e-07 $X=161850 $Y=162050 $dt=15
M2754 61 4 891 VSS! nfet_01v8 L=1.5e-07 W=4.25e-07 $X=162280 $Y=13010 $dt=15
M2755 62 5 892 VSS! nfet_01v8 L=1.5e-07 W=4.25e-07 $X=162280 $Y=21290 $dt=15
M2756 63 6 893 VSS! nfet_01v8 L=1.5e-07 W=4.25e-07 $X=162280 $Y=29570 $dt=15
M2757 64 7 894 VSS! nfet_01v8 L=1.5e-07 W=4.25e-07 $X=162280 $Y=37850 $dt=15
M2758 65 8 895 VSS! nfet_01v8 L=1.5e-07 W=4.25e-07 $X=162280 $Y=46130 $dt=15
M2759 66 9 896 VSS! nfet_01v8 L=1.5e-07 W=4.25e-07 $X=162280 $Y=54410 $dt=15
M2760 67 10 897 VSS! nfet_01v8 L=1.5e-07 W=4.25e-07 $X=162280 $Y=62690 $dt=15
M2761 68 11 898 VSS! nfet_01v8 L=1.5e-07 W=4.25e-07 $X=162280 $Y=70970 $dt=15
M2762 69 12 899 VSS! nfet_01v8 L=1.5e-07 W=4.25e-07 $X=162280 $Y=79250 $dt=15
M2763 70 13 900 VSS! nfet_01v8 L=1.5e-07 W=4.25e-07 $X=162280 $Y=87530 $dt=15
M2764 71 14 901 VSS! nfet_01v8 L=1.5e-07 W=4.25e-07 $X=162280 $Y=95810 $dt=15
M2765 72 15 902 VSS! nfet_01v8 L=1.5e-07 W=4.25e-07 $X=162280 $Y=104090 $dt=15
M2766 73 16 903 VSS! nfet_01v8 L=1.5e-07 W=4.25e-07 $X=162280 $Y=112370 $dt=15
M2767 74 17 904 VSS! nfet_01v8 L=1.5e-07 W=4.25e-07 $X=162280 $Y=120650 $dt=15
M2768 75 18 905 VSS! nfet_01v8 L=1.5e-07 W=4.25e-07 $X=162280 $Y=128930 $dt=15
M2769 76 19 906 VSS! nfet_01v8 L=1.5e-07 W=4.25e-07 $X=162280 $Y=137210 $dt=15
M2770 77 20 907 VSS! nfet_01v8 L=1.5e-07 W=4.25e-07 $X=162280 $Y=145490 $dt=15
M2771 78 21 908 VSS! nfet_01v8 L=1.5e-07 W=4.25e-07 $X=162280 $Y=153770 $dt=15
M2772 79 22 909 VSS! nfet_01v8 L=1.5e-07 W=4.25e-07 $X=162280 $Y=162050 $dt=15
M2773 23 VREF_SEL_8<27> VSS! VSS! nfet_01v8 L=1.5e-07 W=7.6e-07 $X=163150 $Y=11070 $dt=15
M2774 24 VREF_SEL_8<26> VSS! VSS! nfet_01v8 L=1.5e-07 W=7.6e-07 $X=163150 $Y=19350 $dt=15
M2775 25 VREF_SEL_8<25> VSS! VSS! nfet_01v8 L=1.5e-07 W=7.6e-07 $X=163150 $Y=27630 $dt=15
M2776 26 VREF_SEL_8<24> VSS! VSS! nfet_01v8 L=1.5e-07 W=7.6e-07 $X=163150 $Y=35910 $dt=15
M2777 27 VREF_SEL_8<23> VSS! VSS! nfet_01v8 L=1.5e-07 W=7.6e-07 $X=163150 $Y=44190 $dt=15
M2778 28 VREF_SEL_8<22> VSS! VSS! nfet_01v8 L=1.5e-07 W=7.6e-07 $X=163150 $Y=52470 $dt=15
M2779 29 VREF_SEL_8<21> VSS! VSS! nfet_01v8 L=1.5e-07 W=7.6e-07 $X=163150 $Y=60750 $dt=15
M2780 30 VREF_SEL_4<6> VSS! VSS! nfet_01v8 L=1.5e-07 W=7.6e-07 $X=163150 $Y=69030 $dt=15
M2781 31 VREF_SEL_4<5> VSS! VSS! nfet_01v8 L=1.5e-07 W=7.6e-07 $X=163150 $Y=77310 $dt=15
M2782 32 VREF_SEL_1<1> VSS! VSS! nfet_01v8 L=1.5e-07 W=7.6e-07 $X=163150 $Y=85590 $dt=15
M2783 33 VREF_SEL_2 VSS! VSS! nfet_01v8 L=1.5e-07 W=7.6e-07 $X=163150 $Y=93870 $dt=15
M2784 34 VREF_SEL_4<4> VSS! VSS! nfet_01v8 L=1.5e-07 W=7.6e-07 $X=163150 $Y=102150 $dt=15
M2785 35 VREF_SEL_8<20> VSS! VSS! nfet_01v8 L=1.5e-07 W=7.6e-07 $X=163150 $Y=110430 $dt=15
M2786 36 VREF_SEL_8<19> VSS! VSS! nfet_01v8 L=1.5e-07 W=7.6e-07 $X=163150 $Y=118710 $dt=15
M2787 37 VREF_SEL_8<18> VSS! VSS! nfet_01v8 L=1.5e-07 W=7.6e-07 $X=163150 $Y=126990 $dt=15
M2788 38 VREF_SEL_8<17> VSS! VSS! nfet_01v8 L=1.5e-07 W=7.6e-07 $X=163150 $Y=135270 $dt=15
M2789 39 VREF_SEL_8<16> VSS! VSS! nfet_01v8 L=1.5e-07 W=7.6e-07 $X=163150 $Y=143550 $dt=15
M2790 40 VREF_SEL_8<15> VSS! VSS! nfet_01v8 L=1.5e-07 W=7.6e-07 $X=163150 $Y=151830 $dt=15
M2791 41 VREF_SEL_8<14> VSS! VSS! nfet_01v8 L=1.5e-07 W=7.6e-07 $X=163150 $Y=160110 $dt=15
M2792 VSS! SAMPLE 23 VSS! nfet_01v8 L=1.5e-07 W=7.6e-07 $X=163620 $Y=11070 $dt=15
M2793 VSS! SAMPLE 24 VSS! nfet_01v8 L=1.5e-07 W=7.6e-07 $X=163620 $Y=19350 $dt=15
M2794 VSS! SAMPLE 25 VSS! nfet_01v8 L=1.5e-07 W=7.6e-07 $X=163620 $Y=27630 $dt=15
M2795 VSS! SAMPLE 26 VSS! nfet_01v8 L=1.5e-07 W=7.6e-07 $X=163620 $Y=35910 $dt=15
M2796 VSS! SAMPLE 27 VSS! nfet_01v8 L=1.5e-07 W=7.6e-07 $X=163620 $Y=44190 $dt=15
M2797 VSS! SAMPLE 28 VSS! nfet_01v8 L=1.5e-07 W=7.6e-07 $X=163620 $Y=52470 $dt=15
M2798 VSS! SAMPLE 29 VSS! nfet_01v8 L=1.5e-07 W=7.6e-07 $X=163620 $Y=60750 $dt=15
M2799 VSS! SAMPLE 30 VSS! nfet_01v8 L=1.5e-07 W=7.6e-07 $X=163620 $Y=69030 $dt=15
M2800 VSS! SAMPLE 31 VSS! nfet_01v8 L=1.5e-07 W=7.6e-07 $X=163620 $Y=77310 $dt=15
M2801 VSS! SAMPLE 32 VSS! nfet_01v8 L=1.5e-07 W=7.6e-07 $X=163620 $Y=85590 $dt=15
M2802 VSS! SAMPLE 33 VSS! nfet_01v8 L=1.5e-07 W=7.6e-07 $X=163620 $Y=93870 $dt=15
M2803 VSS! SAMPLE 34 VSS! nfet_01v8 L=1.5e-07 W=7.6e-07 $X=163620 $Y=102150 $dt=15
M2804 VSS! SAMPLE 35 VSS! nfet_01v8 L=1.5e-07 W=7.6e-07 $X=163620 $Y=110430 $dt=15
M2805 VSS! SAMPLE 36 VSS! nfet_01v8 L=1.5e-07 W=7.6e-07 $X=163620 $Y=118710 $dt=15
M2806 VSS! SAMPLE 37 VSS! nfet_01v8 L=1.5e-07 W=7.6e-07 $X=163620 $Y=126990 $dt=15
M2807 VSS! SAMPLE 38 VSS! nfet_01v8 L=1.5e-07 W=7.6e-07 $X=163620 $Y=135270 $dt=15
M2808 VSS! SAMPLE 39 VSS! nfet_01v8 L=1.5e-07 W=7.6e-07 $X=163620 $Y=143550 $dt=15
M2809 VSS! SAMPLE 40 VSS! nfet_01v8 L=1.5e-07 W=7.6e-07 $X=163620 $Y=151830 $dt=15
M2810 VSS! SAMPLE 41 VSS! nfet_01v8 L=1.5e-07 W=7.6e-07 $X=163620 $Y=160110 $dt=15
M2811 VSS! SAMPLE 4 VSS! nfet_01v8 L=1.5e-07 W=7.6e-07 $X=163660 $Y=13010 $dt=15
M2812 VSS! SAMPLE 5 VSS! nfet_01v8 L=1.5e-07 W=7.6e-07 $X=163660 $Y=21290 $dt=15
M2813 VSS! SAMPLE 6 VSS! nfet_01v8 L=1.5e-07 W=7.6e-07 $X=163660 $Y=29570 $dt=15
M2814 VSS! SAMPLE 7 VSS! nfet_01v8 L=1.5e-07 W=7.6e-07 $X=163660 $Y=37850 $dt=15
M2815 VSS! SAMPLE 8 VSS! nfet_01v8 L=1.5e-07 W=7.6e-07 $X=163660 $Y=46130 $dt=15
M2816 VSS! SAMPLE 9 VSS! nfet_01v8 L=1.5e-07 W=7.6e-07 $X=163660 $Y=54410 $dt=15
M2817 VSS! SAMPLE 10 VSS! nfet_01v8 L=1.5e-07 W=7.6e-07 $X=163660 $Y=62690 $dt=15
M2818 VSS! SAMPLE 11 VSS! nfet_01v8 L=1.5e-07 W=7.6e-07 $X=163660 $Y=70970 $dt=15
M2819 VSS! SAMPLE 12 VSS! nfet_01v8 L=1.5e-07 W=7.6e-07 $X=163660 $Y=79250 $dt=15
M2820 VSS! SAMPLE 13 VSS! nfet_01v8 L=1.5e-07 W=7.6e-07 $X=163660 $Y=87530 $dt=15
M2821 VSS! SAMPLE 14 VSS! nfet_01v8 L=1.5e-07 W=7.6e-07 $X=163660 $Y=95810 $dt=15
M2822 VSS! SAMPLE 15 VSS! nfet_01v8 L=1.5e-07 W=7.6e-07 $X=163660 $Y=104090 $dt=15
M2823 VSS! SAMPLE 16 VSS! nfet_01v8 L=1.5e-07 W=7.6e-07 $X=163660 $Y=112370 $dt=15
M2824 VSS! SAMPLE 17 VSS! nfet_01v8 L=1.5e-07 W=7.6e-07 $X=163660 $Y=120650 $dt=15
M2825 VSS! SAMPLE 18 VSS! nfet_01v8 L=1.5e-07 W=7.6e-07 $X=163660 $Y=128930 $dt=15
M2826 VSS! SAMPLE 19 VSS! nfet_01v8 L=1.5e-07 W=7.6e-07 $X=163660 $Y=137210 $dt=15
M2827 VSS! SAMPLE 20 VSS! nfet_01v8 L=1.5e-07 W=7.6e-07 $X=163660 $Y=145490 $dt=15
M2828 VSS! SAMPLE 21 VSS! nfet_01v8 L=1.5e-07 W=7.6e-07 $X=163660 $Y=153770 $dt=15
M2829 VSS! SAMPLE 22 VSS! nfet_01v8 L=1.5e-07 W=7.6e-07 $X=163660 $Y=162050 $dt=15
M2830 852 SAMPLE VDD! VDD! pfet_01v8 L=1.5e-07 W=1.13e-06 $X=2360 $Y=14840 $dt=16
M2831 853 SAMPLE VDD! VDD! pfet_01v8 L=1.5e-07 W=1.13e-06 $X=2360 $Y=23120 $dt=16
M2832 854 SAMPLE VDD! VDD! pfet_01v8 L=1.5e-07 W=1.13e-06 $X=2360 $Y=31400 $dt=16
M2833 855 SAMPLE VDD! VDD! pfet_01v8 L=1.5e-07 W=1.13e-06 $X=2360 $Y=39680 $dt=16
M2834 856 SAMPLE VDD! VDD! pfet_01v8 L=1.5e-07 W=1.13e-06 $X=2360 $Y=47960 $dt=16
M2835 857 SAMPLE VDD! VDD! pfet_01v8 L=1.5e-07 W=1.13e-06 $X=2360 $Y=56240 $dt=16
M2836 858 SAMPLE VDD! VDD! pfet_01v8 L=1.5e-07 W=1.13e-06 $X=2360 $Y=64520 $dt=16
M2837 859 SAMPLE VDD! VDD! pfet_01v8 L=1.5e-07 W=1.13e-06 $X=2360 $Y=72800 $dt=16
M2838 860 SAMPLE VDD! VDD! pfet_01v8 L=1.5e-07 W=1.13e-06 $X=2360 $Y=81080 $dt=16
M2839 861 SAMPLE VDD! VDD! pfet_01v8 L=1.5e-07 W=1.13e-06 $X=2360 $Y=89360 $dt=16
M2840 862 SAMPLE VDD! VDD! pfet_01v8 L=1.5e-07 W=1.13e-06 $X=2360 $Y=97640 $dt=16
M2841 863 SAMPLE VDD! VDD! pfet_01v8 L=1.5e-07 W=1.13e-06 $X=2360 $Y=105920 $dt=16
M2842 864 SAMPLE VDD! VDD! pfet_01v8 L=1.5e-07 W=1.13e-06 $X=2360 $Y=114200 $dt=16
M2843 865 SAMPLE VDD! VDD! pfet_01v8 L=1.5e-07 W=1.13e-06 $X=2360 $Y=122480 $dt=16
M2844 866 SAMPLE VDD! VDD! pfet_01v8 L=1.5e-07 W=1.13e-06 $X=2360 $Y=130760 $dt=16
M2845 867 SAMPLE VDD! VDD! pfet_01v8 L=1.5e-07 W=1.13e-06 $X=2360 $Y=139040 $dt=16
M2846 868 SAMPLE VDD! VDD! pfet_01v8 L=1.5e-07 W=1.13e-06 $X=2360 $Y=147320 $dt=16
M2847 869 SAMPLE VDD! VDD! pfet_01v8 L=1.5e-07 W=1.13e-06 $X=2360 $Y=155600 $dt=16
M2848 870 SAMPLE VDD! VDD! pfet_01v8 L=1.5e-07 W=1.13e-06 $X=2360 $Y=163880 $dt=16
M2849 967 SAMPLE VDD! VDD! pfet_01v8 L=1.5e-07 W=1.13e-06 $X=2400 $Y=8870 $dt=16
M2850 968 SAMPLE VDD! VDD! pfet_01v8 L=1.5e-07 W=1.13e-06 $X=2400 $Y=17150 $dt=16
M2851 969 SAMPLE VDD! VDD! pfet_01v8 L=1.5e-07 W=1.13e-06 $X=2400 $Y=25430 $dt=16
M2852 970 SAMPLE VDD! VDD! pfet_01v8 L=1.5e-07 W=1.13e-06 $X=2400 $Y=33710 $dt=16
M2853 971 SAMPLE VDD! VDD! pfet_01v8 L=1.5e-07 W=1.13e-06 $X=2400 $Y=41990 $dt=16
M2854 972 SAMPLE VDD! VDD! pfet_01v8 L=1.5e-07 W=1.13e-06 $X=2400 $Y=50270 $dt=16
M2855 973 SAMPLE VDD! VDD! pfet_01v8 L=1.5e-07 W=1.13e-06 $X=2400 $Y=58550 $dt=16
M2856 974 SAMPLE VDD! VDD! pfet_01v8 L=1.5e-07 W=1.13e-06 $X=2400 $Y=66830 $dt=16
M2857 975 SAMPLE VDD! VDD! pfet_01v8 L=1.5e-07 W=1.13e-06 $X=2400 $Y=75110 $dt=16
M2858 976 SAMPLE VDD! VDD! pfet_01v8 L=1.5e-07 W=1.13e-06 $X=2400 $Y=83390 $dt=16
M2859 977 SAMPLE VDD! VDD! pfet_01v8 L=1.5e-07 W=1.13e-06 $X=2400 $Y=91670 $dt=16
M2860 978 SAMPLE VDD! VDD! pfet_01v8 L=1.5e-07 W=1.13e-06 $X=2400 $Y=99950 $dt=16
M2861 979 SAMPLE VDD! VDD! pfet_01v8 L=1.5e-07 W=1.13e-06 $X=2400 $Y=108230 $dt=16
M2862 980 SAMPLE VDD! VDD! pfet_01v8 L=1.5e-07 W=1.13e-06 $X=2400 $Y=116510 $dt=16
M2863 981 SAMPLE VDD! VDD! pfet_01v8 L=1.5e-07 W=1.13e-06 $X=2400 $Y=124790 $dt=16
M2864 982 SAMPLE VDD! VDD! pfet_01v8 L=1.5e-07 W=1.13e-06 $X=2400 $Y=133070 $dt=16
M2865 983 SAMPLE VDD! VDD! pfet_01v8 L=1.5e-07 W=1.13e-06 $X=2400 $Y=141350 $dt=16
M2866 984 SAMPLE VDD! VDD! pfet_01v8 L=1.5e-07 W=1.13e-06 $X=2400 $Y=149630 $dt=16
M2867 985 SAMPLE VDD! VDD! pfet_01v8 L=1.5e-07 W=1.13e-06 $X=2400 $Y=157910 $dt=16
M2868 720 VREF_SEL_8<13> 967 VDD! pfet_01v8 L=1.5e-07 W=1.13e-06 $X=2870 $Y=8870 $dt=16
M2869 722 VREF_SEL_8<12> 968 VDD! pfet_01v8 L=1.5e-07 W=1.13e-06 $X=2870 $Y=17150 $dt=16
M2870 724 VREF_SEL_8<11> 969 VDD! pfet_01v8 L=1.5e-07 W=1.13e-06 $X=2870 $Y=25430 $dt=16
M2871 726 VREF_SEL_8<10> 970 VDD! pfet_01v8 L=1.5e-07 W=1.13e-06 $X=2870 $Y=33710 $dt=16
M2872 728 VREF_SEL_8<9> 971 VDD! pfet_01v8 L=1.5e-07 W=1.13e-06 $X=2870 $Y=41990 $dt=16
M2873 730 VREF_SEL_8<8> 972 VDD! pfet_01v8 L=1.5e-07 W=1.13e-06 $X=2870 $Y=50270 $dt=16
M2874 732 VREF_SEL_8<7> 973 VDD! pfet_01v8 L=1.5e-07 W=1.13e-06 $X=2870 $Y=58550 $dt=16
M2875 734 VREF_SEL_4<3> 974 VDD! pfet_01v8 L=1.5e-07 W=1.13e-06 $X=2870 $Y=66830 $dt=16
M2876 736 VREF_SEL_4<2> 975 VDD! pfet_01v8 L=1.5e-07 W=1.13e-06 $X=2870 $Y=75110 $dt=16
M2877 738 VREF_SEL_1<0> 976 VDD! pfet_01v8 L=1.5e-07 W=1.13e-06 $X=2870 $Y=83390 $dt=16
M2878 740 VREF_SEL_4<1> 977 VDD! pfet_01v8 L=1.5e-07 W=1.13e-06 $X=2870 $Y=91670 $dt=16
M2879 742 VREF_SEL_4<0> 978 VDD! pfet_01v8 L=1.5e-07 W=1.13e-06 $X=2870 $Y=99950 $dt=16
M2880 744 VREF_SEL_8<6> 979 VDD! pfet_01v8 L=1.5e-07 W=1.13e-06 $X=2870 $Y=108230 $dt=16
M2881 746 VREF_SEL_8<5> 980 VDD! pfet_01v8 L=1.5e-07 W=1.13e-06 $X=2870 $Y=116510 $dt=16
M2882 748 VREF_SEL_8<4> 981 VDD! pfet_01v8 L=1.5e-07 W=1.13e-06 $X=2870 $Y=124790 $dt=16
M2883 750 VREF_SEL_8<3> 982 VDD! pfet_01v8 L=1.5e-07 W=1.13e-06 $X=2870 $Y=133070 $dt=16
M2884 752 VREF_SEL_8<2> 983 VDD! pfet_01v8 L=1.5e-07 W=1.13e-06 $X=2870 $Y=141350 $dt=16
M2885 754 VREF_SEL_8<1> 984 VDD! pfet_01v8 L=1.5e-07 W=1.13e-06 $X=2870 $Y=149630 $dt=16
M2886 756 VREF_SEL_8<0> 985 VDD! pfet_01v8 L=1.5e-07 W=1.13e-06 $X=2870 $Y=157910 $dt=16
M2887 833 852 VDD! VDD! pfet_01v8 L=1.5e-07 W=6.25e-07 $X=3740 $Y=15345 $dt=16
M2888 834 853 VDD! VDD! pfet_01v8 L=1.5e-07 W=6.25e-07 $X=3740 $Y=23625 $dt=16
M2889 835 854 VDD! VDD! pfet_01v8 L=1.5e-07 W=6.25e-07 $X=3740 $Y=31905 $dt=16
M2890 836 855 VDD! VDD! pfet_01v8 L=1.5e-07 W=6.25e-07 $X=3740 $Y=40185 $dt=16
M2891 837 856 VDD! VDD! pfet_01v8 L=1.5e-07 W=6.25e-07 $X=3740 $Y=48465 $dt=16
M2892 838 857 VDD! VDD! pfet_01v8 L=1.5e-07 W=6.25e-07 $X=3740 $Y=56745 $dt=16
M2893 839 858 VDD! VDD! pfet_01v8 L=1.5e-07 W=6.25e-07 $X=3740 $Y=65025 $dt=16
M2894 840 859 VDD! VDD! pfet_01v8 L=1.5e-07 W=6.25e-07 $X=3740 $Y=73305 $dt=16
M2895 841 860 VDD! VDD! pfet_01v8 L=1.5e-07 W=6.25e-07 $X=3740 $Y=81585 $dt=16
M2896 842 861 VDD! VDD! pfet_01v8 L=1.5e-07 W=6.25e-07 $X=3740 $Y=89865 $dt=16
M2897 843 862 VDD! VDD! pfet_01v8 L=1.5e-07 W=6.25e-07 $X=3740 $Y=98145 $dt=16
M2898 844 863 VDD! VDD! pfet_01v8 L=1.5e-07 W=6.25e-07 $X=3740 $Y=106425 $dt=16
M2899 845 864 VDD! VDD! pfet_01v8 L=1.5e-07 W=6.25e-07 $X=3740 $Y=114705 $dt=16
M2900 846 865 VDD! VDD! pfet_01v8 L=1.5e-07 W=6.25e-07 $X=3740 $Y=122985 $dt=16
M2901 847 866 VDD! VDD! pfet_01v8 L=1.5e-07 W=6.25e-07 $X=3740 $Y=131265 $dt=16
M2902 848 867 VDD! VDD! pfet_01v8 L=1.5e-07 W=6.25e-07 $X=3740 $Y=139545 $dt=16
M2903 849 868 VDD! VDD! pfet_01v8 L=1.5e-07 W=6.25e-07 $X=3740 $Y=147825 $dt=16
M2904 850 869 VDD! VDD! pfet_01v8 L=1.5e-07 W=6.25e-07 $X=3740 $Y=156105 $dt=16
M2905 851 870 VDD! VDD! pfet_01v8 L=1.5e-07 W=6.25e-07 $X=3740 $Y=164385 $dt=16
M2906 VDD! VREF_SEL_8<13> 833 VDD! pfet_01v8 L=1.5e-07 W=6.25e-07 $X=4170 $Y=15345 $dt=16
M2907 VDD! VREF_SEL_8<12> 834 VDD! pfet_01v8 L=1.5e-07 W=6.25e-07 $X=4170 $Y=23625 $dt=16
M2908 VDD! VREF_SEL_8<11> 835 VDD! pfet_01v8 L=1.5e-07 W=6.25e-07 $X=4170 $Y=31905 $dt=16
M2909 VDD! VREF_SEL_8<10> 836 VDD! pfet_01v8 L=1.5e-07 W=6.25e-07 $X=4170 $Y=40185 $dt=16
M2910 VDD! VREF_SEL_8<9> 837 VDD! pfet_01v8 L=1.5e-07 W=6.25e-07 $X=4170 $Y=48465 $dt=16
M2911 VDD! VREF_SEL_8<8> 838 VDD! pfet_01v8 L=1.5e-07 W=6.25e-07 $X=4170 $Y=56745 $dt=16
M2912 VDD! VREF_SEL_8<7> 839 VDD! pfet_01v8 L=1.5e-07 W=6.25e-07 $X=4170 $Y=65025 $dt=16
M2913 VDD! VREF_SEL_4<3> 840 VDD! pfet_01v8 L=1.5e-07 W=6.25e-07 $X=4170 $Y=73305 $dt=16
M2914 VDD! VREF_SEL_4<2> 841 VDD! pfet_01v8 L=1.5e-07 W=6.25e-07 $X=4170 $Y=81585 $dt=16
M2915 VDD! VREF_SEL_1<0> 842 VDD! pfet_01v8 L=1.5e-07 W=6.25e-07 $X=4170 $Y=89865 $dt=16
M2916 VDD! VREF_SEL_4<1> 843 VDD! pfet_01v8 L=1.5e-07 W=6.25e-07 $X=4170 $Y=98145 $dt=16
M2917 VDD! VREF_SEL_4<0> 844 VDD! pfet_01v8 L=1.5e-07 W=6.25e-07 $X=4170 $Y=106425 $dt=16
M2918 VDD! VREF_SEL_8<6> 845 VDD! pfet_01v8 L=1.5e-07 W=6.25e-07 $X=4170 $Y=114705 $dt=16
M2919 VDD! VREF_SEL_8<5> 846 VDD! pfet_01v8 L=1.5e-07 W=6.25e-07 $X=4170 $Y=122985 $dt=16
M2920 VDD! VREF_SEL_8<4> 847 VDD! pfet_01v8 L=1.5e-07 W=6.25e-07 $X=4170 $Y=131265 $dt=16
M2921 VDD! VREF_SEL_8<3> 848 VDD! pfet_01v8 L=1.5e-07 W=6.25e-07 $X=4170 $Y=139545 $dt=16
M2922 VDD! VREF_SEL_8<2> 849 VDD! pfet_01v8 L=1.5e-07 W=6.25e-07 $X=4170 $Y=147825 $dt=16
M2923 VDD! VREF_SEL_8<1> 850 VDD! pfet_01v8 L=1.5e-07 W=6.25e-07 $X=4170 $Y=156105 $dt=16
M2924 VDD! VREF_SEL_8<0> 851 VDD! pfet_01v8 L=1.5e-07 W=6.25e-07 $X=4170 $Y=164385 $dt=16
M2925 814 SAMPLE VDD! VDD! pfet_01v8 L=1.5e-07 W=6.25e-07 $X=4200 $Y=8870 $dt=16
M2926 815 SAMPLE VDD! VDD! pfet_01v8 L=1.5e-07 W=6.25e-07 $X=4200 $Y=17150 $dt=16
M2927 816 SAMPLE VDD! VDD! pfet_01v8 L=1.5e-07 W=6.25e-07 $X=4200 $Y=25430 $dt=16
M2928 817 SAMPLE VDD! VDD! pfet_01v8 L=1.5e-07 W=6.25e-07 $X=4200 $Y=33710 $dt=16
M2929 818 SAMPLE VDD! VDD! pfet_01v8 L=1.5e-07 W=6.25e-07 $X=4200 $Y=41990 $dt=16
M2930 819 SAMPLE VDD! VDD! pfet_01v8 L=1.5e-07 W=6.25e-07 $X=4200 $Y=50270 $dt=16
M2931 820 SAMPLE VDD! VDD! pfet_01v8 L=1.5e-07 W=6.25e-07 $X=4200 $Y=58550 $dt=16
M2932 821 SAMPLE VDD! VDD! pfet_01v8 L=1.5e-07 W=6.25e-07 $X=4200 $Y=66830 $dt=16
M2933 822 SAMPLE VDD! VDD! pfet_01v8 L=1.5e-07 W=6.25e-07 $X=4200 $Y=75110 $dt=16
M2934 823 SAMPLE VDD! VDD! pfet_01v8 L=1.5e-07 W=6.25e-07 $X=4200 $Y=83390 $dt=16
M2935 824 SAMPLE VDD! VDD! pfet_01v8 L=1.5e-07 W=6.25e-07 $X=4200 $Y=91670 $dt=16
M2936 825 SAMPLE VDD! VDD! pfet_01v8 L=1.5e-07 W=6.25e-07 $X=4200 $Y=99950 $dt=16
M2937 826 SAMPLE VDD! VDD! pfet_01v8 L=1.5e-07 W=6.25e-07 $X=4200 $Y=108230 $dt=16
M2938 827 SAMPLE VDD! VDD! pfet_01v8 L=1.5e-07 W=6.25e-07 $X=4200 $Y=116510 $dt=16
M2939 828 SAMPLE VDD! VDD! pfet_01v8 L=1.5e-07 W=6.25e-07 $X=4200 $Y=124790 $dt=16
M2940 829 SAMPLE VDD! VDD! pfet_01v8 L=1.5e-07 W=6.25e-07 $X=4200 $Y=133070 $dt=16
M2941 830 SAMPLE VDD! VDD! pfet_01v8 L=1.5e-07 W=6.25e-07 $X=4200 $Y=141350 $dt=16
M2942 831 SAMPLE VDD! VDD! pfet_01v8 L=1.5e-07 W=6.25e-07 $X=4200 $Y=149630 $dt=16
M2943 832 SAMPLE VDD! VDD! pfet_01v8 L=1.5e-07 W=6.25e-07 $X=4200 $Y=157910 $dt=16
M2944 VDD! VREF_SEL_8<13> 814 VDD! pfet_01v8 L=1.5e-07 W=6.25e-07 $X=4630 $Y=8870 $dt=16
M2945 VDD! VREF_SEL_8<12> 815 VDD! pfet_01v8 L=1.5e-07 W=6.25e-07 $X=4630 $Y=17150 $dt=16
M2946 VDD! VREF_SEL_8<11> 816 VDD! pfet_01v8 L=1.5e-07 W=6.25e-07 $X=4630 $Y=25430 $dt=16
M2947 VDD! VREF_SEL_8<10> 817 VDD! pfet_01v8 L=1.5e-07 W=6.25e-07 $X=4630 $Y=33710 $dt=16
M2948 VDD! VREF_SEL_8<9> 818 VDD! pfet_01v8 L=1.5e-07 W=6.25e-07 $X=4630 $Y=41990 $dt=16
M2949 VDD! VREF_SEL_8<8> 819 VDD! pfet_01v8 L=1.5e-07 W=6.25e-07 $X=4630 $Y=50270 $dt=16
M2950 VDD! VREF_SEL_8<7> 820 VDD! pfet_01v8 L=1.5e-07 W=6.25e-07 $X=4630 $Y=58550 $dt=16
M2951 VDD! VREF_SEL_4<3> 821 VDD! pfet_01v8 L=1.5e-07 W=6.25e-07 $X=4630 $Y=66830 $dt=16
M2952 VDD! VREF_SEL_4<2> 822 VDD! pfet_01v8 L=1.5e-07 W=6.25e-07 $X=4630 $Y=75110 $dt=16
M2953 VDD! VREF_SEL_1<0> 823 VDD! pfet_01v8 L=1.5e-07 W=6.25e-07 $X=4630 $Y=83390 $dt=16
M2954 VDD! VREF_SEL_4<1> 824 VDD! pfet_01v8 L=1.5e-07 W=6.25e-07 $X=4630 $Y=91670 $dt=16
M2955 VDD! VREF_SEL_4<0> 825 VDD! pfet_01v8 L=1.5e-07 W=6.25e-07 $X=4630 $Y=99950 $dt=16
M2956 VDD! VREF_SEL_8<6> 826 VDD! pfet_01v8 L=1.5e-07 W=6.25e-07 $X=4630 $Y=108230 $dt=16
M2957 VDD! VREF_SEL_8<5> 827 VDD! pfet_01v8 L=1.5e-07 W=6.25e-07 $X=4630 $Y=116510 $dt=16
M2958 VDD! VREF_SEL_8<4> 828 VDD! pfet_01v8 L=1.5e-07 W=6.25e-07 $X=4630 $Y=124790 $dt=16
M2959 VDD! VREF_SEL_8<3> 829 VDD! pfet_01v8 L=1.5e-07 W=6.25e-07 $X=4630 $Y=133070 $dt=16
M2960 VDD! VREF_SEL_8<2> 830 VDD! pfet_01v8 L=1.5e-07 W=6.25e-07 $X=4630 $Y=141350 $dt=16
M2961 VDD! VREF_SEL_8<1> 831 VDD! pfet_01v8 L=1.5e-07 W=6.25e-07 $X=4630 $Y=149630 $dt=16
M2962 VDD! VREF_SEL_8<0> 832 VDD! pfet_01v8 L=1.5e-07 W=6.25e-07 $X=4630 $Y=157910 $dt=16
M2963 719 833 VDD! VDD! pfet_01v8 L=1.5e-07 W=1.13e-06 $X=4660 $Y=14840 $dt=16
M2964 721 834 VDD! VDD! pfet_01v8 L=1.5e-07 W=1.13e-06 $X=4660 $Y=23120 $dt=16
M2965 723 835 VDD! VDD! pfet_01v8 L=1.5e-07 W=1.13e-06 $X=4660 $Y=31400 $dt=16
M2966 725 836 VDD! VDD! pfet_01v8 L=1.5e-07 W=1.13e-06 $X=4660 $Y=39680 $dt=16
M2967 727 837 VDD! VDD! pfet_01v8 L=1.5e-07 W=1.13e-06 $X=4660 $Y=47960 $dt=16
M2968 729 838 VDD! VDD! pfet_01v8 L=1.5e-07 W=1.13e-06 $X=4660 $Y=56240 $dt=16
M2969 731 839 VDD! VDD! pfet_01v8 L=1.5e-07 W=1.13e-06 $X=4660 $Y=64520 $dt=16
M2970 733 840 VDD! VDD! pfet_01v8 L=1.5e-07 W=1.13e-06 $X=4660 $Y=72800 $dt=16
M2971 735 841 VDD! VDD! pfet_01v8 L=1.5e-07 W=1.13e-06 $X=4660 $Y=81080 $dt=16
M2972 737 842 VDD! VDD! pfet_01v8 L=1.5e-07 W=1.13e-06 $X=4660 $Y=89360 $dt=16
M2973 739 843 VDD! VDD! pfet_01v8 L=1.5e-07 W=1.13e-06 $X=4660 $Y=97640 $dt=16
M2974 741 844 VDD! VDD! pfet_01v8 L=1.5e-07 W=1.13e-06 $X=4660 $Y=105920 $dt=16
M2975 743 845 VDD! VDD! pfet_01v8 L=1.5e-07 W=1.13e-06 $X=4660 $Y=114200 $dt=16
M2976 745 846 VDD! VDD! pfet_01v8 L=1.5e-07 W=1.13e-06 $X=4660 $Y=122480 $dt=16
M2977 747 847 VDD! VDD! pfet_01v8 L=1.5e-07 W=1.13e-06 $X=4660 $Y=130760 $dt=16
M2978 749 848 VDD! VDD! pfet_01v8 L=1.5e-07 W=1.13e-06 $X=4660 $Y=139040 $dt=16
M2979 751 849 VDD! VDD! pfet_01v8 L=1.5e-07 W=1.13e-06 $X=4660 $Y=147320 $dt=16
M2980 753 850 VDD! VDD! pfet_01v8 L=1.5e-07 W=1.13e-06 $X=4660 $Y=155600 $dt=16
M2981 755 851 VDD! VDD! pfet_01v8 L=1.5e-07 W=1.13e-06 $X=4660 $Y=163880 $dt=16
M2982 681 814 VDD! VDD! pfet_01v8 L=1.5e-07 W=1.13e-06 $X=5120 $Y=8870 $dt=16
M2983 682 815 VDD! VDD! pfet_01v8 L=1.5e-07 W=1.13e-06 $X=5120 $Y=17150 $dt=16
M2984 683 816 VDD! VDD! pfet_01v8 L=1.5e-07 W=1.13e-06 $X=5120 $Y=25430 $dt=16
M2985 684 817 VDD! VDD! pfet_01v8 L=1.5e-07 W=1.13e-06 $X=5120 $Y=33710 $dt=16
M2986 685 818 VDD! VDD! pfet_01v8 L=1.5e-07 W=1.13e-06 $X=5120 $Y=41990 $dt=16
M2987 686 819 VDD! VDD! pfet_01v8 L=1.5e-07 W=1.13e-06 $X=5120 $Y=50270 $dt=16
M2988 687 820 VDD! VDD! pfet_01v8 L=1.5e-07 W=1.13e-06 $X=5120 $Y=58550 $dt=16
M2989 688 821 VDD! VDD! pfet_01v8 L=1.5e-07 W=1.13e-06 $X=5120 $Y=66830 $dt=16
M2990 689 822 VDD! VDD! pfet_01v8 L=1.5e-07 W=1.13e-06 $X=5120 $Y=75110 $dt=16
M2991 690 823 VDD! VDD! pfet_01v8 L=1.5e-07 W=1.13e-06 $X=5120 $Y=83390 $dt=16
M2992 691 824 VDD! VDD! pfet_01v8 L=1.5e-07 W=1.13e-06 $X=5120 $Y=91670 $dt=16
M2993 692 825 VDD! VDD! pfet_01v8 L=1.5e-07 W=1.13e-06 $X=5120 $Y=99950 $dt=16
M2994 693 826 VDD! VDD! pfet_01v8 L=1.5e-07 W=1.13e-06 $X=5120 $Y=108230 $dt=16
M2995 694 827 VDD! VDD! pfet_01v8 L=1.5e-07 W=1.13e-06 $X=5120 $Y=116510 $dt=16
M2996 695 828 VDD! VDD! pfet_01v8 L=1.5e-07 W=1.13e-06 $X=5120 $Y=124790 $dt=16
M2997 696 829 VDD! VDD! pfet_01v8 L=1.5e-07 W=1.13e-06 $X=5120 $Y=133070 $dt=16
M2998 697 830 VDD! VDD! pfet_01v8 L=1.5e-07 W=1.13e-06 $X=5120 $Y=141350 $dt=16
M2999 698 831 VDD! VDD! pfet_01v8 L=1.5e-07 W=1.13e-06 $X=5120 $Y=149630 $dt=16
M3000 699 832 VDD! VDD! pfet_01v8 L=1.5e-07 W=1.13e-06 $X=5120 $Y=157910 $dt=16
M3001 VDD! 719 776 VDD! pfet_01v8 L=1.5e-07 W=1.13e-06 $X=6040 $Y=14840 $dt=16
M3002 VDD! 721 777 VDD! pfet_01v8 L=1.5e-07 W=1.13e-06 $X=6040 $Y=23120 $dt=16
M3003 VDD! 723 778 VDD! pfet_01v8 L=1.5e-07 W=1.13e-06 $X=6040 $Y=31400 $dt=16
M3004 VDD! 725 779 VDD! pfet_01v8 L=1.5e-07 W=1.13e-06 $X=6040 $Y=39680 $dt=16
M3005 VDD! 727 780 VDD! pfet_01v8 L=1.5e-07 W=1.13e-06 $X=6040 $Y=47960 $dt=16
M3006 VDD! 729 781 VDD! pfet_01v8 L=1.5e-07 W=1.13e-06 $X=6040 $Y=56240 $dt=16
M3007 VDD! 731 782 VDD! pfet_01v8 L=1.5e-07 W=1.13e-06 $X=6040 $Y=64520 $dt=16
M3008 VDD! 733 783 VDD! pfet_01v8 L=1.5e-07 W=1.13e-06 $X=6040 $Y=72800 $dt=16
M3009 VDD! 735 784 VDD! pfet_01v8 L=1.5e-07 W=1.13e-06 $X=6040 $Y=81080 $dt=16
M3010 VDD! 737 785 VDD! pfet_01v8 L=1.5e-07 W=1.13e-06 $X=6040 $Y=89360 $dt=16
M3011 VDD! 739 786 VDD! pfet_01v8 L=1.5e-07 W=1.13e-06 $X=6040 $Y=97640 $dt=16
M3012 VDD! 741 787 VDD! pfet_01v8 L=1.5e-07 W=1.13e-06 $X=6040 $Y=105920 $dt=16
M3013 VDD! 743 788 VDD! pfet_01v8 L=1.5e-07 W=1.13e-06 $X=6040 $Y=114200 $dt=16
M3014 VDD! 745 789 VDD! pfet_01v8 L=1.5e-07 W=1.13e-06 $X=6040 $Y=122480 $dt=16
M3015 VDD! 747 790 VDD! pfet_01v8 L=1.5e-07 W=1.13e-06 $X=6040 $Y=130760 $dt=16
M3016 VDD! 749 791 VDD! pfet_01v8 L=1.5e-07 W=1.13e-06 $X=6040 $Y=139040 $dt=16
M3017 VDD! 751 792 VDD! pfet_01v8 L=1.5e-07 W=1.13e-06 $X=6040 $Y=147320 $dt=16
M3018 VDD! 753 793 VDD! pfet_01v8 L=1.5e-07 W=1.13e-06 $X=6040 $Y=155600 $dt=16
M3019 VDD! 755 794 VDD! pfet_01v8 L=1.5e-07 W=1.13e-06 $X=6040 $Y=163880 $dt=16
M3020 534 776 VDD! VDD! pfet_01v8 L=1.5e-07 W=1.13e-06 $X=6470 $Y=14840 $dt=16
M3021 536 777 VDD! VDD! pfet_01v8 L=1.5e-07 W=1.13e-06 $X=6470 $Y=23120 $dt=16
M3022 538 778 VDD! VDD! pfet_01v8 L=1.5e-07 W=1.13e-06 $X=6470 $Y=31400 $dt=16
M3023 540 779 VDD! VDD! pfet_01v8 L=1.5e-07 W=1.13e-06 $X=6470 $Y=39680 $dt=16
M3024 542 780 VDD! VDD! pfet_01v8 L=1.5e-07 W=1.13e-06 $X=6470 $Y=47960 $dt=16
M3025 544 781 VDD! VDD! pfet_01v8 L=1.5e-07 W=1.13e-06 $X=6470 $Y=56240 $dt=16
M3026 546 782 VDD! VDD! pfet_01v8 L=1.5e-07 W=1.13e-06 $X=6470 $Y=64520 $dt=16
M3027 548 783 VDD! VDD! pfet_01v8 L=1.5e-07 W=1.13e-06 $X=6470 $Y=72800 $dt=16
M3028 550 784 VDD! VDD! pfet_01v8 L=1.5e-07 W=1.13e-06 $X=6470 $Y=81080 $dt=16
M3029 552 785 VDD! VDD! pfet_01v8 L=1.5e-07 W=1.13e-06 $X=6470 $Y=89360 $dt=16
M3030 554 786 VDD! VDD! pfet_01v8 L=1.5e-07 W=1.13e-06 $X=6470 $Y=97640 $dt=16
M3031 556 787 VDD! VDD! pfet_01v8 L=1.5e-07 W=1.13e-06 $X=6470 $Y=105920 $dt=16
M3032 558 788 VDD! VDD! pfet_01v8 L=1.5e-07 W=1.13e-06 $X=6470 $Y=114200 $dt=16
M3033 560 789 VDD! VDD! pfet_01v8 L=1.5e-07 W=1.13e-06 $X=6470 $Y=122480 $dt=16
M3034 562 790 VDD! VDD! pfet_01v8 L=1.5e-07 W=1.13e-06 $X=6470 $Y=130760 $dt=16
M3035 564 791 VDD! VDD! pfet_01v8 L=1.5e-07 W=1.13e-06 $X=6470 $Y=139040 $dt=16
M3036 566 792 VDD! VDD! pfet_01v8 L=1.5e-07 W=1.13e-06 $X=6470 $Y=147320 $dt=16
M3037 568 793 VDD! VDD! pfet_01v8 L=1.5e-07 W=1.13e-06 $X=6470 $Y=155600 $dt=16
M3038 570 794 VDD! VDD! pfet_01v8 L=1.5e-07 W=1.13e-06 $X=6470 $Y=163880 $dt=16
M3039 457 720 VDD! VDD! pfet_01v8 L=1.5e-07 W=1.13e-06 $X=6500 $Y=8870 $dt=16
M3040 459 722 VDD! VDD! pfet_01v8 L=1.5e-07 W=1.13e-06 $X=6500 $Y=17150 $dt=16
M3041 461 724 VDD! VDD! pfet_01v8 L=1.5e-07 W=1.13e-06 $X=6500 $Y=25430 $dt=16
M3042 463 726 VDD! VDD! pfet_01v8 L=1.5e-07 W=1.13e-06 $X=6500 $Y=33710 $dt=16
M3043 465 728 VDD! VDD! pfet_01v8 L=1.5e-07 W=1.13e-06 $X=6500 $Y=41990 $dt=16
M3044 467 730 VDD! VDD! pfet_01v8 L=1.5e-07 W=1.13e-06 $X=6500 $Y=50270 $dt=16
M3045 469 732 VDD! VDD! pfet_01v8 L=1.5e-07 W=1.13e-06 $X=6500 $Y=58550 $dt=16
M3046 471 734 VDD! VDD! pfet_01v8 L=1.5e-07 W=1.13e-06 $X=6500 $Y=66830 $dt=16
M3047 473 736 VDD! VDD! pfet_01v8 L=1.5e-07 W=1.13e-06 $X=6500 $Y=75110 $dt=16
M3048 475 738 VDD! VDD! pfet_01v8 L=1.5e-07 W=1.13e-06 $X=6500 $Y=83390 $dt=16
M3049 477 740 VDD! VDD! pfet_01v8 L=1.5e-07 W=1.13e-06 $X=6500 $Y=91670 $dt=16
M3050 479 742 VDD! VDD! pfet_01v8 L=1.5e-07 W=1.13e-06 $X=6500 $Y=99950 $dt=16
M3051 481 744 VDD! VDD! pfet_01v8 L=1.5e-07 W=1.13e-06 $X=6500 $Y=108230 $dt=16
M3052 483 746 VDD! VDD! pfet_01v8 L=1.5e-07 W=1.13e-06 $X=6500 $Y=116510 $dt=16
M3053 485 748 VDD! VDD! pfet_01v8 L=1.5e-07 W=1.13e-06 $X=6500 $Y=124790 $dt=16
M3054 487 750 VDD! VDD! pfet_01v8 L=1.5e-07 W=1.13e-06 $X=6500 $Y=133070 $dt=16
M3055 489 752 VDD! VDD! pfet_01v8 L=1.5e-07 W=1.13e-06 $X=6500 $Y=141350 $dt=16
M3056 491 754 VDD! VDD! pfet_01v8 L=1.5e-07 W=1.13e-06 $X=6500 $Y=149630 $dt=16
M3057 493 756 VDD! VDD! pfet_01v8 L=1.5e-07 W=1.13e-06 $X=6500 $Y=157910 $dt=16
M3058 VDD! 776 534 VDD! pfet_01v8 L=1.5e-07 W=1.13e-06 $X=6900 $Y=14840 $dt=16
M3059 VDD! 777 536 VDD! pfet_01v8 L=1.5e-07 W=1.13e-06 $X=6900 $Y=23120 $dt=16
M3060 VDD! 778 538 VDD! pfet_01v8 L=1.5e-07 W=1.13e-06 $X=6900 $Y=31400 $dt=16
M3061 VDD! 779 540 VDD! pfet_01v8 L=1.5e-07 W=1.13e-06 $X=6900 $Y=39680 $dt=16
M3062 VDD! 780 542 VDD! pfet_01v8 L=1.5e-07 W=1.13e-06 $X=6900 $Y=47960 $dt=16
M3063 VDD! 781 544 VDD! pfet_01v8 L=1.5e-07 W=1.13e-06 $X=6900 $Y=56240 $dt=16
M3064 VDD! 782 546 VDD! pfet_01v8 L=1.5e-07 W=1.13e-06 $X=6900 $Y=64520 $dt=16
M3065 VDD! 783 548 VDD! pfet_01v8 L=1.5e-07 W=1.13e-06 $X=6900 $Y=72800 $dt=16
M3066 VDD! 784 550 VDD! pfet_01v8 L=1.5e-07 W=1.13e-06 $X=6900 $Y=81080 $dt=16
M3067 VDD! 785 552 VDD! pfet_01v8 L=1.5e-07 W=1.13e-06 $X=6900 $Y=89360 $dt=16
M3068 VDD! 786 554 VDD! pfet_01v8 L=1.5e-07 W=1.13e-06 $X=6900 $Y=97640 $dt=16
M3069 VDD! 787 556 VDD! pfet_01v8 L=1.5e-07 W=1.13e-06 $X=6900 $Y=105920 $dt=16
M3070 VDD! 788 558 VDD! pfet_01v8 L=1.5e-07 W=1.13e-06 $X=6900 $Y=114200 $dt=16
M3071 VDD! 789 560 VDD! pfet_01v8 L=1.5e-07 W=1.13e-06 $X=6900 $Y=122480 $dt=16
M3072 VDD! 790 562 VDD! pfet_01v8 L=1.5e-07 W=1.13e-06 $X=6900 $Y=130760 $dt=16
M3073 VDD! 791 564 VDD! pfet_01v8 L=1.5e-07 W=1.13e-06 $X=6900 $Y=139040 $dt=16
M3074 VDD! 792 566 VDD! pfet_01v8 L=1.5e-07 W=1.13e-06 $X=6900 $Y=147320 $dt=16
M3075 VDD! 793 568 VDD! pfet_01v8 L=1.5e-07 W=1.13e-06 $X=6900 $Y=155600 $dt=16
M3076 VDD! 794 570 VDD! pfet_01v8 L=1.5e-07 W=1.13e-06 $X=6900 $Y=163880 $dt=16
M3077 VDD! 720 457 VDD! pfet_01v8 L=1.5e-07 W=1.13e-06 $X=6930 $Y=8870 $dt=16
M3078 VDD! 722 459 VDD! pfet_01v8 L=1.5e-07 W=1.13e-06 $X=6930 $Y=17150 $dt=16
M3079 VDD! 724 461 VDD! pfet_01v8 L=1.5e-07 W=1.13e-06 $X=6930 $Y=25430 $dt=16
M3080 VDD! 726 463 VDD! pfet_01v8 L=1.5e-07 W=1.13e-06 $X=6930 $Y=33710 $dt=16
M3081 VDD! 728 465 VDD! pfet_01v8 L=1.5e-07 W=1.13e-06 $X=6930 $Y=41990 $dt=16
M3082 VDD! 730 467 VDD! pfet_01v8 L=1.5e-07 W=1.13e-06 $X=6930 $Y=50270 $dt=16
M3083 VDD! 732 469 VDD! pfet_01v8 L=1.5e-07 W=1.13e-06 $X=6930 $Y=58550 $dt=16
M3084 VDD! 734 471 VDD! pfet_01v8 L=1.5e-07 W=1.13e-06 $X=6930 $Y=66830 $dt=16
M3085 VDD! 736 473 VDD! pfet_01v8 L=1.5e-07 W=1.13e-06 $X=6930 $Y=75110 $dt=16
M3086 VDD! 738 475 VDD! pfet_01v8 L=1.5e-07 W=1.13e-06 $X=6930 $Y=83390 $dt=16
M3087 VDD! 740 477 VDD! pfet_01v8 L=1.5e-07 W=1.13e-06 $X=6930 $Y=91670 $dt=16
M3088 VDD! 742 479 VDD! pfet_01v8 L=1.5e-07 W=1.13e-06 $X=6930 $Y=99950 $dt=16
M3089 VDD! 744 481 VDD! pfet_01v8 L=1.5e-07 W=1.13e-06 $X=6930 $Y=108230 $dt=16
M3090 VDD! 746 483 VDD! pfet_01v8 L=1.5e-07 W=1.13e-06 $X=6930 $Y=116510 $dt=16
M3091 VDD! 748 485 VDD! pfet_01v8 L=1.5e-07 W=1.13e-06 $X=6930 $Y=124790 $dt=16
M3092 VDD! 750 487 VDD! pfet_01v8 L=1.5e-07 W=1.13e-06 $X=6930 $Y=133070 $dt=16
M3093 VDD! 752 489 VDD! pfet_01v8 L=1.5e-07 W=1.13e-06 $X=6930 $Y=141350 $dt=16
M3094 VDD! 754 491 VDD! pfet_01v8 L=1.5e-07 W=1.13e-06 $X=6930 $Y=149630 $dt=16
M3095 VDD! 756 493 VDD! pfet_01v8 L=1.5e-07 W=1.13e-06 $X=6930 $Y=157910 $dt=16
M3096 534 776 VDD! VDD! pfet_01v8 L=1.5e-07 W=1.13e-06 $X=7330 $Y=14840 $dt=16
M3097 536 777 VDD! VDD! pfet_01v8 L=1.5e-07 W=1.13e-06 $X=7330 $Y=23120 $dt=16
M3098 538 778 VDD! VDD! pfet_01v8 L=1.5e-07 W=1.13e-06 $X=7330 $Y=31400 $dt=16
M3099 540 779 VDD! VDD! pfet_01v8 L=1.5e-07 W=1.13e-06 $X=7330 $Y=39680 $dt=16
M3100 542 780 VDD! VDD! pfet_01v8 L=1.5e-07 W=1.13e-06 $X=7330 $Y=47960 $dt=16
M3101 544 781 VDD! VDD! pfet_01v8 L=1.5e-07 W=1.13e-06 $X=7330 $Y=56240 $dt=16
M3102 546 782 VDD! VDD! pfet_01v8 L=1.5e-07 W=1.13e-06 $X=7330 $Y=64520 $dt=16
M3103 548 783 VDD! VDD! pfet_01v8 L=1.5e-07 W=1.13e-06 $X=7330 $Y=72800 $dt=16
M3104 550 784 VDD! VDD! pfet_01v8 L=1.5e-07 W=1.13e-06 $X=7330 $Y=81080 $dt=16
M3105 552 785 VDD! VDD! pfet_01v8 L=1.5e-07 W=1.13e-06 $X=7330 $Y=89360 $dt=16
M3106 554 786 VDD! VDD! pfet_01v8 L=1.5e-07 W=1.13e-06 $X=7330 $Y=97640 $dt=16
M3107 556 787 VDD! VDD! pfet_01v8 L=1.5e-07 W=1.13e-06 $X=7330 $Y=105920 $dt=16
M3108 558 788 VDD! VDD! pfet_01v8 L=1.5e-07 W=1.13e-06 $X=7330 $Y=114200 $dt=16
M3109 560 789 VDD! VDD! pfet_01v8 L=1.5e-07 W=1.13e-06 $X=7330 $Y=122480 $dt=16
M3110 562 790 VDD! VDD! pfet_01v8 L=1.5e-07 W=1.13e-06 $X=7330 $Y=130760 $dt=16
M3111 564 791 VDD! VDD! pfet_01v8 L=1.5e-07 W=1.13e-06 $X=7330 $Y=139040 $dt=16
M3112 566 792 VDD! VDD! pfet_01v8 L=1.5e-07 W=1.13e-06 $X=7330 $Y=147320 $dt=16
M3113 568 793 VDD! VDD! pfet_01v8 L=1.5e-07 W=1.13e-06 $X=7330 $Y=155600 $dt=16
M3114 570 794 VDD! VDD! pfet_01v8 L=1.5e-07 W=1.13e-06 $X=7330 $Y=163880 $dt=16
M3115 457 720 VDD! VDD! pfet_01v8 L=1.5e-07 W=1.13e-06 $X=7360 $Y=8870 $dt=16
M3116 459 722 VDD! VDD! pfet_01v8 L=1.5e-07 W=1.13e-06 $X=7360 $Y=17150 $dt=16
M3117 461 724 VDD! VDD! pfet_01v8 L=1.5e-07 W=1.13e-06 $X=7360 $Y=25430 $dt=16
M3118 463 726 VDD! VDD! pfet_01v8 L=1.5e-07 W=1.13e-06 $X=7360 $Y=33710 $dt=16
M3119 465 728 VDD! VDD! pfet_01v8 L=1.5e-07 W=1.13e-06 $X=7360 $Y=41990 $dt=16
M3120 467 730 VDD! VDD! pfet_01v8 L=1.5e-07 W=1.13e-06 $X=7360 $Y=50270 $dt=16
M3121 469 732 VDD! VDD! pfet_01v8 L=1.5e-07 W=1.13e-06 $X=7360 $Y=58550 $dt=16
M3122 471 734 VDD! VDD! pfet_01v8 L=1.5e-07 W=1.13e-06 $X=7360 $Y=66830 $dt=16
M3123 473 736 VDD! VDD! pfet_01v8 L=1.5e-07 W=1.13e-06 $X=7360 $Y=75110 $dt=16
M3124 475 738 VDD! VDD! pfet_01v8 L=1.5e-07 W=1.13e-06 $X=7360 $Y=83390 $dt=16
M3125 477 740 VDD! VDD! pfet_01v8 L=1.5e-07 W=1.13e-06 $X=7360 $Y=91670 $dt=16
M3126 479 742 VDD! VDD! pfet_01v8 L=1.5e-07 W=1.13e-06 $X=7360 $Y=99950 $dt=16
M3127 481 744 VDD! VDD! pfet_01v8 L=1.5e-07 W=1.13e-06 $X=7360 $Y=108230 $dt=16
M3128 483 746 VDD! VDD! pfet_01v8 L=1.5e-07 W=1.13e-06 $X=7360 $Y=116510 $dt=16
M3129 485 748 VDD! VDD! pfet_01v8 L=1.5e-07 W=1.13e-06 $X=7360 $Y=124790 $dt=16
M3130 487 750 VDD! VDD! pfet_01v8 L=1.5e-07 W=1.13e-06 $X=7360 $Y=133070 $dt=16
M3131 489 752 VDD! VDD! pfet_01v8 L=1.5e-07 W=1.13e-06 $X=7360 $Y=141350 $dt=16
M3132 491 754 VDD! VDD! pfet_01v8 L=1.5e-07 W=1.13e-06 $X=7360 $Y=149630 $dt=16
M3133 493 756 VDD! VDD! pfet_01v8 L=1.5e-07 W=1.13e-06 $X=7360 $Y=157910 $dt=16
M3134 VDD! 776 534 VDD! pfet_01v8 L=1.5e-07 W=1.13e-06 $X=7760 $Y=14840 $dt=16
M3135 VDD! 777 536 VDD! pfet_01v8 L=1.5e-07 W=1.13e-06 $X=7760 $Y=23120 $dt=16
M3136 VDD! 778 538 VDD! pfet_01v8 L=1.5e-07 W=1.13e-06 $X=7760 $Y=31400 $dt=16
M3137 VDD! 779 540 VDD! pfet_01v8 L=1.5e-07 W=1.13e-06 $X=7760 $Y=39680 $dt=16
M3138 VDD! 780 542 VDD! pfet_01v8 L=1.5e-07 W=1.13e-06 $X=7760 $Y=47960 $dt=16
M3139 VDD! 781 544 VDD! pfet_01v8 L=1.5e-07 W=1.13e-06 $X=7760 $Y=56240 $dt=16
M3140 VDD! 782 546 VDD! pfet_01v8 L=1.5e-07 W=1.13e-06 $X=7760 $Y=64520 $dt=16
M3141 VDD! 783 548 VDD! pfet_01v8 L=1.5e-07 W=1.13e-06 $X=7760 $Y=72800 $dt=16
M3142 VDD! 784 550 VDD! pfet_01v8 L=1.5e-07 W=1.13e-06 $X=7760 $Y=81080 $dt=16
M3143 VDD! 785 552 VDD! pfet_01v8 L=1.5e-07 W=1.13e-06 $X=7760 $Y=89360 $dt=16
M3144 VDD! 786 554 VDD! pfet_01v8 L=1.5e-07 W=1.13e-06 $X=7760 $Y=97640 $dt=16
M3145 VDD! 787 556 VDD! pfet_01v8 L=1.5e-07 W=1.13e-06 $X=7760 $Y=105920 $dt=16
M3146 VDD! 788 558 VDD! pfet_01v8 L=1.5e-07 W=1.13e-06 $X=7760 $Y=114200 $dt=16
M3147 VDD! 789 560 VDD! pfet_01v8 L=1.5e-07 W=1.13e-06 $X=7760 $Y=122480 $dt=16
M3148 VDD! 790 562 VDD! pfet_01v8 L=1.5e-07 W=1.13e-06 $X=7760 $Y=130760 $dt=16
M3149 VDD! 791 564 VDD! pfet_01v8 L=1.5e-07 W=1.13e-06 $X=7760 $Y=139040 $dt=16
M3150 VDD! 792 566 VDD! pfet_01v8 L=1.5e-07 W=1.13e-06 $X=7760 $Y=147320 $dt=16
M3151 VDD! 793 568 VDD! pfet_01v8 L=1.5e-07 W=1.13e-06 $X=7760 $Y=155600 $dt=16
M3152 VDD! 794 570 VDD! pfet_01v8 L=1.5e-07 W=1.13e-06 $X=7760 $Y=163880 $dt=16
M3153 VDD! 720 457 VDD! pfet_01v8 L=1.5e-07 W=1.13e-06 $X=7790 $Y=8870 $dt=16
M3154 VDD! 722 459 VDD! pfet_01v8 L=1.5e-07 W=1.13e-06 $X=7790 $Y=17150 $dt=16
M3155 VDD! 724 461 VDD! pfet_01v8 L=1.5e-07 W=1.13e-06 $X=7790 $Y=25430 $dt=16
M3156 VDD! 726 463 VDD! pfet_01v8 L=1.5e-07 W=1.13e-06 $X=7790 $Y=33710 $dt=16
M3157 VDD! 728 465 VDD! pfet_01v8 L=1.5e-07 W=1.13e-06 $X=7790 $Y=41990 $dt=16
M3158 VDD! 730 467 VDD! pfet_01v8 L=1.5e-07 W=1.13e-06 $X=7790 $Y=50270 $dt=16
M3159 VDD! 732 469 VDD! pfet_01v8 L=1.5e-07 W=1.13e-06 $X=7790 $Y=58550 $dt=16
M3160 VDD! 734 471 VDD! pfet_01v8 L=1.5e-07 W=1.13e-06 $X=7790 $Y=66830 $dt=16
M3161 VDD! 736 473 VDD! pfet_01v8 L=1.5e-07 W=1.13e-06 $X=7790 $Y=75110 $dt=16
M3162 VDD! 738 475 VDD! pfet_01v8 L=1.5e-07 W=1.13e-06 $X=7790 $Y=83390 $dt=16
M3163 VDD! 740 477 VDD! pfet_01v8 L=1.5e-07 W=1.13e-06 $X=7790 $Y=91670 $dt=16
M3164 VDD! 742 479 VDD! pfet_01v8 L=1.5e-07 W=1.13e-06 $X=7790 $Y=99950 $dt=16
M3165 VDD! 744 481 VDD! pfet_01v8 L=1.5e-07 W=1.13e-06 $X=7790 $Y=108230 $dt=16
M3166 VDD! 746 483 VDD! pfet_01v8 L=1.5e-07 W=1.13e-06 $X=7790 $Y=116510 $dt=16
M3167 VDD! 748 485 VDD! pfet_01v8 L=1.5e-07 W=1.13e-06 $X=7790 $Y=124790 $dt=16
M3168 VDD! 750 487 VDD! pfet_01v8 L=1.5e-07 W=1.13e-06 $X=7790 $Y=133070 $dt=16
M3169 VDD! 752 489 VDD! pfet_01v8 L=1.5e-07 W=1.13e-06 $X=7790 $Y=141350 $dt=16
M3170 VDD! 754 491 VDD! pfet_01v8 L=1.5e-07 W=1.13e-06 $X=7790 $Y=149630 $dt=16
M3171 VDD! 756 493 VDD! pfet_01v8 L=1.5e-07 W=1.13e-06 $X=7790 $Y=157910 $dt=16
M3172 533 719 VDD! VDD! pfet_01v8 L=1.5e-07 W=1.13e-06 $X=8800 $Y=8870 $dt=16
M3173 VDD! 720 757 VDD! pfet_01v8 L=1.5e-07 W=1.13e-06 $X=8800 $Y=14840 $dt=16
M3174 535 721 VDD! VDD! pfet_01v8 L=1.5e-07 W=1.13e-06 $X=8800 $Y=17150 $dt=16
M3175 VDD! 722 758 VDD! pfet_01v8 L=1.5e-07 W=1.13e-06 $X=8800 $Y=23120 $dt=16
M3176 537 723 VDD! VDD! pfet_01v8 L=1.5e-07 W=1.13e-06 $X=8800 $Y=25430 $dt=16
M3177 VDD! 724 759 VDD! pfet_01v8 L=1.5e-07 W=1.13e-06 $X=8800 $Y=31400 $dt=16
M3178 539 725 VDD! VDD! pfet_01v8 L=1.5e-07 W=1.13e-06 $X=8800 $Y=33710 $dt=16
M3179 VDD! 726 760 VDD! pfet_01v8 L=1.5e-07 W=1.13e-06 $X=8800 $Y=39680 $dt=16
M3180 541 727 VDD! VDD! pfet_01v8 L=1.5e-07 W=1.13e-06 $X=8800 $Y=41990 $dt=16
M3181 VDD! 728 761 VDD! pfet_01v8 L=1.5e-07 W=1.13e-06 $X=8800 $Y=47960 $dt=16
M3182 543 729 VDD! VDD! pfet_01v8 L=1.5e-07 W=1.13e-06 $X=8800 $Y=50270 $dt=16
M3183 VDD! 730 762 VDD! pfet_01v8 L=1.5e-07 W=1.13e-06 $X=8800 $Y=56240 $dt=16
M3184 545 731 VDD! VDD! pfet_01v8 L=1.5e-07 W=1.13e-06 $X=8800 $Y=58550 $dt=16
M3185 VDD! 732 763 VDD! pfet_01v8 L=1.5e-07 W=1.13e-06 $X=8800 $Y=64520 $dt=16
M3186 547 733 VDD! VDD! pfet_01v8 L=1.5e-07 W=1.13e-06 $X=8800 $Y=66830 $dt=16
M3187 VDD! 734 764 VDD! pfet_01v8 L=1.5e-07 W=1.13e-06 $X=8800 $Y=72800 $dt=16
M3188 549 735 VDD! VDD! pfet_01v8 L=1.5e-07 W=1.13e-06 $X=8800 $Y=75110 $dt=16
M3189 VDD! 736 765 VDD! pfet_01v8 L=1.5e-07 W=1.13e-06 $X=8800 $Y=81080 $dt=16
M3190 551 737 VDD! VDD! pfet_01v8 L=1.5e-07 W=1.13e-06 $X=8800 $Y=83390 $dt=16
M3191 VDD! 738 766 VDD! pfet_01v8 L=1.5e-07 W=1.13e-06 $X=8800 $Y=89360 $dt=16
M3192 553 739 VDD! VDD! pfet_01v8 L=1.5e-07 W=1.13e-06 $X=8800 $Y=91670 $dt=16
M3193 VDD! 740 767 VDD! pfet_01v8 L=1.5e-07 W=1.13e-06 $X=8800 $Y=97640 $dt=16
M3194 555 741 VDD! VDD! pfet_01v8 L=1.5e-07 W=1.13e-06 $X=8800 $Y=99950 $dt=16
M3195 VDD! 742 768 VDD! pfet_01v8 L=1.5e-07 W=1.13e-06 $X=8800 $Y=105920 $dt=16
M3196 557 743 VDD! VDD! pfet_01v8 L=1.5e-07 W=1.13e-06 $X=8800 $Y=108230 $dt=16
M3197 VDD! 744 769 VDD! pfet_01v8 L=1.5e-07 W=1.13e-06 $X=8800 $Y=114200 $dt=16
M3198 559 745 VDD! VDD! pfet_01v8 L=1.5e-07 W=1.13e-06 $X=8800 $Y=116510 $dt=16
M3199 VDD! 746 770 VDD! pfet_01v8 L=1.5e-07 W=1.13e-06 $X=8800 $Y=122480 $dt=16
M3200 561 747 VDD! VDD! pfet_01v8 L=1.5e-07 W=1.13e-06 $X=8800 $Y=124790 $dt=16
M3201 VDD! 748 771 VDD! pfet_01v8 L=1.5e-07 W=1.13e-06 $X=8800 $Y=130760 $dt=16
M3202 563 749 VDD! VDD! pfet_01v8 L=1.5e-07 W=1.13e-06 $X=8800 $Y=133070 $dt=16
M3203 VDD! 750 772 VDD! pfet_01v8 L=1.5e-07 W=1.13e-06 $X=8800 $Y=139040 $dt=16
M3204 565 751 VDD! VDD! pfet_01v8 L=1.5e-07 W=1.13e-06 $X=8800 $Y=141350 $dt=16
M3205 VDD! 752 773 VDD! pfet_01v8 L=1.5e-07 W=1.13e-06 $X=8800 $Y=147320 $dt=16
M3206 567 753 VDD! VDD! pfet_01v8 L=1.5e-07 W=1.13e-06 $X=8800 $Y=149630 $dt=16
M3207 VDD! 754 774 VDD! pfet_01v8 L=1.5e-07 W=1.13e-06 $X=8800 $Y=155600 $dt=16
M3208 569 755 VDD! VDD! pfet_01v8 L=1.5e-07 W=1.13e-06 $X=8800 $Y=157910 $dt=16
M3209 VDD! 756 775 VDD! pfet_01v8 L=1.5e-07 W=1.13e-06 $X=8800 $Y=163880 $dt=16
M3210 VDD! 719 533 VDD! pfet_01v8 L=1.5e-07 W=1.13e-06 $X=9230 $Y=8870 $dt=16
M3211 458 757 VDD! VDD! pfet_01v8 L=1.5e-07 W=1.13e-06 $X=9230 $Y=14840 $dt=16
M3212 VDD! 721 535 VDD! pfet_01v8 L=1.5e-07 W=1.13e-06 $X=9230 $Y=17150 $dt=16
M3213 460 758 VDD! VDD! pfet_01v8 L=1.5e-07 W=1.13e-06 $X=9230 $Y=23120 $dt=16
M3214 VDD! 723 537 VDD! pfet_01v8 L=1.5e-07 W=1.13e-06 $X=9230 $Y=25430 $dt=16
M3215 462 759 VDD! VDD! pfet_01v8 L=1.5e-07 W=1.13e-06 $X=9230 $Y=31400 $dt=16
M3216 VDD! 725 539 VDD! pfet_01v8 L=1.5e-07 W=1.13e-06 $X=9230 $Y=33710 $dt=16
M3217 464 760 VDD! VDD! pfet_01v8 L=1.5e-07 W=1.13e-06 $X=9230 $Y=39680 $dt=16
M3218 VDD! 727 541 VDD! pfet_01v8 L=1.5e-07 W=1.13e-06 $X=9230 $Y=41990 $dt=16
M3219 466 761 VDD! VDD! pfet_01v8 L=1.5e-07 W=1.13e-06 $X=9230 $Y=47960 $dt=16
M3220 VDD! 729 543 VDD! pfet_01v8 L=1.5e-07 W=1.13e-06 $X=9230 $Y=50270 $dt=16
M3221 468 762 VDD! VDD! pfet_01v8 L=1.5e-07 W=1.13e-06 $X=9230 $Y=56240 $dt=16
M3222 VDD! 731 545 VDD! pfet_01v8 L=1.5e-07 W=1.13e-06 $X=9230 $Y=58550 $dt=16
M3223 470 763 VDD! VDD! pfet_01v8 L=1.5e-07 W=1.13e-06 $X=9230 $Y=64520 $dt=16
M3224 VDD! 733 547 VDD! pfet_01v8 L=1.5e-07 W=1.13e-06 $X=9230 $Y=66830 $dt=16
M3225 472 764 VDD! VDD! pfet_01v8 L=1.5e-07 W=1.13e-06 $X=9230 $Y=72800 $dt=16
M3226 VDD! 735 549 VDD! pfet_01v8 L=1.5e-07 W=1.13e-06 $X=9230 $Y=75110 $dt=16
M3227 474 765 VDD! VDD! pfet_01v8 L=1.5e-07 W=1.13e-06 $X=9230 $Y=81080 $dt=16
M3228 VDD! 737 551 VDD! pfet_01v8 L=1.5e-07 W=1.13e-06 $X=9230 $Y=83390 $dt=16
M3229 476 766 VDD! VDD! pfet_01v8 L=1.5e-07 W=1.13e-06 $X=9230 $Y=89360 $dt=16
M3230 VDD! 739 553 VDD! pfet_01v8 L=1.5e-07 W=1.13e-06 $X=9230 $Y=91670 $dt=16
M3231 478 767 VDD! VDD! pfet_01v8 L=1.5e-07 W=1.13e-06 $X=9230 $Y=97640 $dt=16
M3232 VDD! 741 555 VDD! pfet_01v8 L=1.5e-07 W=1.13e-06 $X=9230 $Y=99950 $dt=16
M3233 480 768 VDD! VDD! pfet_01v8 L=1.5e-07 W=1.13e-06 $X=9230 $Y=105920 $dt=16
M3234 VDD! 743 557 VDD! pfet_01v8 L=1.5e-07 W=1.13e-06 $X=9230 $Y=108230 $dt=16
M3235 482 769 VDD! VDD! pfet_01v8 L=1.5e-07 W=1.13e-06 $X=9230 $Y=114200 $dt=16
M3236 VDD! 745 559 VDD! pfet_01v8 L=1.5e-07 W=1.13e-06 $X=9230 $Y=116510 $dt=16
M3237 484 770 VDD! VDD! pfet_01v8 L=1.5e-07 W=1.13e-06 $X=9230 $Y=122480 $dt=16
M3238 VDD! 747 561 VDD! pfet_01v8 L=1.5e-07 W=1.13e-06 $X=9230 $Y=124790 $dt=16
M3239 486 771 VDD! VDD! pfet_01v8 L=1.5e-07 W=1.13e-06 $X=9230 $Y=130760 $dt=16
M3240 VDD! 749 563 VDD! pfet_01v8 L=1.5e-07 W=1.13e-06 $X=9230 $Y=133070 $dt=16
M3241 488 772 VDD! VDD! pfet_01v8 L=1.5e-07 W=1.13e-06 $X=9230 $Y=139040 $dt=16
M3242 VDD! 751 565 VDD! pfet_01v8 L=1.5e-07 W=1.13e-06 $X=9230 $Y=141350 $dt=16
M3243 490 773 VDD! VDD! pfet_01v8 L=1.5e-07 W=1.13e-06 $X=9230 $Y=147320 $dt=16
M3244 VDD! 753 567 VDD! pfet_01v8 L=1.5e-07 W=1.13e-06 $X=9230 $Y=149630 $dt=16
M3245 492 774 VDD! VDD! pfet_01v8 L=1.5e-07 W=1.13e-06 $X=9230 $Y=155600 $dt=16
M3246 VDD! 755 569 VDD! pfet_01v8 L=1.5e-07 W=1.13e-06 $X=9230 $Y=157910 $dt=16
M3247 494 775 VDD! VDD! pfet_01v8 L=1.5e-07 W=1.13e-06 $X=9230 $Y=163880 $dt=16
M3248 533 719 VDD! VDD! pfet_01v8 L=1.5e-07 W=1.13e-06 $X=9660 $Y=8870 $dt=16
M3249 VDD! 757 458 VDD! pfet_01v8 L=1.5e-07 W=1.13e-06 $X=9660 $Y=14840 $dt=16
M3250 535 721 VDD! VDD! pfet_01v8 L=1.5e-07 W=1.13e-06 $X=9660 $Y=17150 $dt=16
M3251 VDD! 758 460 VDD! pfet_01v8 L=1.5e-07 W=1.13e-06 $X=9660 $Y=23120 $dt=16
M3252 537 723 VDD! VDD! pfet_01v8 L=1.5e-07 W=1.13e-06 $X=9660 $Y=25430 $dt=16
M3253 VDD! 759 462 VDD! pfet_01v8 L=1.5e-07 W=1.13e-06 $X=9660 $Y=31400 $dt=16
M3254 539 725 VDD! VDD! pfet_01v8 L=1.5e-07 W=1.13e-06 $X=9660 $Y=33710 $dt=16
M3255 VDD! 760 464 VDD! pfet_01v8 L=1.5e-07 W=1.13e-06 $X=9660 $Y=39680 $dt=16
M3256 541 727 VDD! VDD! pfet_01v8 L=1.5e-07 W=1.13e-06 $X=9660 $Y=41990 $dt=16
M3257 VDD! 761 466 VDD! pfet_01v8 L=1.5e-07 W=1.13e-06 $X=9660 $Y=47960 $dt=16
M3258 543 729 VDD! VDD! pfet_01v8 L=1.5e-07 W=1.13e-06 $X=9660 $Y=50270 $dt=16
M3259 VDD! 762 468 VDD! pfet_01v8 L=1.5e-07 W=1.13e-06 $X=9660 $Y=56240 $dt=16
M3260 545 731 VDD! VDD! pfet_01v8 L=1.5e-07 W=1.13e-06 $X=9660 $Y=58550 $dt=16
M3261 VDD! 763 470 VDD! pfet_01v8 L=1.5e-07 W=1.13e-06 $X=9660 $Y=64520 $dt=16
M3262 547 733 VDD! VDD! pfet_01v8 L=1.5e-07 W=1.13e-06 $X=9660 $Y=66830 $dt=16
M3263 VDD! 764 472 VDD! pfet_01v8 L=1.5e-07 W=1.13e-06 $X=9660 $Y=72800 $dt=16
M3264 549 735 VDD! VDD! pfet_01v8 L=1.5e-07 W=1.13e-06 $X=9660 $Y=75110 $dt=16
M3265 VDD! 765 474 VDD! pfet_01v8 L=1.5e-07 W=1.13e-06 $X=9660 $Y=81080 $dt=16
M3266 551 737 VDD! VDD! pfet_01v8 L=1.5e-07 W=1.13e-06 $X=9660 $Y=83390 $dt=16
M3267 VDD! 766 476 VDD! pfet_01v8 L=1.5e-07 W=1.13e-06 $X=9660 $Y=89360 $dt=16
M3268 553 739 VDD! VDD! pfet_01v8 L=1.5e-07 W=1.13e-06 $X=9660 $Y=91670 $dt=16
M3269 VDD! 767 478 VDD! pfet_01v8 L=1.5e-07 W=1.13e-06 $X=9660 $Y=97640 $dt=16
M3270 555 741 VDD! VDD! pfet_01v8 L=1.5e-07 W=1.13e-06 $X=9660 $Y=99950 $dt=16
M3271 VDD! 768 480 VDD! pfet_01v8 L=1.5e-07 W=1.13e-06 $X=9660 $Y=105920 $dt=16
M3272 557 743 VDD! VDD! pfet_01v8 L=1.5e-07 W=1.13e-06 $X=9660 $Y=108230 $dt=16
M3273 VDD! 769 482 VDD! pfet_01v8 L=1.5e-07 W=1.13e-06 $X=9660 $Y=114200 $dt=16
M3274 559 745 VDD! VDD! pfet_01v8 L=1.5e-07 W=1.13e-06 $X=9660 $Y=116510 $dt=16
M3275 VDD! 770 484 VDD! pfet_01v8 L=1.5e-07 W=1.13e-06 $X=9660 $Y=122480 $dt=16
M3276 561 747 VDD! VDD! pfet_01v8 L=1.5e-07 W=1.13e-06 $X=9660 $Y=124790 $dt=16
M3277 VDD! 771 486 VDD! pfet_01v8 L=1.5e-07 W=1.13e-06 $X=9660 $Y=130760 $dt=16
M3278 563 749 VDD! VDD! pfet_01v8 L=1.5e-07 W=1.13e-06 $X=9660 $Y=133070 $dt=16
M3279 VDD! 772 488 VDD! pfet_01v8 L=1.5e-07 W=1.13e-06 $X=9660 $Y=139040 $dt=16
M3280 565 751 VDD! VDD! pfet_01v8 L=1.5e-07 W=1.13e-06 $X=9660 $Y=141350 $dt=16
M3281 VDD! 773 490 VDD! pfet_01v8 L=1.5e-07 W=1.13e-06 $X=9660 $Y=147320 $dt=16
M3282 567 753 VDD! VDD! pfet_01v8 L=1.5e-07 W=1.13e-06 $X=9660 $Y=149630 $dt=16
M3283 VDD! 774 492 VDD! pfet_01v8 L=1.5e-07 W=1.13e-06 $X=9660 $Y=155600 $dt=16
M3284 569 755 VDD! VDD! pfet_01v8 L=1.5e-07 W=1.13e-06 $X=9660 $Y=157910 $dt=16
M3285 VDD! 775 494 VDD! pfet_01v8 L=1.5e-07 W=1.13e-06 $X=9660 $Y=163880 $dt=16
M3286 VDD! 719 533 VDD! pfet_01v8 L=1.5e-07 W=1.13e-06 $X=10090 $Y=8870 $dt=16
M3287 458 757 VDD! VDD! pfet_01v8 L=1.5e-07 W=1.13e-06 $X=10090 $Y=14840 $dt=16
M3288 VDD! 721 535 VDD! pfet_01v8 L=1.5e-07 W=1.13e-06 $X=10090 $Y=17150 $dt=16
M3289 460 758 VDD! VDD! pfet_01v8 L=1.5e-07 W=1.13e-06 $X=10090 $Y=23120 $dt=16
M3290 VDD! 723 537 VDD! pfet_01v8 L=1.5e-07 W=1.13e-06 $X=10090 $Y=25430 $dt=16
M3291 462 759 VDD! VDD! pfet_01v8 L=1.5e-07 W=1.13e-06 $X=10090 $Y=31400 $dt=16
M3292 VDD! 725 539 VDD! pfet_01v8 L=1.5e-07 W=1.13e-06 $X=10090 $Y=33710 $dt=16
M3293 464 760 VDD! VDD! pfet_01v8 L=1.5e-07 W=1.13e-06 $X=10090 $Y=39680 $dt=16
M3294 VDD! 727 541 VDD! pfet_01v8 L=1.5e-07 W=1.13e-06 $X=10090 $Y=41990 $dt=16
M3295 466 761 VDD! VDD! pfet_01v8 L=1.5e-07 W=1.13e-06 $X=10090 $Y=47960 $dt=16
M3296 VDD! 729 543 VDD! pfet_01v8 L=1.5e-07 W=1.13e-06 $X=10090 $Y=50270 $dt=16
M3297 468 762 VDD! VDD! pfet_01v8 L=1.5e-07 W=1.13e-06 $X=10090 $Y=56240 $dt=16
M3298 VDD! 731 545 VDD! pfet_01v8 L=1.5e-07 W=1.13e-06 $X=10090 $Y=58550 $dt=16
M3299 470 763 VDD! VDD! pfet_01v8 L=1.5e-07 W=1.13e-06 $X=10090 $Y=64520 $dt=16
M3300 VDD! 733 547 VDD! pfet_01v8 L=1.5e-07 W=1.13e-06 $X=10090 $Y=66830 $dt=16
M3301 472 764 VDD! VDD! pfet_01v8 L=1.5e-07 W=1.13e-06 $X=10090 $Y=72800 $dt=16
M3302 VDD! 735 549 VDD! pfet_01v8 L=1.5e-07 W=1.13e-06 $X=10090 $Y=75110 $dt=16
M3303 474 765 VDD! VDD! pfet_01v8 L=1.5e-07 W=1.13e-06 $X=10090 $Y=81080 $dt=16
M3304 VDD! 737 551 VDD! pfet_01v8 L=1.5e-07 W=1.13e-06 $X=10090 $Y=83390 $dt=16
M3305 476 766 VDD! VDD! pfet_01v8 L=1.5e-07 W=1.13e-06 $X=10090 $Y=89360 $dt=16
M3306 VDD! 739 553 VDD! pfet_01v8 L=1.5e-07 W=1.13e-06 $X=10090 $Y=91670 $dt=16
M3307 478 767 VDD! VDD! pfet_01v8 L=1.5e-07 W=1.13e-06 $X=10090 $Y=97640 $dt=16
M3308 VDD! 741 555 VDD! pfet_01v8 L=1.5e-07 W=1.13e-06 $X=10090 $Y=99950 $dt=16
M3309 480 768 VDD! VDD! pfet_01v8 L=1.5e-07 W=1.13e-06 $X=10090 $Y=105920 $dt=16
M3310 VDD! 743 557 VDD! pfet_01v8 L=1.5e-07 W=1.13e-06 $X=10090 $Y=108230 $dt=16
M3311 482 769 VDD! VDD! pfet_01v8 L=1.5e-07 W=1.13e-06 $X=10090 $Y=114200 $dt=16
M3312 VDD! 745 559 VDD! pfet_01v8 L=1.5e-07 W=1.13e-06 $X=10090 $Y=116510 $dt=16
M3313 484 770 VDD! VDD! pfet_01v8 L=1.5e-07 W=1.13e-06 $X=10090 $Y=122480 $dt=16
M3314 VDD! 747 561 VDD! pfet_01v8 L=1.5e-07 W=1.13e-06 $X=10090 $Y=124790 $dt=16
M3315 486 771 VDD! VDD! pfet_01v8 L=1.5e-07 W=1.13e-06 $X=10090 $Y=130760 $dt=16
M3316 VDD! 749 563 VDD! pfet_01v8 L=1.5e-07 W=1.13e-06 $X=10090 $Y=133070 $dt=16
M3317 488 772 VDD! VDD! pfet_01v8 L=1.5e-07 W=1.13e-06 $X=10090 $Y=139040 $dt=16
M3318 VDD! 751 565 VDD! pfet_01v8 L=1.5e-07 W=1.13e-06 $X=10090 $Y=141350 $dt=16
M3319 490 773 VDD! VDD! pfet_01v8 L=1.5e-07 W=1.13e-06 $X=10090 $Y=147320 $dt=16
M3320 VDD! 753 567 VDD! pfet_01v8 L=1.5e-07 W=1.13e-06 $X=10090 $Y=149630 $dt=16
M3321 492 774 VDD! VDD! pfet_01v8 L=1.5e-07 W=1.13e-06 $X=10090 $Y=155600 $dt=16
M3322 VDD! 755 569 VDD! pfet_01v8 L=1.5e-07 W=1.13e-06 $X=10090 $Y=157910 $dt=16
M3323 494 775 VDD! VDD! pfet_01v8 L=1.5e-07 W=1.13e-06 $X=10090 $Y=163880 $dt=16
M3324 VDD! 757 458 VDD! pfet_01v8 L=1.5e-07 W=1.13e-06 $X=10520 $Y=14840 $dt=16
M3325 VDD! 758 460 VDD! pfet_01v8 L=1.5e-07 W=1.13e-06 $X=10520 $Y=23120 $dt=16
M3326 VDD! 759 462 VDD! pfet_01v8 L=1.5e-07 W=1.13e-06 $X=10520 $Y=31400 $dt=16
M3327 VDD! 760 464 VDD! pfet_01v8 L=1.5e-07 W=1.13e-06 $X=10520 $Y=39680 $dt=16
M3328 VDD! 761 466 VDD! pfet_01v8 L=1.5e-07 W=1.13e-06 $X=10520 $Y=47960 $dt=16
M3329 VDD! 762 468 VDD! pfet_01v8 L=1.5e-07 W=1.13e-06 $X=10520 $Y=56240 $dt=16
M3330 VDD! 763 470 VDD! pfet_01v8 L=1.5e-07 W=1.13e-06 $X=10520 $Y=64520 $dt=16
M3331 VDD! 764 472 VDD! pfet_01v8 L=1.5e-07 W=1.13e-06 $X=10520 $Y=72800 $dt=16
M3332 VDD! 765 474 VDD! pfet_01v8 L=1.5e-07 W=1.13e-06 $X=10520 $Y=81080 $dt=16
M3333 VDD! 766 476 VDD! pfet_01v8 L=1.5e-07 W=1.13e-06 $X=10520 $Y=89360 $dt=16
M3334 VDD! 767 478 VDD! pfet_01v8 L=1.5e-07 W=1.13e-06 $X=10520 $Y=97640 $dt=16
M3335 VDD! 768 480 VDD! pfet_01v8 L=1.5e-07 W=1.13e-06 $X=10520 $Y=105920 $dt=16
M3336 VDD! 769 482 VDD! pfet_01v8 L=1.5e-07 W=1.13e-06 $X=10520 $Y=114200 $dt=16
M3337 VDD! 770 484 VDD! pfet_01v8 L=1.5e-07 W=1.13e-06 $X=10520 $Y=122480 $dt=16
M3338 VDD! 771 486 VDD! pfet_01v8 L=1.5e-07 W=1.13e-06 $X=10520 $Y=130760 $dt=16
M3339 VDD! 772 488 VDD! pfet_01v8 L=1.5e-07 W=1.13e-06 $X=10520 $Y=139040 $dt=16
M3340 VDD! 773 490 VDD! pfet_01v8 L=1.5e-07 W=1.13e-06 $X=10520 $Y=147320 $dt=16
M3341 VDD! 774 492 VDD! pfet_01v8 L=1.5e-07 W=1.13e-06 $X=10520 $Y=155600 $dt=16
M3342 VDD! 775 494 VDD! pfet_01v8 L=1.5e-07 W=1.13e-06 $X=10520 $Y=163880 $dt=16
M3343 700 681 VDD! VDD! pfet_01v8 L=1.5e-07 W=1.13e-06 $X=11560 $Y=14840 $dt=16
M3344 701 682 VDD! VDD! pfet_01v8 L=1.5e-07 W=1.13e-06 $X=11560 $Y=23120 $dt=16
M3345 702 683 VDD! VDD! pfet_01v8 L=1.5e-07 W=1.13e-06 $X=11560 $Y=31400 $dt=16
M3346 703 684 VDD! VDD! pfet_01v8 L=1.5e-07 W=1.13e-06 $X=11560 $Y=39680 $dt=16
M3347 704 685 VDD! VDD! pfet_01v8 L=1.5e-07 W=1.13e-06 $X=11560 $Y=47960 $dt=16
M3348 705 686 VDD! VDD! pfet_01v8 L=1.5e-07 W=1.13e-06 $X=11560 $Y=56240 $dt=16
M3349 706 687 VDD! VDD! pfet_01v8 L=1.5e-07 W=1.13e-06 $X=11560 $Y=64520 $dt=16
M3350 707 688 VDD! VDD! pfet_01v8 L=1.5e-07 W=1.13e-06 $X=11560 $Y=72800 $dt=16
M3351 708 689 VDD! VDD! pfet_01v8 L=1.5e-07 W=1.13e-06 $X=11560 $Y=81080 $dt=16
M3352 709 690 VDD! VDD! pfet_01v8 L=1.5e-07 W=1.13e-06 $X=11560 $Y=89360 $dt=16
M3353 710 691 VDD! VDD! pfet_01v8 L=1.5e-07 W=1.13e-06 $X=11560 $Y=97640 $dt=16
M3354 711 692 VDD! VDD! pfet_01v8 L=1.5e-07 W=1.13e-06 $X=11560 $Y=105920 $dt=16
M3355 712 693 VDD! VDD! pfet_01v8 L=1.5e-07 W=1.13e-06 $X=11560 $Y=114200 $dt=16
M3356 713 694 VDD! VDD! pfet_01v8 L=1.5e-07 W=1.13e-06 $X=11560 $Y=122480 $dt=16
M3357 714 695 VDD! VDD! pfet_01v8 L=1.5e-07 W=1.13e-06 $X=11560 $Y=130760 $dt=16
M3358 715 696 VDD! VDD! pfet_01v8 L=1.5e-07 W=1.13e-06 $X=11560 $Y=139040 $dt=16
M3359 716 697 VDD! VDD! pfet_01v8 L=1.5e-07 W=1.13e-06 $X=11560 $Y=147320 $dt=16
M3360 717 698 VDD! VDD! pfet_01v8 L=1.5e-07 W=1.13e-06 $X=11560 $Y=155600 $dt=16
M3361 718 699 VDD! VDD! pfet_01v8 L=1.5e-07 W=1.13e-06 $X=11560 $Y=163880 $dt=16
M3362 VDD! 681 700 VDD! pfet_01v8 L=1.5e-07 W=1.13e-06 $X=11990 $Y=14840 $dt=16
M3363 VDD! 682 701 VDD! pfet_01v8 L=1.5e-07 W=1.13e-06 $X=11990 $Y=23120 $dt=16
M3364 VDD! 683 702 VDD! pfet_01v8 L=1.5e-07 W=1.13e-06 $X=11990 $Y=31400 $dt=16
M3365 VDD! 684 703 VDD! pfet_01v8 L=1.5e-07 W=1.13e-06 $X=11990 $Y=39680 $dt=16
M3366 VDD! 685 704 VDD! pfet_01v8 L=1.5e-07 W=1.13e-06 $X=11990 $Y=47960 $dt=16
M3367 VDD! 686 705 VDD! pfet_01v8 L=1.5e-07 W=1.13e-06 $X=11990 $Y=56240 $dt=16
M3368 VDD! 687 706 VDD! pfet_01v8 L=1.5e-07 W=1.13e-06 $X=11990 $Y=64520 $dt=16
M3369 VDD! 688 707 VDD! pfet_01v8 L=1.5e-07 W=1.13e-06 $X=11990 $Y=72800 $dt=16
M3370 VDD! 689 708 VDD! pfet_01v8 L=1.5e-07 W=1.13e-06 $X=11990 $Y=81080 $dt=16
M3371 VDD! 690 709 VDD! pfet_01v8 L=1.5e-07 W=1.13e-06 $X=11990 $Y=89360 $dt=16
M3372 VDD! 691 710 VDD! pfet_01v8 L=1.5e-07 W=1.13e-06 $X=11990 $Y=97640 $dt=16
M3373 VDD! 692 711 VDD! pfet_01v8 L=1.5e-07 W=1.13e-06 $X=11990 $Y=105920 $dt=16
M3374 VDD! 693 712 VDD! pfet_01v8 L=1.5e-07 W=1.13e-06 $X=11990 $Y=114200 $dt=16
M3375 VDD! 694 713 VDD! pfet_01v8 L=1.5e-07 W=1.13e-06 $X=11990 $Y=122480 $dt=16
M3376 VDD! 695 714 VDD! pfet_01v8 L=1.5e-07 W=1.13e-06 $X=11990 $Y=130760 $dt=16
M3377 VDD! 696 715 VDD! pfet_01v8 L=1.5e-07 W=1.13e-06 $X=11990 $Y=139040 $dt=16
M3378 VDD! 697 716 VDD! pfet_01v8 L=1.5e-07 W=1.13e-06 $X=11990 $Y=147320 $dt=16
M3379 VDD! 698 717 VDD! pfet_01v8 L=1.5e-07 W=1.13e-06 $X=11990 $Y=155600 $dt=16
M3380 VDD! 699 718 VDD! pfet_01v8 L=1.5e-07 W=1.13e-06 $X=11990 $Y=163880 $dt=16
M3381 495 700 VDD! VDD! pfet_01v8 L=1.5e-07 W=1.13e-06 $X=12420 $Y=14840 $dt=16
M3382 496 701 VDD! VDD! pfet_01v8 L=1.5e-07 W=1.13e-06 $X=12420 $Y=23120 $dt=16
M3383 497 702 VDD! VDD! pfet_01v8 L=1.5e-07 W=1.13e-06 $X=12420 $Y=31400 $dt=16
M3384 498 703 VDD! VDD! pfet_01v8 L=1.5e-07 W=1.13e-06 $X=12420 $Y=39680 $dt=16
M3385 499 704 VDD! VDD! pfet_01v8 L=1.5e-07 W=1.13e-06 $X=12420 $Y=47960 $dt=16
M3386 500 705 VDD! VDD! pfet_01v8 L=1.5e-07 W=1.13e-06 $X=12420 $Y=56240 $dt=16
M3387 501 706 VDD! VDD! pfet_01v8 L=1.5e-07 W=1.13e-06 $X=12420 $Y=64520 $dt=16
M3388 502 707 VDD! VDD! pfet_01v8 L=1.5e-07 W=1.13e-06 $X=12420 $Y=72800 $dt=16
M3389 503 708 VDD! VDD! pfet_01v8 L=1.5e-07 W=1.13e-06 $X=12420 $Y=81080 $dt=16
M3390 504 709 VDD! VDD! pfet_01v8 L=1.5e-07 W=1.13e-06 $X=12420 $Y=89360 $dt=16
M3391 505 710 VDD! VDD! pfet_01v8 L=1.5e-07 W=1.13e-06 $X=12420 $Y=97640 $dt=16
M3392 506 711 VDD! VDD! pfet_01v8 L=1.5e-07 W=1.13e-06 $X=12420 $Y=105920 $dt=16
M3393 507 712 VDD! VDD! pfet_01v8 L=1.5e-07 W=1.13e-06 $X=12420 $Y=114200 $dt=16
M3394 508 713 VDD! VDD! pfet_01v8 L=1.5e-07 W=1.13e-06 $X=12420 $Y=122480 $dt=16
M3395 509 714 VDD! VDD! pfet_01v8 L=1.5e-07 W=1.13e-06 $X=12420 $Y=130760 $dt=16
M3396 510 715 VDD! VDD! pfet_01v8 L=1.5e-07 W=1.13e-06 $X=12420 $Y=139040 $dt=16
M3397 511 716 VDD! VDD! pfet_01v8 L=1.5e-07 W=1.13e-06 $X=12420 $Y=147320 $dt=16
M3398 512 717 VDD! VDD! pfet_01v8 L=1.5e-07 W=1.13e-06 $X=12420 $Y=155600 $dt=16
M3399 513 718 VDD! VDD! pfet_01v8 L=1.5e-07 W=1.13e-06 $X=12420 $Y=163880 $dt=16
M3400 514 681 VDD! VDD! pfet_01v8 L=1.5e-07 W=1.13e-06 $X=12480 $Y=8870 $dt=16
M3401 515 682 VDD! VDD! pfet_01v8 L=1.5e-07 W=1.13e-06 $X=12480 $Y=17150 $dt=16
M3402 516 683 VDD! VDD! pfet_01v8 L=1.5e-07 W=1.13e-06 $X=12480 $Y=25430 $dt=16
M3403 517 684 VDD! VDD! pfet_01v8 L=1.5e-07 W=1.13e-06 $X=12480 $Y=33710 $dt=16
M3404 518 685 VDD! VDD! pfet_01v8 L=1.5e-07 W=1.13e-06 $X=12480 $Y=41990 $dt=16
M3405 519 686 VDD! VDD! pfet_01v8 L=1.5e-07 W=1.13e-06 $X=12480 $Y=50270 $dt=16
M3406 520 687 VDD! VDD! pfet_01v8 L=1.5e-07 W=1.13e-06 $X=12480 $Y=58550 $dt=16
M3407 521 688 VDD! VDD! pfet_01v8 L=1.5e-07 W=1.13e-06 $X=12480 $Y=66830 $dt=16
M3408 522 689 VDD! VDD! pfet_01v8 L=1.5e-07 W=1.13e-06 $X=12480 $Y=75110 $dt=16
M3409 523 690 VDD! VDD! pfet_01v8 L=1.5e-07 W=1.13e-06 $X=12480 $Y=83390 $dt=16
M3410 524 691 VDD! VDD! pfet_01v8 L=1.5e-07 W=1.13e-06 $X=12480 $Y=91670 $dt=16
M3411 525 692 VDD! VDD! pfet_01v8 L=1.5e-07 W=1.13e-06 $X=12480 $Y=99950 $dt=16
M3412 526 693 VDD! VDD! pfet_01v8 L=1.5e-07 W=1.13e-06 $X=12480 $Y=108230 $dt=16
M3413 527 694 VDD! VDD! pfet_01v8 L=1.5e-07 W=1.13e-06 $X=12480 $Y=116510 $dt=16
M3414 528 695 VDD! VDD! pfet_01v8 L=1.5e-07 W=1.13e-06 $X=12480 $Y=124790 $dt=16
M3415 529 696 VDD! VDD! pfet_01v8 L=1.5e-07 W=1.13e-06 $X=12480 $Y=133070 $dt=16
M3416 530 697 VDD! VDD! pfet_01v8 L=1.5e-07 W=1.13e-06 $X=12480 $Y=141350 $dt=16
M3417 531 698 VDD! VDD! pfet_01v8 L=1.5e-07 W=1.13e-06 $X=12480 $Y=149630 $dt=16
M3418 532 699 VDD! VDD! pfet_01v8 L=1.5e-07 W=1.13e-06 $X=12480 $Y=157910 $dt=16
M3419 VDD! 700 495 VDD! pfet_01v8 L=1.5e-07 W=1.13e-06 $X=12850 $Y=14840 $dt=16
M3420 VDD! 701 496 VDD! pfet_01v8 L=1.5e-07 W=1.13e-06 $X=12850 $Y=23120 $dt=16
M3421 VDD! 702 497 VDD! pfet_01v8 L=1.5e-07 W=1.13e-06 $X=12850 $Y=31400 $dt=16
M3422 VDD! 703 498 VDD! pfet_01v8 L=1.5e-07 W=1.13e-06 $X=12850 $Y=39680 $dt=16
M3423 VDD! 704 499 VDD! pfet_01v8 L=1.5e-07 W=1.13e-06 $X=12850 $Y=47960 $dt=16
M3424 VDD! 705 500 VDD! pfet_01v8 L=1.5e-07 W=1.13e-06 $X=12850 $Y=56240 $dt=16
M3425 VDD! 706 501 VDD! pfet_01v8 L=1.5e-07 W=1.13e-06 $X=12850 $Y=64520 $dt=16
M3426 VDD! 707 502 VDD! pfet_01v8 L=1.5e-07 W=1.13e-06 $X=12850 $Y=72800 $dt=16
M3427 VDD! 708 503 VDD! pfet_01v8 L=1.5e-07 W=1.13e-06 $X=12850 $Y=81080 $dt=16
M3428 VDD! 709 504 VDD! pfet_01v8 L=1.5e-07 W=1.13e-06 $X=12850 $Y=89360 $dt=16
M3429 VDD! 710 505 VDD! pfet_01v8 L=1.5e-07 W=1.13e-06 $X=12850 $Y=97640 $dt=16
M3430 VDD! 711 506 VDD! pfet_01v8 L=1.5e-07 W=1.13e-06 $X=12850 $Y=105920 $dt=16
M3431 VDD! 712 507 VDD! pfet_01v8 L=1.5e-07 W=1.13e-06 $X=12850 $Y=114200 $dt=16
M3432 VDD! 713 508 VDD! pfet_01v8 L=1.5e-07 W=1.13e-06 $X=12850 $Y=122480 $dt=16
M3433 VDD! 714 509 VDD! pfet_01v8 L=1.5e-07 W=1.13e-06 $X=12850 $Y=130760 $dt=16
M3434 VDD! 715 510 VDD! pfet_01v8 L=1.5e-07 W=1.13e-06 $X=12850 $Y=139040 $dt=16
M3435 VDD! 716 511 VDD! pfet_01v8 L=1.5e-07 W=1.13e-06 $X=12850 $Y=147320 $dt=16
M3436 VDD! 717 512 VDD! pfet_01v8 L=1.5e-07 W=1.13e-06 $X=12850 $Y=155600 $dt=16
M3437 VDD! 718 513 VDD! pfet_01v8 L=1.5e-07 W=1.13e-06 $X=12850 $Y=163880 $dt=16
M3438 VDD! 681 514 VDD! pfet_01v8 L=1.5e-07 W=1.13e-06 $X=12910 $Y=8870 $dt=16
M3439 VDD! 682 515 VDD! pfet_01v8 L=1.5e-07 W=1.13e-06 $X=12910 $Y=17150 $dt=16
M3440 VDD! 683 516 VDD! pfet_01v8 L=1.5e-07 W=1.13e-06 $X=12910 $Y=25430 $dt=16
M3441 VDD! 684 517 VDD! pfet_01v8 L=1.5e-07 W=1.13e-06 $X=12910 $Y=33710 $dt=16
M3442 VDD! 685 518 VDD! pfet_01v8 L=1.5e-07 W=1.13e-06 $X=12910 $Y=41990 $dt=16
M3443 VDD! 686 519 VDD! pfet_01v8 L=1.5e-07 W=1.13e-06 $X=12910 $Y=50270 $dt=16
M3444 VDD! 687 520 VDD! pfet_01v8 L=1.5e-07 W=1.13e-06 $X=12910 $Y=58550 $dt=16
M3445 VDD! 688 521 VDD! pfet_01v8 L=1.5e-07 W=1.13e-06 $X=12910 $Y=66830 $dt=16
M3446 VDD! 689 522 VDD! pfet_01v8 L=1.5e-07 W=1.13e-06 $X=12910 $Y=75110 $dt=16
M3447 VDD! 690 523 VDD! pfet_01v8 L=1.5e-07 W=1.13e-06 $X=12910 $Y=83390 $dt=16
M3448 VDD! 691 524 VDD! pfet_01v8 L=1.5e-07 W=1.13e-06 $X=12910 $Y=91670 $dt=16
M3449 VDD! 692 525 VDD! pfet_01v8 L=1.5e-07 W=1.13e-06 $X=12910 $Y=99950 $dt=16
M3450 VDD! 693 526 VDD! pfet_01v8 L=1.5e-07 W=1.13e-06 $X=12910 $Y=108230 $dt=16
M3451 VDD! 694 527 VDD! pfet_01v8 L=1.5e-07 W=1.13e-06 $X=12910 $Y=116510 $dt=16
M3452 VDD! 695 528 VDD! pfet_01v8 L=1.5e-07 W=1.13e-06 $X=12910 $Y=124790 $dt=16
M3453 VDD! 696 529 VDD! pfet_01v8 L=1.5e-07 W=1.13e-06 $X=12910 $Y=133070 $dt=16
M3454 VDD! 697 530 VDD! pfet_01v8 L=1.5e-07 W=1.13e-06 $X=12910 $Y=141350 $dt=16
M3455 VDD! 698 531 VDD! pfet_01v8 L=1.5e-07 W=1.13e-06 $X=12910 $Y=149630 $dt=16
M3456 VDD! 699 532 VDD! pfet_01v8 L=1.5e-07 W=1.13e-06 $X=12910 $Y=157910 $dt=16
M3457 495 700 VDD! VDD! pfet_01v8 L=1.5e-07 W=1.13e-06 $X=13280 $Y=14840 $dt=16
M3458 496 701 VDD! VDD! pfet_01v8 L=1.5e-07 W=1.13e-06 $X=13280 $Y=23120 $dt=16
M3459 497 702 VDD! VDD! pfet_01v8 L=1.5e-07 W=1.13e-06 $X=13280 $Y=31400 $dt=16
M3460 498 703 VDD! VDD! pfet_01v8 L=1.5e-07 W=1.13e-06 $X=13280 $Y=39680 $dt=16
M3461 499 704 VDD! VDD! pfet_01v8 L=1.5e-07 W=1.13e-06 $X=13280 $Y=47960 $dt=16
M3462 500 705 VDD! VDD! pfet_01v8 L=1.5e-07 W=1.13e-06 $X=13280 $Y=56240 $dt=16
M3463 501 706 VDD! VDD! pfet_01v8 L=1.5e-07 W=1.13e-06 $X=13280 $Y=64520 $dt=16
M3464 502 707 VDD! VDD! pfet_01v8 L=1.5e-07 W=1.13e-06 $X=13280 $Y=72800 $dt=16
M3465 503 708 VDD! VDD! pfet_01v8 L=1.5e-07 W=1.13e-06 $X=13280 $Y=81080 $dt=16
M3466 504 709 VDD! VDD! pfet_01v8 L=1.5e-07 W=1.13e-06 $X=13280 $Y=89360 $dt=16
M3467 505 710 VDD! VDD! pfet_01v8 L=1.5e-07 W=1.13e-06 $X=13280 $Y=97640 $dt=16
M3468 506 711 VDD! VDD! pfet_01v8 L=1.5e-07 W=1.13e-06 $X=13280 $Y=105920 $dt=16
M3469 507 712 VDD! VDD! pfet_01v8 L=1.5e-07 W=1.13e-06 $X=13280 $Y=114200 $dt=16
M3470 508 713 VDD! VDD! pfet_01v8 L=1.5e-07 W=1.13e-06 $X=13280 $Y=122480 $dt=16
M3471 509 714 VDD! VDD! pfet_01v8 L=1.5e-07 W=1.13e-06 $X=13280 $Y=130760 $dt=16
M3472 510 715 VDD! VDD! pfet_01v8 L=1.5e-07 W=1.13e-06 $X=13280 $Y=139040 $dt=16
M3473 511 716 VDD! VDD! pfet_01v8 L=1.5e-07 W=1.13e-06 $X=13280 $Y=147320 $dt=16
M3474 512 717 VDD! VDD! pfet_01v8 L=1.5e-07 W=1.13e-06 $X=13280 $Y=155600 $dt=16
M3475 513 718 VDD! VDD! pfet_01v8 L=1.5e-07 W=1.13e-06 $X=13280 $Y=163880 $dt=16
M3476 514 681 VDD! VDD! pfet_01v8 L=1.5e-07 W=1.13e-06 $X=13340 $Y=8870 $dt=16
M3477 515 682 VDD! VDD! pfet_01v8 L=1.5e-07 W=1.13e-06 $X=13340 $Y=17150 $dt=16
M3478 516 683 VDD! VDD! pfet_01v8 L=1.5e-07 W=1.13e-06 $X=13340 $Y=25430 $dt=16
M3479 517 684 VDD! VDD! pfet_01v8 L=1.5e-07 W=1.13e-06 $X=13340 $Y=33710 $dt=16
M3480 518 685 VDD! VDD! pfet_01v8 L=1.5e-07 W=1.13e-06 $X=13340 $Y=41990 $dt=16
M3481 519 686 VDD! VDD! pfet_01v8 L=1.5e-07 W=1.13e-06 $X=13340 $Y=50270 $dt=16
M3482 520 687 VDD! VDD! pfet_01v8 L=1.5e-07 W=1.13e-06 $X=13340 $Y=58550 $dt=16
M3483 521 688 VDD! VDD! pfet_01v8 L=1.5e-07 W=1.13e-06 $X=13340 $Y=66830 $dt=16
M3484 522 689 VDD! VDD! pfet_01v8 L=1.5e-07 W=1.13e-06 $X=13340 $Y=75110 $dt=16
M3485 523 690 VDD! VDD! pfet_01v8 L=1.5e-07 W=1.13e-06 $X=13340 $Y=83390 $dt=16
M3486 524 691 VDD! VDD! pfet_01v8 L=1.5e-07 W=1.13e-06 $X=13340 $Y=91670 $dt=16
M3487 525 692 VDD! VDD! pfet_01v8 L=1.5e-07 W=1.13e-06 $X=13340 $Y=99950 $dt=16
M3488 526 693 VDD! VDD! pfet_01v8 L=1.5e-07 W=1.13e-06 $X=13340 $Y=108230 $dt=16
M3489 527 694 VDD! VDD! pfet_01v8 L=1.5e-07 W=1.13e-06 $X=13340 $Y=116510 $dt=16
M3490 528 695 VDD! VDD! pfet_01v8 L=1.5e-07 W=1.13e-06 $X=13340 $Y=124790 $dt=16
M3491 529 696 VDD! VDD! pfet_01v8 L=1.5e-07 W=1.13e-06 $X=13340 $Y=133070 $dt=16
M3492 530 697 VDD! VDD! pfet_01v8 L=1.5e-07 W=1.13e-06 $X=13340 $Y=141350 $dt=16
M3493 531 698 VDD! VDD! pfet_01v8 L=1.5e-07 W=1.13e-06 $X=13340 $Y=149630 $dt=16
M3494 532 699 VDD! VDD! pfet_01v8 L=1.5e-07 W=1.13e-06 $X=13340 $Y=157910 $dt=16
M3495 VDD! 700 495 VDD! pfet_01v8 L=1.5e-07 W=1.13e-06 $X=13710 $Y=14840 $dt=16
M3496 VDD! 701 496 VDD! pfet_01v8 L=1.5e-07 W=1.13e-06 $X=13710 $Y=23120 $dt=16
M3497 VDD! 702 497 VDD! pfet_01v8 L=1.5e-07 W=1.13e-06 $X=13710 $Y=31400 $dt=16
M3498 VDD! 703 498 VDD! pfet_01v8 L=1.5e-07 W=1.13e-06 $X=13710 $Y=39680 $dt=16
M3499 VDD! 704 499 VDD! pfet_01v8 L=1.5e-07 W=1.13e-06 $X=13710 $Y=47960 $dt=16
M3500 VDD! 705 500 VDD! pfet_01v8 L=1.5e-07 W=1.13e-06 $X=13710 $Y=56240 $dt=16
M3501 VDD! 706 501 VDD! pfet_01v8 L=1.5e-07 W=1.13e-06 $X=13710 $Y=64520 $dt=16
M3502 VDD! 707 502 VDD! pfet_01v8 L=1.5e-07 W=1.13e-06 $X=13710 $Y=72800 $dt=16
M3503 VDD! 708 503 VDD! pfet_01v8 L=1.5e-07 W=1.13e-06 $X=13710 $Y=81080 $dt=16
M3504 VDD! 709 504 VDD! pfet_01v8 L=1.5e-07 W=1.13e-06 $X=13710 $Y=89360 $dt=16
M3505 VDD! 710 505 VDD! pfet_01v8 L=1.5e-07 W=1.13e-06 $X=13710 $Y=97640 $dt=16
M3506 VDD! 711 506 VDD! pfet_01v8 L=1.5e-07 W=1.13e-06 $X=13710 $Y=105920 $dt=16
M3507 VDD! 712 507 VDD! pfet_01v8 L=1.5e-07 W=1.13e-06 $X=13710 $Y=114200 $dt=16
M3508 VDD! 713 508 VDD! pfet_01v8 L=1.5e-07 W=1.13e-06 $X=13710 $Y=122480 $dt=16
M3509 VDD! 714 509 VDD! pfet_01v8 L=1.5e-07 W=1.13e-06 $X=13710 $Y=130760 $dt=16
M3510 VDD! 715 510 VDD! pfet_01v8 L=1.5e-07 W=1.13e-06 $X=13710 $Y=139040 $dt=16
M3511 VDD! 716 511 VDD! pfet_01v8 L=1.5e-07 W=1.13e-06 $X=13710 $Y=147320 $dt=16
M3512 VDD! 717 512 VDD! pfet_01v8 L=1.5e-07 W=1.13e-06 $X=13710 $Y=155600 $dt=16
M3513 VDD! 718 513 VDD! pfet_01v8 L=1.5e-07 W=1.13e-06 $X=13710 $Y=163880 $dt=16
M3514 VDD! 681 514 VDD! pfet_01v8 L=1.5e-07 W=1.13e-06 $X=13770 $Y=8870 $dt=16
M3515 VDD! 682 515 VDD! pfet_01v8 L=1.5e-07 W=1.13e-06 $X=13770 $Y=17150 $dt=16
M3516 VDD! 683 516 VDD! pfet_01v8 L=1.5e-07 W=1.13e-06 $X=13770 $Y=25430 $dt=16
M3517 VDD! 684 517 VDD! pfet_01v8 L=1.5e-07 W=1.13e-06 $X=13770 $Y=33710 $dt=16
M3518 VDD! 685 518 VDD! pfet_01v8 L=1.5e-07 W=1.13e-06 $X=13770 $Y=41990 $dt=16
M3519 VDD! 686 519 VDD! pfet_01v8 L=1.5e-07 W=1.13e-06 $X=13770 $Y=50270 $dt=16
M3520 VDD! 687 520 VDD! pfet_01v8 L=1.5e-07 W=1.13e-06 $X=13770 $Y=58550 $dt=16
M3521 VDD! 688 521 VDD! pfet_01v8 L=1.5e-07 W=1.13e-06 $X=13770 $Y=66830 $dt=16
M3522 VDD! 689 522 VDD! pfet_01v8 L=1.5e-07 W=1.13e-06 $X=13770 $Y=75110 $dt=16
M3523 VDD! 690 523 VDD! pfet_01v8 L=1.5e-07 W=1.13e-06 $X=13770 $Y=83390 $dt=16
M3524 VDD! 691 524 VDD! pfet_01v8 L=1.5e-07 W=1.13e-06 $X=13770 $Y=91670 $dt=16
M3525 VDD! 692 525 VDD! pfet_01v8 L=1.5e-07 W=1.13e-06 $X=13770 $Y=99950 $dt=16
M3526 VDD! 693 526 VDD! pfet_01v8 L=1.5e-07 W=1.13e-06 $X=13770 $Y=108230 $dt=16
M3527 VDD! 694 527 VDD! pfet_01v8 L=1.5e-07 W=1.13e-06 $X=13770 $Y=116510 $dt=16
M3528 VDD! 695 528 VDD! pfet_01v8 L=1.5e-07 W=1.13e-06 $X=13770 $Y=124790 $dt=16
M3529 VDD! 696 529 VDD! pfet_01v8 L=1.5e-07 W=1.13e-06 $X=13770 $Y=133070 $dt=16
M3530 VDD! 697 530 VDD! pfet_01v8 L=1.5e-07 W=1.13e-06 $X=13770 $Y=141350 $dt=16
M3531 VDD! 698 531 VDD! pfet_01v8 L=1.5e-07 W=1.13e-06 $X=13770 $Y=149630 $dt=16
M3532 VDD! 699 532 VDD! pfet_01v8 L=1.5e-07 W=1.13e-06 $X=13770 $Y=157910 $dt=16
M3533 495 700 VDD! VDD! pfet_01v8 L=1.5e-07 W=1.13e-06 $X=14140 $Y=14840 $dt=16
M3534 496 701 VDD! VDD! pfet_01v8 L=1.5e-07 W=1.13e-06 $X=14140 $Y=23120 $dt=16
M3535 497 702 VDD! VDD! pfet_01v8 L=1.5e-07 W=1.13e-06 $X=14140 $Y=31400 $dt=16
M3536 498 703 VDD! VDD! pfet_01v8 L=1.5e-07 W=1.13e-06 $X=14140 $Y=39680 $dt=16
M3537 499 704 VDD! VDD! pfet_01v8 L=1.5e-07 W=1.13e-06 $X=14140 $Y=47960 $dt=16
M3538 500 705 VDD! VDD! pfet_01v8 L=1.5e-07 W=1.13e-06 $X=14140 $Y=56240 $dt=16
M3539 501 706 VDD! VDD! pfet_01v8 L=1.5e-07 W=1.13e-06 $X=14140 $Y=64520 $dt=16
M3540 502 707 VDD! VDD! pfet_01v8 L=1.5e-07 W=1.13e-06 $X=14140 $Y=72800 $dt=16
M3541 503 708 VDD! VDD! pfet_01v8 L=1.5e-07 W=1.13e-06 $X=14140 $Y=81080 $dt=16
M3542 504 709 VDD! VDD! pfet_01v8 L=1.5e-07 W=1.13e-06 $X=14140 $Y=89360 $dt=16
M3543 505 710 VDD! VDD! pfet_01v8 L=1.5e-07 W=1.13e-06 $X=14140 $Y=97640 $dt=16
M3544 506 711 VDD! VDD! pfet_01v8 L=1.5e-07 W=1.13e-06 $X=14140 $Y=105920 $dt=16
M3545 507 712 VDD! VDD! pfet_01v8 L=1.5e-07 W=1.13e-06 $X=14140 $Y=114200 $dt=16
M3546 508 713 VDD! VDD! pfet_01v8 L=1.5e-07 W=1.13e-06 $X=14140 $Y=122480 $dt=16
M3547 509 714 VDD! VDD! pfet_01v8 L=1.5e-07 W=1.13e-06 $X=14140 $Y=130760 $dt=16
M3548 510 715 VDD! VDD! pfet_01v8 L=1.5e-07 W=1.13e-06 $X=14140 $Y=139040 $dt=16
M3549 511 716 VDD! VDD! pfet_01v8 L=1.5e-07 W=1.13e-06 $X=14140 $Y=147320 $dt=16
M3550 512 717 VDD! VDD! pfet_01v8 L=1.5e-07 W=1.13e-06 $X=14140 $Y=155600 $dt=16
M3551 513 718 VDD! VDD! pfet_01v8 L=1.5e-07 W=1.13e-06 $X=14140 $Y=163880 $dt=16
M3552 514 681 VDD! VDD! pfet_01v8 L=1.5e-07 W=1.13e-06 $X=14200 $Y=8870 $dt=16
M3553 515 682 VDD! VDD! pfet_01v8 L=1.5e-07 W=1.13e-06 $X=14200 $Y=17150 $dt=16
M3554 516 683 VDD! VDD! pfet_01v8 L=1.5e-07 W=1.13e-06 $X=14200 $Y=25430 $dt=16
M3555 517 684 VDD! VDD! pfet_01v8 L=1.5e-07 W=1.13e-06 $X=14200 $Y=33710 $dt=16
M3556 518 685 VDD! VDD! pfet_01v8 L=1.5e-07 W=1.13e-06 $X=14200 $Y=41990 $dt=16
M3557 519 686 VDD! VDD! pfet_01v8 L=1.5e-07 W=1.13e-06 $X=14200 $Y=50270 $dt=16
M3558 520 687 VDD! VDD! pfet_01v8 L=1.5e-07 W=1.13e-06 $X=14200 $Y=58550 $dt=16
M3559 521 688 VDD! VDD! pfet_01v8 L=1.5e-07 W=1.13e-06 $X=14200 $Y=66830 $dt=16
M3560 522 689 VDD! VDD! pfet_01v8 L=1.5e-07 W=1.13e-06 $X=14200 $Y=75110 $dt=16
M3561 523 690 VDD! VDD! pfet_01v8 L=1.5e-07 W=1.13e-06 $X=14200 $Y=83390 $dt=16
M3562 524 691 VDD! VDD! pfet_01v8 L=1.5e-07 W=1.13e-06 $X=14200 $Y=91670 $dt=16
M3563 525 692 VDD! VDD! pfet_01v8 L=1.5e-07 W=1.13e-06 $X=14200 $Y=99950 $dt=16
M3564 526 693 VDD! VDD! pfet_01v8 L=1.5e-07 W=1.13e-06 $X=14200 $Y=108230 $dt=16
M3565 527 694 VDD! VDD! pfet_01v8 L=1.5e-07 W=1.13e-06 $X=14200 $Y=116510 $dt=16
M3566 528 695 VDD! VDD! pfet_01v8 L=1.5e-07 W=1.13e-06 $X=14200 $Y=124790 $dt=16
M3567 529 696 VDD! VDD! pfet_01v8 L=1.5e-07 W=1.13e-06 $X=14200 $Y=133070 $dt=16
M3568 530 697 VDD! VDD! pfet_01v8 L=1.5e-07 W=1.13e-06 $X=14200 $Y=141350 $dt=16
M3569 531 698 VDD! VDD! pfet_01v8 L=1.5e-07 W=1.13e-06 $X=14200 $Y=149630 $dt=16
M3570 532 699 VDD! VDD! pfet_01v8 L=1.5e-07 W=1.13e-06 $X=14200 $Y=157910 $dt=16
M3571 VDD! 700 495 VDD! pfet_01v8 L=1.5e-07 W=1.13e-06 $X=14570 $Y=14840 $dt=16
M3572 VDD! 701 496 VDD! pfet_01v8 L=1.5e-07 W=1.13e-06 $X=14570 $Y=23120 $dt=16
M3573 VDD! 702 497 VDD! pfet_01v8 L=1.5e-07 W=1.13e-06 $X=14570 $Y=31400 $dt=16
M3574 VDD! 703 498 VDD! pfet_01v8 L=1.5e-07 W=1.13e-06 $X=14570 $Y=39680 $dt=16
M3575 VDD! 704 499 VDD! pfet_01v8 L=1.5e-07 W=1.13e-06 $X=14570 $Y=47960 $dt=16
M3576 VDD! 705 500 VDD! pfet_01v8 L=1.5e-07 W=1.13e-06 $X=14570 $Y=56240 $dt=16
M3577 VDD! 706 501 VDD! pfet_01v8 L=1.5e-07 W=1.13e-06 $X=14570 $Y=64520 $dt=16
M3578 VDD! 707 502 VDD! pfet_01v8 L=1.5e-07 W=1.13e-06 $X=14570 $Y=72800 $dt=16
M3579 VDD! 708 503 VDD! pfet_01v8 L=1.5e-07 W=1.13e-06 $X=14570 $Y=81080 $dt=16
M3580 VDD! 709 504 VDD! pfet_01v8 L=1.5e-07 W=1.13e-06 $X=14570 $Y=89360 $dt=16
M3581 VDD! 710 505 VDD! pfet_01v8 L=1.5e-07 W=1.13e-06 $X=14570 $Y=97640 $dt=16
M3582 VDD! 711 506 VDD! pfet_01v8 L=1.5e-07 W=1.13e-06 $X=14570 $Y=105920 $dt=16
M3583 VDD! 712 507 VDD! pfet_01v8 L=1.5e-07 W=1.13e-06 $X=14570 $Y=114200 $dt=16
M3584 VDD! 713 508 VDD! pfet_01v8 L=1.5e-07 W=1.13e-06 $X=14570 $Y=122480 $dt=16
M3585 VDD! 714 509 VDD! pfet_01v8 L=1.5e-07 W=1.13e-06 $X=14570 $Y=130760 $dt=16
M3586 VDD! 715 510 VDD! pfet_01v8 L=1.5e-07 W=1.13e-06 $X=14570 $Y=139040 $dt=16
M3587 VDD! 716 511 VDD! pfet_01v8 L=1.5e-07 W=1.13e-06 $X=14570 $Y=147320 $dt=16
M3588 VDD! 717 512 VDD! pfet_01v8 L=1.5e-07 W=1.13e-06 $X=14570 $Y=155600 $dt=16
M3589 VDD! 718 513 VDD! pfet_01v8 L=1.5e-07 W=1.13e-06 $X=14570 $Y=163880 $dt=16
M3590 VDD! 681 514 VDD! pfet_01v8 L=1.5e-07 W=1.13e-06 $X=14630 $Y=8870 $dt=16
M3591 VDD! 682 515 VDD! pfet_01v8 L=1.5e-07 W=1.13e-06 $X=14630 $Y=17150 $dt=16
M3592 VDD! 683 516 VDD! pfet_01v8 L=1.5e-07 W=1.13e-06 $X=14630 $Y=25430 $dt=16
M3593 VDD! 684 517 VDD! pfet_01v8 L=1.5e-07 W=1.13e-06 $X=14630 $Y=33710 $dt=16
M3594 VDD! 685 518 VDD! pfet_01v8 L=1.5e-07 W=1.13e-06 $X=14630 $Y=41990 $dt=16
M3595 VDD! 686 519 VDD! pfet_01v8 L=1.5e-07 W=1.13e-06 $X=14630 $Y=50270 $dt=16
M3596 VDD! 687 520 VDD! pfet_01v8 L=1.5e-07 W=1.13e-06 $X=14630 $Y=58550 $dt=16
M3597 VDD! 688 521 VDD! pfet_01v8 L=1.5e-07 W=1.13e-06 $X=14630 $Y=66830 $dt=16
M3598 VDD! 689 522 VDD! pfet_01v8 L=1.5e-07 W=1.13e-06 $X=14630 $Y=75110 $dt=16
M3599 VDD! 690 523 VDD! pfet_01v8 L=1.5e-07 W=1.13e-06 $X=14630 $Y=83390 $dt=16
M3600 VDD! 691 524 VDD! pfet_01v8 L=1.5e-07 W=1.13e-06 $X=14630 $Y=91670 $dt=16
M3601 VDD! 692 525 VDD! pfet_01v8 L=1.5e-07 W=1.13e-06 $X=14630 $Y=99950 $dt=16
M3602 VDD! 693 526 VDD! pfet_01v8 L=1.5e-07 W=1.13e-06 $X=14630 $Y=108230 $dt=16
M3603 VDD! 694 527 VDD! pfet_01v8 L=1.5e-07 W=1.13e-06 $X=14630 $Y=116510 $dt=16
M3604 VDD! 695 528 VDD! pfet_01v8 L=1.5e-07 W=1.13e-06 $X=14630 $Y=124790 $dt=16
M3605 VDD! 696 529 VDD! pfet_01v8 L=1.5e-07 W=1.13e-06 $X=14630 $Y=133070 $dt=16
M3606 VDD! 697 530 VDD! pfet_01v8 L=1.5e-07 W=1.13e-06 $X=14630 $Y=141350 $dt=16
M3607 VDD! 698 531 VDD! pfet_01v8 L=1.5e-07 W=1.13e-06 $X=14630 $Y=149630 $dt=16
M3608 VDD! 699 532 VDD! pfet_01v8 L=1.5e-07 W=1.13e-06 $X=14630 $Y=157910 $dt=16
M3609 495 700 VDD! VDD! pfet_01v8 L=1.5e-07 W=1.13e-06 $X=15000 $Y=14840 $dt=16
M3610 496 701 VDD! VDD! pfet_01v8 L=1.5e-07 W=1.13e-06 $X=15000 $Y=23120 $dt=16
M3611 497 702 VDD! VDD! pfet_01v8 L=1.5e-07 W=1.13e-06 $X=15000 $Y=31400 $dt=16
M3612 498 703 VDD! VDD! pfet_01v8 L=1.5e-07 W=1.13e-06 $X=15000 $Y=39680 $dt=16
M3613 499 704 VDD! VDD! pfet_01v8 L=1.5e-07 W=1.13e-06 $X=15000 $Y=47960 $dt=16
M3614 500 705 VDD! VDD! pfet_01v8 L=1.5e-07 W=1.13e-06 $X=15000 $Y=56240 $dt=16
M3615 501 706 VDD! VDD! pfet_01v8 L=1.5e-07 W=1.13e-06 $X=15000 $Y=64520 $dt=16
M3616 502 707 VDD! VDD! pfet_01v8 L=1.5e-07 W=1.13e-06 $X=15000 $Y=72800 $dt=16
M3617 503 708 VDD! VDD! pfet_01v8 L=1.5e-07 W=1.13e-06 $X=15000 $Y=81080 $dt=16
M3618 504 709 VDD! VDD! pfet_01v8 L=1.5e-07 W=1.13e-06 $X=15000 $Y=89360 $dt=16
M3619 505 710 VDD! VDD! pfet_01v8 L=1.5e-07 W=1.13e-06 $X=15000 $Y=97640 $dt=16
M3620 506 711 VDD! VDD! pfet_01v8 L=1.5e-07 W=1.13e-06 $X=15000 $Y=105920 $dt=16
M3621 507 712 VDD! VDD! pfet_01v8 L=1.5e-07 W=1.13e-06 $X=15000 $Y=114200 $dt=16
M3622 508 713 VDD! VDD! pfet_01v8 L=1.5e-07 W=1.13e-06 $X=15000 $Y=122480 $dt=16
M3623 509 714 VDD! VDD! pfet_01v8 L=1.5e-07 W=1.13e-06 $X=15000 $Y=130760 $dt=16
M3624 510 715 VDD! VDD! pfet_01v8 L=1.5e-07 W=1.13e-06 $X=15000 $Y=139040 $dt=16
M3625 511 716 VDD! VDD! pfet_01v8 L=1.5e-07 W=1.13e-06 $X=15000 $Y=147320 $dt=16
M3626 512 717 VDD! VDD! pfet_01v8 L=1.5e-07 W=1.13e-06 $X=15000 $Y=155600 $dt=16
M3627 513 718 VDD! VDD! pfet_01v8 L=1.5e-07 W=1.13e-06 $X=15000 $Y=163880 $dt=16
M3628 514 681 VDD! VDD! pfet_01v8 L=1.5e-07 W=1.13e-06 $X=15060 $Y=8870 $dt=16
M3629 515 682 VDD! VDD! pfet_01v8 L=1.5e-07 W=1.13e-06 $X=15060 $Y=17150 $dt=16
M3630 516 683 VDD! VDD! pfet_01v8 L=1.5e-07 W=1.13e-06 $X=15060 $Y=25430 $dt=16
M3631 517 684 VDD! VDD! pfet_01v8 L=1.5e-07 W=1.13e-06 $X=15060 $Y=33710 $dt=16
M3632 518 685 VDD! VDD! pfet_01v8 L=1.5e-07 W=1.13e-06 $X=15060 $Y=41990 $dt=16
M3633 519 686 VDD! VDD! pfet_01v8 L=1.5e-07 W=1.13e-06 $X=15060 $Y=50270 $dt=16
M3634 520 687 VDD! VDD! pfet_01v8 L=1.5e-07 W=1.13e-06 $X=15060 $Y=58550 $dt=16
M3635 521 688 VDD! VDD! pfet_01v8 L=1.5e-07 W=1.13e-06 $X=15060 $Y=66830 $dt=16
M3636 522 689 VDD! VDD! pfet_01v8 L=1.5e-07 W=1.13e-06 $X=15060 $Y=75110 $dt=16
M3637 523 690 VDD! VDD! pfet_01v8 L=1.5e-07 W=1.13e-06 $X=15060 $Y=83390 $dt=16
M3638 524 691 VDD! VDD! pfet_01v8 L=1.5e-07 W=1.13e-06 $X=15060 $Y=91670 $dt=16
M3639 525 692 VDD! VDD! pfet_01v8 L=1.5e-07 W=1.13e-06 $X=15060 $Y=99950 $dt=16
M3640 526 693 VDD! VDD! pfet_01v8 L=1.5e-07 W=1.13e-06 $X=15060 $Y=108230 $dt=16
M3641 527 694 VDD! VDD! pfet_01v8 L=1.5e-07 W=1.13e-06 $X=15060 $Y=116510 $dt=16
M3642 528 695 VDD! VDD! pfet_01v8 L=1.5e-07 W=1.13e-06 $X=15060 $Y=124790 $dt=16
M3643 529 696 VDD! VDD! pfet_01v8 L=1.5e-07 W=1.13e-06 $X=15060 $Y=133070 $dt=16
M3644 530 697 VDD! VDD! pfet_01v8 L=1.5e-07 W=1.13e-06 $X=15060 $Y=141350 $dt=16
M3645 531 698 VDD! VDD! pfet_01v8 L=1.5e-07 W=1.13e-06 $X=15060 $Y=149630 $dt=16
M3646 532 699 VDD! VDD! pfet_01v8 L=1.5e-07 W=1.13e-06 $X=15060 $Y=157910 $dt=16
M3647 VDD! 700 495 VDD! pfet_01v8 L=1.5e-07 W=1.13e-06 $X=15430 $Y=14840 $dt=16
M3648 VDD! 701 496 VDD! pfet_01v8 L=1.5e-07 W=1.13e-06 $X=15430 $Y=23120 $dt=16
M3649 VDD! 702 497 VDD! pfet_01v8 L=1.5e-07 W=1.13e-06 $X=15430 $Y=31400 $dt=16
M3650 VDD! 703 498 VDD! pfet_01v8 L=1.5e-07 W=1.13e-06 $X=15430 $Y=39680 $dt=16
M3651 VDD! 704 499 VDD! pfet_01v8 L=1.5e-07 W=1.13e-06 $X=15430 $Y=47960 $dt=16
M3652 VDD! 705 500 VDD! pfet_01v8 L=1.5e-07 W=1.13e-06 $X=15430 $Y=56240 $dt=16
M3653 VDD! 706 501 VDD! pfet_01v8 L=1.5e-07 W=1.13e-06 $X=15430 $Y=64520 $dt=16
M3654 VDD! 707 502 VDD! pfet_01v8 L=1.5e-07 W=1.13e-06 $X=15430 $Y=72800 $dt=16
M3655 VDD! 708 503 VDD! pfet_01v8 L=1.5e-07 W=1.13e-06 $X=15430 $Y=81080 $dt=16
M3656 VDD! 709 504 VDD! pfet_01v8 L=1.5e-07 W=1.13e-06 $X=15430 $Y=89360 $dt=16
M3657 VDD! 710 505 VDD! pfet_01v8 L=1.5e-07 W=1.13e-06 $X=15430 $Y=97640 $dt=16
M3658 VDD! 711 506 VDD! pfet_01v8 L=1.5e-07 W=1.13e-06 $X=15430 $Y=105920 $dt=16
M3659 VDD! 712 507 VDD! pfet_01v8 L=1.5e-07 W=1.13e-06 $X=15430 $Y=114200 $dt=16
M3660 VDD! 713 508 VDD! pfet_01v8 L=1.5e-07 W=1.13e-06 $X=15430 $Y=122480 $dt=16
M3661 VDD! 714 509 VDD! pfet_01v8 L=1.5e-07 W=1.13e-06 $X=15430 $Y=130760 $dt=16
M3662 VDD! 715 510 VDD! pfet_01v8 L=1.5e-07 W=1.13e-06 $X=15430 $Y=139040 $dt=16
M3663 VDD! 716 511 VDD! pfet_01v8 L=1.5e-07 W=1.13e-06 $X=15430 $Y=147320 $dt=16
M3664 VDD! 717 512 VDD! pfet_01v8 L=1.5e-07 W=1.13e-06 $X=15430 $Y=155600 $dt=16
M3665 VDD! 718 513 VDD! pfet_01v8 L=1.5e-07 W=1.13e-06 $X=15430 $Y=163880 $dt=16
M3666 VDD! 681 514 VDD! pfet_01v8 L=1.5e-07 W=1.13e-06 $X=15490 $Y=8870 $dt=16
M3667 VDD! 682 515 VDD! pfet_01v8 L=1.5e-07 W=1.13e-06 $X=15490 $Y=17150 $dt=16
M3668 VDD! 683 516 VDD! pfet_01v8 L=1.5e-07 W=1.13e-06 $X=15490 $Y=25430 $dt=16
M3669 VDD! 684 517 VDD! pfet_01v8 L=1.5e-07 W=1.13e-06 $X=15490 $Y=33710 $dt=16
M3670 VDD! 685 518 VDD! pfet_01v8 L=1.5e-07 W=1.13e-06 $X=15490 $Y=41990 $dt=16
M3671 VDD! 686 519 VDD! pfet_01v8 L=1.5e-07 W=1.13e-06 $X=15490 $Y=50270 $dt=16
M3672 VDD! 687 520 VDD! pfet_01v8 L=1.5e-07 W=1.13e-06 $X=15490 $Y=58550 $dt=16
M3673 VDD! 688 521 VDD! pfet_01v8 L=1.5e-07 W=1.13e-06 $X=15490 $Y=66830 $dt=16
M3674 VDD! 689 522 VDD! pfet_01v8 L=1.5e-07 W=1.13e-06 $X=15490 $Y=75110 $dt=16
M3675 VDD! 690 523 VDD! pfet_01v8 L=1.5e-07 W=1.13e-06 $X=15490 $Y=83390 $dt=16
M3676 VDD! 691 524 VDD! pfet_01v8 L=1.5e-07 W=1.13e-06 $X=15490 $Y=91670 $dt=16
M3677 VDD! 692 525 VDD! pfet_01v8 L=1.5e-07 W=1.13e-06 $X=15490 $Y=99950 $dt=16
M3678 VDD! 693 526 VDD! pfet_01v8 L=1.5e-07 W=1.13e-06 $X=15490 $Y=108230 $dt=16
M3679 VDD! 694 527 VDD! pfet_01v8 L=1.5e-07 W=1.13e-06 $X=15490 $Y=116510 $dt=16
M3680 VDD! 695 528 VDD! pfet_01v8 L=1.5e-07 W=1.13e-06 $X=15490 $Y=124790 $dt=16
M3681 VDD! 696 529 VDD! pfet_01v8 L=1.5e-07 W=1.13e-06 $X=15490 $Y=133070 $dt=16
M3682 VDD! 697 530 VDD! pfet_01v8 L=1.5e-07 W=1.13e-06 $X=15490 $Y=141350 $dt=16
M3683 VDD! 698 531 VDD! pfet_01v8 L=1.5e-07 W=1.13e-06 $X=15490 $Y=149630 $dt=16
M3684 VDD! 699 532 VDD! pfet_01v8 L=1.5e-07 W=1.13e-06 $X=15490 $Y=157910 $dt=16
M3685 667 533 VREF_P VDD! pfet_01v8 L=1.5e-07 W=1.5e-06 $X=17630 $Y=10150 $dt=16
M3686 668 535 VREF_P VDD! pfet_01v8 L=1.5e-07 W=1.5e-06 $X=17630 $Y=18430 $dt=16
M3687 669 537 VREF_P VDD! pfet_01v8 L=1.5e-07 W=1.5e-06 $X=17630 $Y=26710 $dt=16
M3688 670 539 VREF_P VDD! pfet_01v8 L=1.5e-07 W=1.5e-06 $X=17630 $Y=34990 $dt=16
M3689 671 541 VREF_P VDD! pfet_01v8 L=1.5e-07 W=1.5e-06 $X=17630 $Y=43270 $dt=16
M3690 672 543 VREF_P VDD! pfet_01v8 L=1.5e-07 W=1.5e-06 $X=17630 $Y=51550 $dt=16
M3691 673 545 VREF_P VDD! pfet_01v8 L=1.5e-07 W=1.5e-06 $X=17630 $Y=59830 $dt=16
M3692 VDD! VSS! VDD! VDD! pfet_01v8 L=5.8e-07 W=1.5e-06 $X=17630 $Y=68110 $dt=16
M3693 VDD! VSS! VDD! VDD! pfet_01v8 L=5.8e-07 W=1.5e-06 $X=17630 $Y=76390 $dt=16
M3694 VDD! VSS! VDD! VDD! pfet_01v8 L=5.8e-07 W=1.5e-06 $X=17630 $Y=84670 $dt=16
M3695 VDD! VSS! VDD! VDD! pfet_01v8 L=5.8e-07 W=1.5e-06 $X=17630 $Y=92950 $dt=16
M3696 VDD! VSS! VDD! VDD! pfet_01v8 L=5.8e-07 W=1.5e-06 $X=17630 $Y=101230 $dt=16
M3697 674 557 VREF_P VDD! pfet_01v8 L=1.5e-07 W=1.5e-06 $X=17630 $Y=109510 $dt=16
M3698 675 559 VREF_P VDD! pfet_01v8 L=1.5e-07 W=1.5e-06 $X=17630 $Y=117790 $dt=16
M3699 676 561 VREF_P VDD! pfet_01v8 L=1.5e-07 W=1.5e-06 $X=17630 $Y=126070 $dt=16
M3700 677 563 VREF_P VDD! pfet_01v8 L=1.5e-07 W=1.5e-06 $X=17630 $Y=134350 $dt=16
M3701 678 565 VREF_P VDD! pfet_01v8 L=1.5e-07 W=1.5e-06 $X=17630 $Y=142630 $dt=16
M3702 679 567 VREF_P VDD! pfet_01v8 L=1.5e-07 W=1.5e-06 $X=17630 $Y=150910 $dt=16
M3703 680 569 VREF_P VDD! pfet_01v8 L=1.5e-07 W=1.5e-06 $X=17630 $Y=159190 $dt=16
M3704 VIN 514 667 VDD! pfet_01v8 L=1.5e-07 W=1.5e-06 $X=18060 $Y=10150 $dt=16
M3705 VIN 515 668 VDD! pfet_01v8 L=1.5e-07 W=1.5e-06 $X=18060 $Y=18430 $dt=16
M3706 VIN 516 669 VDD! pfet_01v8 L=1.5e-07 W=1.5e-06 $X=18060 $Y=26710 $dt=16
M3707 VIN 517 670 VDD! pfet_01v8 L=1.5e-07 W=1.5e-06 $X=18060 $Y=34990 $dt=16
M3708 VIN 518 671 VDD! pfet_01v8 L=1.5e-07 W=1.5e-06 $X=18060 $Y=43270 $dt=16
M3709 VIN 519 672 VDD! pfet_01v8 L=1.5e-07 W=1.5e-06 $X=18060 $Y=51550 $dt=16
M3710 VIN 520 673 VDD! pfet_01v8 L=1.5e-07 W=1.5e-06 $X=18060 $Y=59830 $dt=16
M3711 VIN 526 674 VDD! pfet_01v8 L=1.5e-07 W=1.5e-06 $X=18060 $Y=109510 $dt=16
M3712 VIN 527 675 VDD! pfet_01v8 L=1.5e-07 W=1.5e-06 $X=18060 $Y=117790 $dt=16
M3713 VIN 528 676 VDD! pfet_01v8 L=1.5e-07 W=1.5e-06 $X=18060 $Y=126070 $dt=16
M3714 VIN 529 677 VDD! pfet_01v8 L=1.5e-07 W=1.5e-06 $X=18060 $Y=134350 $dt=16
M3715 VIN 530 678 VDD! pfet_01v8 L=1.5e-07 W=1.5e-06 $X=18060 $Y=142630 $dt=16
M3716 VIN 531 679 VDD! pfet_01v8 L=1.5e-07 W=1.5e-06 $X=18060 $Y=150910 $dt=16
M3717 VIN 532 680 VDD! pfet_01v8 L=1.5e-07 W=1.5e-06 $X=18060 $Y=159190 $dt=16
M3718 VDD! VSS! VDD! VDD! pfet_01v8 L=5.8e-07 W=1.5e-06 $X=23750 $Y=68110 $dt=16
M3719 VDD! VSS! VDD! VDD! pfet_01v8 L=5.8e-07 W=1.5e-06 $X=23750 $Y=76390 $dt=16
M3720 VDD! VSS! VDD! VDD! pfet_01v8 L=5.8e-07 W=1.5e-06 $X=23750 $Y=84670 $dt=16
M3721 VDD! VSS! VDD! VDD! pfet_01v8 L=5.8e-07 W=1.5e-06 $X=23750 $Y=92950 $dt=16
M3722 VDD! VSS! VDD! VDD! pfet_01v8 L=5.8e-07 W=1.5e-06 $X=23750 $Y=101230 $dt=16
M3723 667 495 667 VDD! pfet_01v8 L=1.5e-07 W=1.5e-06 $X=23760 $Y=10150 $dt=16
M3724 668 496 668 VDD! pfet_01v8 L=1.5e-07 W=1.5e-06 $X=23760 $Y=18430 $dt=16
M3725 669 497 669 VDD! pfet_01v8 L=1.5e-07 W=1.5e-06 $X=23760 $Y=26710 $dt=16
M3726 670 498 670 VDD! pfet_01v8 L=1.5e-07 W=1.5e-06 $X=23760 $Y=34990 $dt=16
M3727 671 499 671 VDD! pfet_01v8 L=1.5e-07 W=1.5e-06 $X=23760 $Y=43270 $dt=16
M3728 672 500 672 VDD! pfet_01v8 L=1.5e-07 W=1.5e-06 $X=23760 $Y=51550 $dt=16
M3729 673 501 673 VDD! pfet_01v8 L=1.5e-07 W=1.5e-06 $X=23760 $Y=59830 $dt=16
M3730 674 507 674 VDD! pfet_01v8 L=1.5e-07 W=1.5e-06 $X=23760 $Y=109510 $dt=16
M3731 675 508 675 VDD! pfet_01v8 L=1.5e-07 W=1.5e-06 $X=23760 $Y=117790 $dt=16
M3732 676 509 676 VDD! pfet_01v8 L=1.5e-07 W=1.5e-06 $X=23760 $Y=126070 $dt=16
M3733 677 510 677 VDD! pfet_01v8 L=1.5e-07 W=1.5e-06 $X=23760 $Y=134350 $dt=16
M3734 678 511 678 VDD! pfet_01v8 L=1.5e-07 W=1.5e-06 $X=23760 $Y=142630 $dt=16
M3735 679 512 679 VDD! pfet_01v8 L=1.5e-07 W=1.5e-06 $X=23760 $Y=150910 $dt=16
M3736 680 513 680 VDD! pfet_01v8 L=1.5e-07 W=1.5e-06 $X=23760 $Y=159190 $dt=16
M3737 VREF_N 457 667 VDD! pfet_01v8 L=1.5e-07 W=1.5e-06 $X=24190 $Y=10150 $dt=16
M3738 VREF_N 459 668 VDD! pfet_01v8 L=1.5e-07 W=1.5e-06 $X=24190 $Y=18430 $dt=16
M3739 VREF_N 461 669 VDD! pfet_01v8 L=1.5e-07 W=1.5e-06 $X=24190 $Y=26710 $dt=16
M3740 VREF_N 463 670 VDD! pfet_01v8 L=1.5e-07 W=1.5e-06 $X=24190 $Y=34990 $dt=16
M3741 VREF_N 465 671 VDD! pfet_01v8 L=1.5e-07 W=1.5e-06 $X=24190 $Y=43270 $dt=16
M3742 VREF_N 467 672 VDD! pfet_01v8 L=1.5e-07 W=1.5e-06 $X=24190 $Y=51550 $dt=16
M3743 VREF_N 469 673 VDD! pfet_01v8 L=1.5e-07 W=1.5e-06 $X=24190 $Y=59830 $dt=16
M3744 VREF_N 481 674 VDD! pfet_01v8 L=1.5e-07 W=1.5e-06 $X=24190 $Y=109510 $dt=16
M3745 VREF_N 483 675 VDD! pfet_01v8 L=1.5e-07 W=1.5e-06 $X=24190 $Y=117790 $dt=16
M3746 VREF_N 485 676 VDD! pfet_01v8 L=1.5e-07 W=1.5e-06 $X=24190 $Y=126070 $dt=16
M3747 VREF_N 487 677 VDD! pfet_01v8 L=1.5e-07 W=1.5e-06 $X=24190 $Y=134350 $dt=16
M3748 VREF_N 489 678 VDD! pfet_01v8 L=1.5e-07 W=1.5e-06 $X=24190 $Y=142630 $dt=16
M3749 VREF_N 491 679 VDD! pfet_01v8 L=1.5e-07 W=1.5e-06 $X=24190 $Y=150910 $dt=16
M3750 VREF_N 493 680 VDD! pfet_01v8 L=1.5e-07 W=1.5e-06 $X=24190 $Y=159190 $dt=16
M3751 653 533 VREF_P VDD! pfet_01v8 L=1.5e-07 W=1.5e-06 $X=25910 $Y=10150 $dt=16
M3752 654 535 VREF_P VDD! pfet_01v8 L=1.5e-07 W=1.5e-06 $X=25910 $Y=18430 $dt=16
M3753 655 537 VREF_P VDD! pfet_01v8 L=1.5e-07 W=1.5e-06 $X=25910 $Y=26710 $dt=16
M3754 656 539 VREF_P VDD! pfet_01v8 L=1.5e-07 W=1.5e-06 $X=25910 $Y=34990 $dt=16
M3755 657 541 VREF_P VDD! pfet_01v8 L=1.5e-07 W=1.5e-06 $X=25910 $Y=43270 $dt=16
M3756 658 543 VREF_P VDD! pfet_01v8 L=1.5e-07 W=1.5e-06 $X=25910 $Y=51550 $dt=16
M3757 659 545 VREF_P VDD! pfet_01v8 L=1.5e-07 W=1.5e-06 $X=25910 $Y=59830 $dt=16
M3758 VDD! VSS! VDD! VDD! pfet_01v8 L=5.8e-07 W=1.5e-06 $X=25910 $Y=68110 $dt=16
M3759 VDD! VSS! VDD! VDD! pfet_01v8 L=5.8e-07 W=1.5e-06 $X=25910 $Y=76390 $dt=16
M3760 VDD! VSS! VDD! VDD! pfet_01v8 L=5.8e-07 W=1.5e-06 $X=25910 $Y=84670 $dt=16
M3761 VDD! VSS! VDD! VDD! pfet_01v8 L=5.8e-07 W=1.5e-06 $X=25910 $Y=92950 $dt=16
M3762 VDD! VSS! VDD! VDD! pfet_01v8 L=5.8e-07 W=1.5e-06 $X=25910 $Y=101230 $dt=16
M3763 660 557 VREF_P VDD! pfet_01v8 L=1.5e-07 W=1.5e-06 $X=25910 $Y=109510 $dt=16
M3764 661 559 VREF_P VDD! pfet_01v8 L=1.5e-07 W=1.5e-06 $X=25910 $Y=117790 $dt=16
M3765 662 561 VREF_P VDD! pfet_01v8 L=1.5e-07 W=1.5e-06 $X=25910 $Y=126070 $dt=16
M3766 663 563 VREF_P VDD! pfet_01v8 L=1.5e-07 W=1.5e-06 $X=25910 $Y=134350 $dt=16
M3767 664 565 VREF_P VDD! pfet_01v8 L=1.5e-07 W=1.5e-06 $X=25910 $Y=142630 $dt=16
M3768 665 567 VREF_P VDD! pfet_01v8 L=1.5e-07 W=1.5e-06 $X=25910 $Y=150910 $dt=16
M3769 666 569 VREF_P VDD! pfet_01v8 L=1.5e-07 W=1.5e-06 $X=25910 $Y=159190 $dt=16
M3770 VIN 514 653 VDD! pfet_01v8 L=1.5e-07 W=1.5e-06 $X=26340 $Y=10150 $dt=16
M3771 VIN 515 654 VDD! pfet_01v8 L=1.5e-07 W=1.5e-06 $X=26340 $Y=18430 $dt=16
M3772 VIN 516 655 VDD! pfet_01v8 L=1.5e-07 W=1.5e-06 $X=26340 $Y=26710 $dt=16
M3773 VIN 517 656 VDD! pfet_01v8 L=1.5e-07 W=1.5e-06 $X=26340 $Y=34990 $dt=16
M3774 VIN 518 657 VDD! pfet_01v8 L=1.5e-07 W=1.5e-06 $X=26340 $Y=43270 $dt=16
M3775 VIN 519 658 VDD! pfet_01v8 L=1.5e-07 W=1.5e-06 $X=26340 $Y=51550 $dt=16
M3776 VIN 520 659 VDD! pfet_01v8 L=1.5e-07 W=1.5e-06 $X=26340 $Y=59830 $dt=16
M3777 VIN 526 660 VDD! pfet_01v8 L=1.5e-07 W=1.5e-06 $X=26340 $Y=109510 $dt=16
M3778 VIN 527 661 VDD! pfet_01v8 L=1.5e-07 W=1.5e-06 $X=26340 $Y=117790 $dt=16
M3779 VIN 528 662 VDD! pfet_01v8 L=1.5e-07 W=1.5e-06 $X=26340 $Y=126070 $dt=16
M3780 VIN 529 663 VDD! pfet_01v8 L=1.5e-07 W=1.5e-06 $X=26340 $Y=134350 $dt=16
M3781 VIN 530 664 VDD! pfet_01v8 L=1.5e-07 W=1.5e-06 $X=26340 $Y=142630 $dt=16
M3782 VIN 531 665 VDD! pfet_01v8 L=1.5e-07 W=1.5e-06 $X=26340 $Y=150910 $dt=16
M3783 VIN 532 666 VDD! pfet_01v8 L=1.5e-07 W=1.5e-06 $X=26340 $Y=159190 $dt=16
M3784 VDD! VSS! VDD! VDD! pfet_01v8 L=5.8e-07 W=1.5e-06 $X=32030 $Y=68110 $dt=16
M3785 VDD! VSS! VDD! VDD! pfet_01v8 L=5.8e-07 W=1.5e-06 $X=32030 $Y=76390 $dt=16
M3786 VDD! VSS! VDD! VDD! pfet_01v8 L=5.8e-07 W=1.5e-06 $X=32030 $Y=84670 $dt=16
M3787 VDD! VSS! VDD! VDD! pfet_01v8 L=5.8e-07 W=1.5e-06 $X=32030 $Y=92950 $dt=16
M3788 VDD! VSS! VDD! VDD! pfet_01v8 L=5.8e-07 W=1.5e-06 $X=32030 $Y=101230 $dt=16
M3789 653 495 653 VDD! pfet_01v8 L=1.5e-07 W=1.5e-06 $X=32040 $Y=10150 $dt=16
M3790 654 496 654 VDD! pfet_01v8 L=1.5e-07 W=1.5e-06 $X=32040 $Y=18430 $dt=16
M3791 655 497 655 VDD! pfet_01v8 L=1.5e-07 W=1.5e-06 $X=32040 $Y=26710 $dt=16
M3792 656 498 656 VDD! pfet_01v8 L=1.5e-07 W=1.5e-06 $X=32040 $Y=34990 $dt=16
M3793 657 499 657 VDD! pfet_01v8 L=1.5e-07 W=1.5e-06 $X=32040 $Y=43270 $dt=16
M3794 658 500 658 VDD! pfet_01v8 L=1.5e-07 W=1.5e-06 $X=32040 $Y=51550 $dt=16
M3795 659 501 659 VDD! pfet_01v8 L=1.5e-07 W=1.5e-06 $X=32040 $Y=59830 $dt=16
M3796 660 507 660 VDD! pfet_01v8 L=1.5e-07 W=1.5e-06 $X=32040 $Y=109510 $dt=16
M3797 661 508 661 VDD! pfet_01v8 L=1.5e-07 W=1.5e-06 $X=32040 $Y=117790 $dt=16
M3798 662 509 662 VDD! pfet_01v8 L=1.5e-07 W=1.5e-06 $X=32040 $Y=126070 $dt=16
M3799 663 510 663 VDD! pfet_01v8 L=1.5e-07 W=1.5e-06 $X=32040 $Y=134350 $dt=16
M3800 664 511 664 VDD! pfet_01v8 L=1.5e-07 W=1.5e-06 $X=32040 $Y=142630 $dt=16
M3801 665 512 665 VDD! pfet_01v8 L=1.5e-07 W=1.5e-06 $X=32040 $Y=150910 $dt=16
M3802 666 513 666 VDD! pfet_01v8 L=1.5e-07 W=1.5e-06 $X=32040 $Y=159190 $dt=16
M3803 VREF_N 457 653 VDD! pfet_01v8 L=1.5e-07 W=1.5e-06 $X=32470 $Y=10150 $dt=16
M3804 VREF_N 459 654 VDD! pfet_01v8 L=1.5e-07 W=1.5e-06 $X=32470 $Y=18430 $dt=16
M3805 VREF_N 461 655 VDD! pfet_01v8 L=1.5e-07 W=1.5e-06 $X=32470 $Y=26710 $dt=16
M3806 VREF_N 463 656 VDD! pfet_01v8 L=1.5e-07 W=1.5e-06 $X=32470 $Y=34990 $dt=16
M3807 VREF_N 465 657 VDD! pfet_01v8 L=1.5e-07 W=1.5e-06 $X=32470 $Y=43270 $dt=16
M3808 VREF_N 467 658 VDD! pfet_01v8 L=1.5e-07 W=1.5e-06 $X=32470 $Y=51550 $dt=16
M3809 VREF_N 469 659 VDD! pfet_01v8 L=1.5e-07 W=1.5e-06 $X=32470 $Y=59830 $dt=16
M3810 VREF_N 481 660 VDD! pfet_01v8 L=1.5e-07 W=1.5e-06 $X=32470 $Y=109510 $dt=16
M3811 VREF_N 483 661 VDD! pfet_01v8 L=1.5e-07 W=1.5e-06 $X=32470 $Y=117790 $dt=16
M3812 VREF_N 485 662 VDD! pfet_01v8 L=1.5e-07 W=1.5e-06 $X=32470 $Y=126070 $dt=16
M3813 VREF_N 487 663 VDD! pfet_01v8 L=1.5e-07 W=1.5e-06 $X=32470 $Y=134350 $dt=16
M3814 VREF_N 489 664 VDD! pfet_01v8 L=1.5e-07 W=1.5e-06 $X=32470 $Y=142630 $dt=16
M3815 VREF_N 491 665 VDD! pfet_01v8 L=1.5e-07 W=1.5e-06 $X=32470 $Y=150910 $dt=16
M3816 VREF_N 493 666 VDD! pfet_01v8 L=1.5e-07 W=1.5e-06 $X=32470 $Y=159190 $dt=16
M3817 639 533 VREF_P VDD! pfet_01v8 L=1.5e-07 W=1.5e-06 $X=34190 $Y=10150 $dt=16
M3818 640 535 VREF_P VDD! pfet_01v8 L=1.5e-07 W=1.5e-06 $X=34190 $Y=18430 $dt=16
M3819 641 537 VREF_P VDD! pfet_01v8 L=1.5e-07 W=1.5e-06 $X=34190 $Y=26710 $dt=16
M3820 642 539 VREF_P VDD! pfet_01v8 L=1.5e-07 W=1.5e-06 $X=34190 $Y=34990 $dt=16
M3821 643 541 VREF_P VDD! pfet_01v8 L=1.5e-07 W=1.5e-06 $X=34190 $Y=43270 $dt=16
M3822 644 543 VREF_P VDD! pfet_01v8 L=1.5e-07 W=1.5e-06 $X=34190 $Y=51550 $dt=16
M3823 645 545 VREF_P VDD! pfet_01v8 L=1.5e-07 W=1.5e-06 $X=34190 $Y=59830 $dt=16
M3824 VDD! VSS! VDD! VDD! pfet_01v8 L=5.8e-07 W=1.5e-06 $X=34190 $Y=68110 $dt=16
M3825 VDD! VSS! VDD! VDD! pfet_01v8 L=5.8e-07 W=1.5e-06 $X=34190 $Y=76390 $dt=16
M3826 VDD! VSS! VDD! VDD! pfet_01v8 L=5.8e-07 W=1.5e-06 $X=34190 $Y=84670 $dt=16
M3827 VDD! VSS! VDD! VDD! pfet_01v8 L=5.8e-07 W=1.5e-06 $X=34190 $Y=92950 $dt=16
M3828 VDD! VSS! VDD! VDD! pfet_01v8 L=5.8e-07 W=1.5e-06 $X=34190 $Y=101230 $dt=16
M3829 646 557 VREF_P VDD! pfet_01v8 L=1.5e-07 W=1.5e-06 $X=34190 $Y=109510 $dt=16
M3830 647 559 VREF_P VDD! pfet_01v8 L=1.5e-07 W=1.5e-06 $X=34190 $Y=117790 $dt=16
M3831 648 561 VREF_P VDD! pfet_01v8 L=1.5e-07 W=1.5e-06 $X=34190 $Y=126070 $dt=16
M3832 649 563 VREF_P VDD! pfet_01v8 L=1.5e-07 W=1.5e-06 $X=34190 $Y=134350 $dt=16
M3833 650 565 VREF_P VDD! pfet_01v8 L=1.5e-07 W=1.5e-06 $X=34190 $Y=142630 $dt=16
M3834 651 567 VREF_P VDD! pfet_01v8 L=1.5e-07 W=1.5e-06 $X=34190 $Y=150910 $dt=16
M3835 652 569 VREF_P VDD! pfet_01v8 L=1.5e-07 W=1.5e-06 $X=34190 $Y=159190 $dt=16
M3836 VIN 514 639 VDD! pfet_01v8 L=1.5e-07 W=1.5e-06 $X=34620 $Y=10150 $dt=16
M3837 VIN 515 640 VDD! pfet_01v8 L=1.5e-07 W=1.5e-06 $X=34620 $Y=18430 $dt=16
M3838 VIN 516 641 VDD! pfet_01v8 L=1.5e-07 W=1.5e-06 $X=34620 $Y=26710 $dt=16
M3839 VIN 517 642 VDD! pfet_01v8 L=1.5e-07 W=1.5e-06 $X=34620 $Y=34990 $dt=16
M3840 VIN 518 643 VDD! pfet_01v8 L=1.5e-07 W=1.5e-06 $X=34620 $Y=43270 $dt=16
M3841 VIN 519 644 VDD! pfet_01v8 L=1.5e-07 W=1.5e-06 $X=34620 $Y=51550 $dt=16
M3842 VIN 520 645 VDD! pfet_01v8 L=1.5e-07 W=1.5e-06 $X=34620 $Y=59830 $dt=16
M3843 VIN 526 646 VDD! pfet_01v8 L=1.5e-07 W=1.5e-06 $X=34620 $Y=109510 $dt=16
M3844 VIN 527 647 VDD! pfet_01v8 L=1.5e-07 W=1.5e-06 $X=34620 $Y=117790 $dt=16
M3845 VIN 528 648 VDD! pfet_01v8 L=1.5e-07 W=1.5e-06 $X=34620 $Y=126070 $dt=16
M3846 VIN 529 649 VDD! pfet_01v8 L=1.5e-07 W=1.5e-06 $X=34620 $Y=134350 $dt=16
M3847 VIN 530 650 VDD! pfet_01v8 L=1.5e-07 W=1.5e-06 $X=34620 $Y=142630 $dt=16
M3848 VIN 531 651 VDD! pfet_01v8 L=1.5e-07 W=1.5e-06 $X=34620 $Y=150910 $dt=16
M3849 VIN 532 652 VDD! pfet_01v8 L=1.5e-07 W=1.5e-06 $X=34620 $Y=159190 $dt=16
M3850 VDD! VSS! VDD! VDD! pfet_01v8 L=5.8e-07 W=1.5e-06 $X=40310 $Y=68110 $dt=16
M3851 VDD! VSS! VDD! VDD! pfet_01v8 L=5.8e-07 W=1.5e-06 $X=40310 $Y=76390 $dt=16
M3852 VDD! VSS! VDD! VDD! pfet_01v8 L=5.8e-07 W=1.5e-06 $X=40310 $Y=84670 $dt=16
M3853 VDD! VSS! VDD! VDD! pfet_01v8 L=5.8e-07 W=1.5e-06 $X=40310 $Y=92950 $dt=16
M3854 VDD! VSS! VDD! VDD! pfet_01v8 L=5.8e-07 W=1.5e-06 $X=40310 $Y=101230 $dt=16
M3855 639 495 639 VDD! pfet_01v8 L=1.5e-07 W=1.5e-06 $X=40320 $Y=10150 $dt=16
M3856 640 496 640 VDD! pfet_01v8 L=1.5e-07 W=1.5e-06 $X=40320 $Y=18430 $dt=16
M3857 641 497 641 VDD! pfet_01v8 L=1.5e-07 W=1.5e-06 $X=40320 $Y=26710 $dt=16
M3858 642 498 642 VDD! pfet_01v8 L=1.5e-07 W=1.5e-06 $X=40320 $Y=34990 $dt=16
M3859 643 499 643 VDD! pfet_01v8 L=1.5e-07 W=1.5e-06 $X=40320 $Y=43270 $dt=16
M3860 644 500 644 VDD! pfet_01v8 L=1.5e-07 W=1.5e-06 $X=40320 $Y=51550 $dt=16
M3861 645 501 645 VDD! pfet_01v8 L=1.5e-07 W=1.5e-06 $X=40320 $Y=59830 $dt=16
M3862 646 507 646 VDD! pfet_01v8 L=1.5e-07 W=1.5e-06 $X=40320 $Y=109510 $dt=16
M3863 647 508 647 VDD! pfet_01v8 L=1.5e-07 W=1.5e-06 $X=40320 $Y=117790 $dt=16
M3864 648 509 648 VDD! pfet_01v8 L=1.5e-07 W=1.5e-06 $X=40320 $Y=126070 $dt=16
M3865 649 510 649 VDD! pfet_01v8 L=1.5e-07 W=1.5e-06 $X=40320 $Y=134350 $dt=16
M3866 650 511 650 VDD! pfet_01v8 L=1.5e-07 W=1.5e-06 $X=40320 $Y=142630 $dt=16
M3867 651 512 651 VDD! pfet_01v8 L=1.5e-07 W=1.5e-06 $X=40320 $Y=150910 $dt=16
M3868 652 513 652 VDD! pfet_01v8 L=1.5e-07 W=1.5e-06 $X=40320 $Y=159190 $dt=16
M3869 VREF_N 457 639 VDD! pfet_01v8 L=1.5e-07 W=1.5e-06 $X=40750 $Y=10150 $dt=16
M3870 VREF_N 459 640 VDD! pfet_01v8 L=1.5e-07 W=1.5e-06 $X=40750 $Y=18430 $dt=16
M3871 VREF_N 461 641 VDD! pfet_01v8 L=1.5e-07 W=1.5e-06 $X=40750 $Y=26710 $dt=16
M3872 VREF_N 463 642 VDD! pfet_01v8 L=1.5e-07 W=1.5e-06 $X=40750 $Y=34990 $dt=16
M3873 VREF_N 465 643 VDD! pfet_01v8 L=1.5e-07 W=1.5e-06 $X=40750 $Y=43270 $dt=16
M3874 VREF_N 467 644 VDD! pfet_01v8 L=1.5e-07 W=1.5e-06 $X=40750 $Y=51550 $dt=16
M3875 VREF_N 469 645 VDD! pfet_01v8 L=1.5e-07 W=1.5e-06 $X=40750 $Y=59830 $dt=16
M3876 VREF_N 481 646 VDD! pfet_01v8 L=1.5e-07 W=1.5e-06 $X=40750 $Y=109510 $dt=16
M3877 VREF_N 483 647 VDD! pfet_01v8 L=1.5e-07 W=1.5e-06 $X=40750 $Y=117790 $dt=16
M3878 VREF_N 485 648 VDD! pfet_01v8 L=1.5e-07 W=1.5e-06 $X=40750 $Y=126070 $dt=16
M3879 VREF_N 487 649 VDD! pfet_01v8 L=1.5e-07 W=1.5e-06 $X=40750 $Y=134350 $dt=16
M3880 VREF_N 489 650 VDD! pfet_01v8 L=1.5e-07 W=1.5e-06 $X=40750 $Y=142630 $dt=16
M3881 VREF_N 491 651 VDD! pfet_01v8 L=1.5e-07 W=1.5e-06 $X=40750 $Y=150910 $dt=16
M3882 VREF_N 493 652 VDD! pfet_01v8 L=1.5e-07 W=1.5e-06 $X=40750 $Y=159190 $dt=16
M3883 625 533 VREF_P VDD! pfet_01v8 L=1.5e-07 W=1.5e-06 $X=42470 $Y=10150 $dt=16
M3884 626 535 VREF_P VDD! pfet_01v8 L=1.5e-07 W=1.5e-06 $X=42470 $Y=18430 $dt=16
M3885 627 537 VREF_P VDD! pfet_01v8 L=1.5e-07 W=1.5e-06 $X=42470 $Y=26710 $dt=16
M3886 628 539 VREF_P VDD! pfet_01v8 L=1.5e-07 W=1.5e-06 $X=42470 $Y=34990 $dt=16
M3887 629 541 VREF_P VDD! pfet_01v8 L=1.5e-07 W=1.5e-06 $X=42470 $Y=43270 $dt=16
M3888 630 543 VREF_P VDD! pfet_01v8 L=1.5e-07 W=1.5e-06 $X=42470 $Y=51550 $dt=16
M3889 631 545 VREF_P VDD! pfet_01v8 L=1.5e-07 W=1.5e-06 $X=42470 $Y=59830 $dt=16
M3890 VDD! VSS! VDD! VDD! pfet_01v8 L=5.8e-07 W=1.5e-06 $X=42470 $Y=68110 $dt=16
M3891 VDD! VSS! VDD! VDD! pfet_01v8 L=5.8e-07 W=1.5e-06 $X=42470 $Y=76390 $dt=16
M3892 VDD! VSS! VDD! VDD! pfet_01v8 L=5.8e-07 W=1.5e-06 $X=42470 $Y=84670 $dt=16
M3893 VDD! VSS! VDD! VDD! pfet_01v8 L=5.8e-07 W=1.5e-06 $X=42470 $Y=92950 $dt=16
M3894 VDD! VSS! VDD! VDD! pfet_01v8 L=5.8e-07 W=1.5e-06 $X=42470 $Y=101230 $dt=16
M3895 632 557 VREF_P VDD! pfet_01v8 L=1.5e-07 W=1.5e-06 $X=42470 $Y=109510 $dt=16
M3896 633 559 VREF_P VDD! pfet_01v8 L=1.5e-07 W=1.5e-06 $X=42470 $Y=117790 $dt=16
M3897 634 561 VREF_P VDD! pfet_01v8 L=1.5e-07 W=1.5e-06 $X=42470 $Y=126070 $dt=16
M3898 635 563 VREF_P VDD! pfet_01v8 L=1.5e-07 W=1.5e-06 $X=42470 $Y=134350 $dt=16
M3899 636 565 VREF_P VDD! pfet_01v8 L=1.5e-07 W=1.5e-06 $X=42470 $Y=142630 $dt=16
M3900 637 567 VREF_P VDD! pfet_01v8 L=1.5e-07 W=1.5e-06 $X=42470 $Y=150910 $dt=16
M3901 638 569 VREF_P VDD! pfet_01v8 L=1.5e-07 W=1.5e-06 $X=42470 $Y=159190 $dt=16
M3902 VIN 514 625 VDD! pfet_01v8 L=1.5e-07 W=1.5e-06 $X=42900 $Y=10150 $dt=16
M3903 VIN 515 626 VDD! pfet_01v8 L=1.5e-07 W=1.5e-06 $X=42900 $Y=18430 $dt=16
M3904 VIN 516 627 VDD! pfet_01v8 L=1.5e-07 W=1.5e-06 $X=42900 $Y=26710 $dt=16
M3905 VIN 517 628 VDD! pfet_01v8 L=1.5e-07 W=1.5e-06 $X=42900 $Y=34990 $dt=16
M3906 VIN 518 629 VDD! pfet_01v8 L=1.5e-07 W=1.5e-06 $X=42900 $Y=43270 $dt=16
M3907 VIN 519 630 VDD! pfet_01v8 L=1.5e-07 W=1.5e-06 $X=42900 $Y=51550 $dt=16
M3908 VIN 520 631 VDD! pfet_01v8 L=1.5e-07 W=1.5e-06 $X=42900 $Y=59830 $dt=16
M3909 VIN 526 632 VDD! pfet_01v8 L=1.5e-07 W=1.5e-06 $X=42900 $Y=109510 $dt=16
M3910 VIN 527 633 VDD! pfet_01v8 L=1.5e-07 W=1.5e-06 $X=42900 $Y=117790 $dt=16
M3911 VIN 528 634 VDD! pfet_01v8 L=1.5e-07 W=1.5e-06 $X=42900 $Y=126070 $dt=16
M3912 VIN 529 635 VDD! pfet_01v8 L=1.5e-07 W=1.5e-06 $X=42900 $Y=134350 $dt=16
M3913 VIN 530 636 VDD! pfet_01v8 L=1.5e-07 W=1.5e-06 $X=42900 $Y=142630 $dt=16
M3914 VIN 531 637 VDD! pfet_01v8 L=1.5e-07 W=1.5e-06 $X=42900 $Y=150910 $dt=16
M3915 VIN 532 638 VDD! pfet_01v8 L=1.5e-07 W=1.5e-06 $X=42900 $Y=159190 $dt=16
M3916 VDD! VSS! VDD! VDD! pfet_01v8 L=5.8e-07 W=1.5e-06 $X=48590 $Y=68110 $dt=16
M3917 VDD! VSS! VDD! VDD! pfet_01v8 L=5.8e-07 W=1.5e-06 $X=48590 $Y=76390 $dt=16
M3918 VDD! VSS! VDD! VDD! pfet_01v8 L=5.8e-07 W=1.5e-06 $X=48590 $Y=84670 $dt=16
M3919 VDD! VSS! VDD! VDD! pfet_01v8 L=5.8e-07 W=1.5e-06 $X=48590 $Y=92950 $dt=16
M3920 VDD! VSS! VDD! VDD! pfet_01v8 L=5.8e-07 W=1.5e-06 $X=48590 $Y=101230 $dt=16
M3921 625 495 625 VDD! pfet_01v8 L=1.5e-07 W=1.5e-06 $X=48600 $Y=10150 $dt=16
M3922 626 496 626 VDD! pfet_01v8 L=1.5e-07 W=1.5e-06 $X=48600 $Y=18430 $dt=16
M3923 627 497 627 VDD! pfet_01v8 L=1.5e-07 W=1.5e-06 $X=48600 $Y=26710 $dt=16
M3924 628 498 628 VDD! pfet_01v8 L=1.5e-07 W=1.5e-06 $X=48600 $Y=34990 $dt=16
M3925 629 499 629 VDD! pfet_01v8 L=1.5e-07 W=1.5e-06 $X=48600 $Y=43270 $dt=16
M3926 630 500 630 VDD! pfet_01v8 L=1.5e-07 W=1.5e-06 $X=48600 $Y=51550 $dt=16
M3927 631 501 631 VDD! pfet_01v8 L=1.5e-07 W=1.5e-06 $X=48600 $Y=59830 $dt=16
M3928 632 507 632 VDD! pfet_01v8 L=1.5e-07 W=1.5e-06 $X=48600 $Y=109510 $dt=16
M3929 633 508 633 VDD! pfet_01v8 L=1.5e-07 W=1.5e-06 $X=48600 $Y=117790 $dt=16
M3930 634 509 634 VDD! pfet_01v8 L=1.5e-07 W=1.5e-06 $X=48600 $Y=126070 $dt=16
M3931 635 510 635 VDD! pfet_01v8 L=1.5e-07 W=1.5e-06 $X=48600 $Y=134350 $dt=16
M3932 636 511 636 VDD! pfet_01v8 L=1.5e-07 W=1.5e-06 $X=48600 $Y=142630 $dt=16
M3933 637 512 637 VDD! pfet_01v8 L=1.5e-07 W=1.5e-06 $X=48600 $Y=150910 $dt=16
M3934 638 513 638 VDD! pfet_01v8 L=1.5e-07 W=1.5e-06 $X=48600 $Y=159190 $dt=16
M3935 VREF_N 457 625 VDD! pfet_01v8 L=1.5e-07 W=1.5e-06 $X=49030 $Y=10150 $dt=16
M3936 VREF_N 459 626 VDD! pfet_01v8 L=1.5e-07 W=1.5e-06 $X=49030 $Y=18430 $dt=16
M3937 VREF_N 461 627 VDD! pfet_01v8 L=1.5e-07 W=1.5e-06 $X=49030 $Y=26710 $dt=16
M3938 VREF_N 463 628 VDD! pfet_01v8 L=1.5e-07 W=1.5e-06 $X=49030 $Y=34990 $dt=16
M3939 VREF_N 465 629 VDD! pfet_01v8 L=1.5e-07 W=1.5e-06 $X=49030 $Y=43270 $dt=16
M3940 VREF_N 467 630 VDD! pfet_01v8 L=1.5e-07 W=1.5e-06 $X=49030 $Y=51550 $dt=16
M3941 VREF_N 469 631 VDD! pfet_01v8 L=1.5e-07 W=1.5e-06 $X=49030 $Y=59830 $dt=16
M3942 VREF_N 481 632 VDD! pfet_01v8 L=1.5e-07 W=1.5e-06 $X=49030 $Y=109510 $dt=16
M3943 VREF_N 483 633 VDD! pfet_01v8 L=1.5e-07 W=1.5e-06 $X=49030 $Y=117790 $dt=16
M3944 VREF_N 485 634 VDD! pfet_01v8 L=1.5e-07 W=1.5e-06 $X=49030 $Y=126070 $dt=16
M3945 VREF_N 487 635 VDD! pfet_01v8 L=1.5e-07 W=1.5e-06 $X=49030 $Y=134350 $dt=16
M3946 VREF_N 489 636 VDD! pfet_01v8 L=1.5e-07 W=1.5e-06 $X=49030 $Y=142630 $dt=16
M3947 VREF_N 491 637 VDD! pfet_01v8 L=1.5e-07 W=1.5e-06 $X=49030 $Y=150910 $dt=16
M3948 VREF_N 493 638 VDD! pfet_01v8 L=1.5e-07 W=1.5e-06 $X=49030 $Y=159190 $dt=16
M3949 607 533 VREF_P VDD! pfet_01v8 L=1.5e-07 W=1.5e-06 $X=50750 $Y=10150 $dt=16
M3950 608 535 VREF_P VDD! pfet_01v8 L=1.5e-07 W=1.5e-06 $X=50750 $Y=18430 $dt=16
M3951 609 537 VREF_P VDD! pfet_01v8 L=1.5e-07 W=1.5e-06 $X=50750 $Y=26710 $dt=16
M3952 610 539 VREF_P VDD! pfet_01v8 L=1.5e-07 W=1.5e-06 $X=50750 $Y=34990 $dt=16
M3953 611 541 VREF_P VDD! pfet_01v8 L=1.5e-07 W=1.5e-06 $X=50750 $Y=43270 $dt=16
M3954 612 543 VREF_P VDD! pfet_01v8 L=1.5e-07 W=1.5e-06 $X=50750 $Y=51550 $dt=16
M3955 613 545 VREF_P VDD! pfet_01v8 L=1.5e-07 W=1.5e-06 $X=50750 $Y=59830 $dt=16
M3956 614 547 VREF_P VDD! pfet_01v8 L=1.5e-07 W=1.5e-06 $X=50750 $Y=68110 $dt=16
M3957 615 549 VREF_P VDD! pfet_01v8 L=1.5e-07 W=1.5e-06 $X=50750 $Y=76390 $dt=16
M3958 VDD! VSS! VDD! VDD! pfet_01v8 L=5.8e-07 W=1.5e-06 $X=50750 $Y=84670 $dt=16
M3959 616 553 VREF_P VDD! pfet_01v8 L=1.5e-07 W=1.5e-06 $X=50750 $Y=92950 $dt=16
M3960 617 555 VREF_P VDD! pfet_01v8 L=1.5e-07 W=1.5e-06 $X=50750 $Y=101230 $dt=16
M3961 618 557 VREF_P VDD! pfet_01v8 L=1.5e-07 W=1.5e-06 $X=50750 $Y=109510 $dt=16
M3962 619 559 VREF_P VDD! pfet_01v8 L=1.5e-07 W=1.5e-06 $X=50750 $Y=117790 $dt=16
M3963 620 561 VREF_P VDD! pfet_01v8 L=1.5e-07 W=1.5e-06 $X=50750 $Y=126070 $dt=16
M3964 621 563 VREF_P VDD! pfet_01v8 L=1.5e-07 W=1.5e-06 $X=50750 $Y=134350 $dt=16
M3965 622 565 VREF_P VDD! pfet_01v8 L=1.5e-07 W=1.5e-06 $X=50750 $Y=142630 $dt=16
M3966 623 567 VREF_P VDD! pfet_01v8 L=1.5e-07 W=1.5e-06 $X=50750 $Y=150910 $dt=16
M3967 624 569 VREF_P VDD! pfet_01v8 L=1.5e-07 W=1.5e-06 $X=50750 $Y=159190 $dt=16
M3968 VIN 514 607 VDD! pfet_01v8 L=1.5e-07 W=1.5e-06 $X=51180 $Y=10150 $dt=16
M3969 VIN 515 608 VDD! pfet_01v8 L=1.5e-07 W=1.5e-06 $X=51180 $Y=18430 $dt=16
M3970 VIN 516 609 VDD! pfet_01v8 L=1.5e-07 W=1.5e-06 $X=51180 $Y=26710 $dt=16
M3971 VIN 517 610 VDD! pfet_01v8 L=1.5e-07 W=1.5e-06 $X=51180 $Y=34990 $dt=16
M3972 VIN 518 611 VDD! pfet_01v8 L=1.5e-07 W=1.5e-06 $X=51180 $Y=43270 $dt=16
M3973 VIN 519 612 VDD! pfet_01v8 L=1.5e-07 W=1.5e-06 $X=51180 $Y=51550 $dt=16
M3974 VIN 520 613 VDD! pfet_01v8 L=1.5e-07 W=1.5e-06 $X=51180 $Y=59830 $dt=16
M3975 VIN 521 614 VDD! pfet_01v8 L=1.5e-07 W=1.5e-06 $X=51180 $Y=68110 $dt=16
M3976 VIN 522 615 VDD! pfet_01v8 L=1.5e-07 W=1.5e-06 $X=51180 $Y=76390 $dt=16
M3977 VIN 524 616 VDD! pfet_01v8 L=1.5e-07 W=1.5e-06 $X=51180 $Y=92950 $dt=16
M3978 VIN 525 617 VDD! pfet_01v8 L=1.5e-07 W=1.5e-06 $X=51180 $Y=101230 $dt=16
M3979 VIN 526 618 VDD! pfet_01v8 L=1.5e-07 W=1.5e-06 $X=51180 $Y=109510 $dt=16
M3980 VIN 527 619 VDD! pfet_01v8 L=1.5e-07 W=1.5e-06 $X=51180 $Y=117790 $dt=16
M3981 VIN 528 620 VDD! pfet_01v8 L=1.5e-07 W=1.5e-06 $X=51180 $Y=126070 $dt=16
M3982 VIN 529 621 VDD! pfet_01v8 L=1.5e-07 W=1.5e-06 $X=51180 $Y=134350 $dt=16
M3983 VIN 530 622 VDD! pfet_01v8 L=1.5e-07 W=1.5e-06 $X=51180 $Y=142630 $dt=16
M3984 VIN 531 623 VDD! pfet_01v8 L=1.5e-07 W=1.5e-06 $X=51180 $Y=150910 $dt=16
M3985 VIN 532 624 VDD! pfet_01v8 L=1.5e-07 W=1.5e-06 $X=51180 $Y=159190 $dt=16
M3986 VDD! VSS! VDD! VDD! pfet_01v8 L=5.8e-07 W=1.5e-06 $X=56870 $Y=84670 $dt=16
M3987 607 495 607 VDD! pfet_01v8 L=1.5e-07 W=1.5e-06 $X=56880 $Y=10150 $dt=16
M3988 608 496 608 VDD! pfet_01v8 L=1.5e-07 W=1.5e-06 $X=56880 $Y=18430 $dt=16
M3989 609 497 609 VDD! pfet_01v8 L=1.5e-07 W=1.5e-06 $X=56880 $Y=26710 $dt=16
M3990 610 498 610 VDD! pfet_01v8 L=1.5e-07 W=1.5e-06 $X=56880 $Y=34990 $dt=16
M3991 611 499 611 VDD! pfet_01v8 L=1.5e-07 W=1.5e-06 $X=56880 $Y=43270 $dt=16
M3992 612 500 612 VDD! pfet_01v8 L=1.5e-07 W=1.5e-06 $X=56880 $Y=51550 $dt=16
M3993 613 501 613 VDD! pfet_01v8 L=1.5e-07 W=1.5e-06 $X=56880 $Y=59830 $dt=16
M3994 614 502 614 VDD! pfet_01v8 L=1.5e-07 W=1.5e-06 $X=56880 $Y=68110 $dt=16
M3995 615 503 615 VDD! pfet_01v8 L=1.5e-07 W=1.5e-06 $X=56880 $Y=76390 $dt=16
M3996 616 505 616 VDD! pfet_01v8 L=1.5e-07 W=1.5e-06 $X=56880 $Y=92950 $dt=16
M3997 617 506 617 VDD! pfet_01v8 L=1.5e-07 W=1.5e-06 $X=56880 $Y=101230 $dt=16
M3998 618 507 618 VDD! pfet_01v8 L=1.5e-07 W=1.5e-06 $X=56880 $Y=109510 $dt=16
M3999 619 508 619 VDD! pfet_01v8 L=1.5e-07 W=1.5e-06 $X=56880 $Y=117790 $dt=16
M4000 620 509 620 VDD! pfet_01v8 L=1.5e-07 W=1.5e-06 $X=56880 $Y=126070 $dt=16
M4001 621 510 621 VDD! pfet_01v8 L=1.5e-07 W=1.5e-06 $X=56880 $Y=134350 $dt=16
M4002 622 511 622 VDD! pfet_01v8 L=1.5e-07 W=1.5e-06 $X=56880 $Y=142630 $dt=16
M4003 623 512 623 VDD! pfet_01v8 L=1.5e-07 W=1.5e-06 $X=56880 $Y=150910 $dt=16
M4004 624 513 624 VDD! pfet_01v8 L=1.5e-07 W=1.5e-06 $X=56880 $Y=159190 $dt=16
M4005 VREF_N 457 607 VDD! pfet_01v8 L=1.5e-07 W=1.5e-06 $X=57310 $Y=10150 $dt=16
M4006 VREF_N 459 608 VDD! pfet_01v8 L=1.5e-07 W=1.5e-06 $X=57310 $Y=18430 $dt=16
M4007 VREF_N 461 609 VDD! pfet_01v8 L=1.5e-07 W=1.5e-06 $X=57310 $Y=26710 $dt=16
M4008 VREF_N 463 610 VDD! pfet_01v8 L=1.5e-07 W=1.5e-06 $X=57310 $Y=34990 $dt=16
M4009 VREF_N 465 611 VDD! pfet_01v8 L=1.5e-07 W=1.5e-06 $X=57310 $Y=43270 $dt=16
M4010 VREF_N 467 612 VDD! pfet_01v8 L=1.5e-07 W=1.5e-06 $X=57310 $Y=51550 $dt=16
M4011 VREF_N 469 613 VDD! pfet_01v8 L=1.5e-07 W=1.5e-06 $X=57310 $Y=59830 $dt=16
M4012 VREF_N 471 614 VDD! pfet_01v8 L=1.5e-07 W=1.5e-06 $X=57310 $Y=68110 $dt=16
M4013 VREF_N 473 615 VDD! pfet_01v8 L=1.5e-07 W=1.5e-06 $X=57310 $Y=76390 $dt=16
M4014 VREF_N 477 616 VDD! pfet_01v8 L=1.5e-07 W=1.5e-06 $X=57310 $Y=92950 $dt=16
M4015 VREF_N 479 617 VDD! pfet_01v8 L=1.5e-07 W=1.5e-06 $X=57310 $Y=101230 $dt=16
M4016 VREF_N 481 618 VDD! pfet_01v8 L=1.5e-07 W=1.5e-06 $X=57310 $Y=109510 $dt=16
M4017 VREF_N 483 619 VDD! pfet_01v8 L=1.5e-07 W=1.5e-06 $X=57310 $Y=117790 $dt=16
M4018 VREF_N 485 620 VDD! pfet_01v8 L=1.5e-07 W=1.5e-06 $X=57310 $Y=126070 $dt=16
M4019 VREF_N 487 621 VDD! pfet_01v8 L=1.5e-07 W=1.5e-06 $X=57310 $Y=134350 $dt=16
M4020 VREF_N 489 622 VDD! pfet_01v8 L=1.5e-07 W=1.5e-06 $X=57310 $Y=142630 $dt=16
M4021 VREF_N 491 623 VDD! pfet_01v8 L=1.5e-07 W=1.5e-06 $X=57310 $Y=150910 $dt=16
M4022 VREF_N 493 624 VDD! pfet_01v8 L=1.5e-07 W=1.5e-06 $X=57310 $Y=159190 $dt=16
M4023 589 533 VREF_P VDD! pfet_01v8 L=1.5e-07 W=1.5e-06 $X=59030 $Y=10150 $dt=16
M4024 590 535 VREF_P VDD! pfet_01v8 L=1.5e-07 W=1.5e-06 $X=59030 $Y=18430 $dt=16
M4025 591 537 VREF_P VDD! pfet_01v8 L=1.5e-07 W=1.5e-06 $X=59030 $Y=26710 $dt=16
M4026 592 539 VREF_P VDD! pfet_01v8 L=1.5e-07 W=1.5e-06 $X=59030 $Y=34990 $dt=16
M4027 593 541 VREF_P VDD! pfet_01v8 L=1.5e-07 W=1.5e-06 $X=59030 $Y=43270 $dt=16
M4028 594 543 VREF_P VDD! pfet_01v8 L=1.5e-07 W=1.5e-06 $X=59030 $Y=51550 $dt=16
M4029 595 545 VREF_P VDD! pfet_01v8 L=1.5e-07 W=1.5e-06 $X=59030 $Y=59830 $dt=16
M4030 596 547 VREF_P VDD! pfet_01v8 L=1.5e-07 W=1.5e-06 $X=59030 $Y=68110 $dt=16
M4031 597 549 VREF_P VDD! pfet_01v8 L=1.5e-07 W=1.5e-06 $X=59030 $Y=76390 $dt=16
M4032 VDD! VSS! VDD! VDD! pfet_01v8 L=5.8e-07 W=1.5e-06 $X=59030 $Y=84670 $dt=16
M4033 598 553 VREF_P VDD! pfet_01v8 L=1.5e-07 W=1.5e-06 $X=59030 $Y=92950 $dt=16
M4034 599 555 VREF_P VDD! pfet_01v8 L=1.5e-07 W=1.5e-06 $X=59030 $Y=101230 $dt=16
M4035 600 557 VREF_P VDD! pfet_01v8 L=1.5e-07 W=1.5e-06 $X=59030 $Y=109510 $dt=16
M4036 601 559 VREF_P VDD! pfet_01v8 L=1.5e-07 W=1.5e-06 $X=59030 $Y=117790 $dt=16
M4037 602 561 VREF_P VDD! pfet_01v8 L=1.5e-07 W=1.5e-06 $X=59030 $Y=126070 $dt=16
M4038 603 563 VREF_P VDD! pfet_01v8 L=1.5e-07 W=1.5e-06 $X=59030 $Y=134350 $dt=16
M4039 604 565 VREF_P VDD! pfet_01v8 L=1.5e-07 W=1.5e-06 $X=59030 $Y=142630 $dt=16
M4040 605 567 VREF_P VDD! pfet_01v8 L=1.5e-07 W=1.5e-06 $X=59030 $Y=150910 $dt=16
M4041 606 569 VREF_P VDD! pfet_01v8 L=1.5e-07 W=1.5e-06 $X=59030 $Y=159190 $dt=16
M4042 VIN 514 589 VDD! pfet_01v8 L=1.5e-07 W=1.5e-06 $X=59460 $Y=10150 $dt=16
M4043 VIN 515 590 VDD! pfet_01v8 L=1.5e-07 W=1.5e-06 $X=59460 $Y=18430 $dt=16
M4044 VIN 516 591 VDD! pfet_01v8 L=1.5e-07 W=1.5e-06 $X=59460 $Y=26710 $dt=16
M4045 VIN 517 592 VDD! pfet_01v8 L=1.5e-07 W=1.5e-06 $X=59460 $Y=34990 $dt=16
M4046 VIN 518 593 VDD! pfet_01v8 L=1.5e-07 W=1.5e-06 $X=59460 $Y=43270 $dt=16
M4047 VIN 519 594 VDD! pfet_01v8 L=1.5e-07 W=1.5e-06 $X=59460 $Y=51550 $dt=16
M4048 VIN 520 595 VDD! pfet_01v8 L=1.5e-07 W=1.5e-06 $X=59460 $Y=59830 $dt=16
M4049 VIN 521 596 VDD! pfet_01v8 L=1.5e-07 W=1.5e-06 $X=59460 $Y=68110 $dt=16
M4050 VIN 522 597 VDD! pfet_01v8 L=1.5e-07 W=1.5e-06 $X=59460 $Y=76390 $dt=16
M4051 VIN 524 598 VDD! pfet_01v8 L=1.5e-07 W=1.5e-06 $X=59460 $Y=92950 $dt=16
M4052 VIN 525 599 VDD! pfet_01v8 L=1.5e-07 W=1.5e-06 $X=59460 $Y=101230 $dt=16
M4053 VIN 526 600 VDD! pfet_01v8 L=1.5e-07 W=1.5e-06 $X=59460 $Y=109510 $dt=16
M4054 VIN 527 601 VDD! pfet_01v8 L=1.5e-07 W=1.5e-06 $X=59460 $Y=117790 $dt=16
M4055 VIN 528 602 VDD! pfet_01v8 L=1.5e-07 W=1.5e-06 $X=59460 $Y=126070 $dt=16
M4056 VIN 529 603 VDD! pfet_01v8 L=1.5e-07 W=1.5e-06 $X=59460 $Y=134350 $dt=16
M4057 VIN 530 604 VDD! pfet_01v8 L=1.5e-07 W=1.5e-06 $X=59460 $Y=142630 $dt=16
M4058 VIN 531 605 VDD! pfet_01v8 L=1.5e-07 W=1.5e-06 $X=59460 $Y=150910 $dt=16
M4059 VIN 532 606 VDD! pfet_01v8 L=1.5e-07 W=1.5e-06 $X=59460 $Y=159190 $dt=16
M4060 VDD! VSS! VDD! VDD! pfet_01v8 L=5.8e-07 W=1.5e-06 $X=65150 $Y=84670 $dt=16
M4061 589 495 589 VDD! pfet_01v8 L=1.5e-07 W=1.5e-06 $X=65160 $Y=10150 $dt=16
M4062 590 496 590 VDD! pfet_01v8 L=1.5e-07 W=1.5e-06 $X=65160 $Y=18430 $dt=16
M4063 591 497 591 VDD! pfet_01v8 L=1.5e-07 W=1.5e-06 $X=65160 $Y=26710 $dt=16
M4064 592 498 592 VDD! pfet_01v8 L=1.5e-07 W=1.5e-06 $X=65160 $Y=34990 $dt=16
M4065 593 499 593 VDD! pfet_01v8 L=1.5e-07 W=1.5e-06 $X=65160 $Y=43270 $dt=16
M4066 594 500 594 VDD! pfet_01v8 L=1.5e-07 W=1.5e-06 $X=65160 $Y=51550 $dt=16
M4067 595 501 595 VDD! pfet_01v8 L=1.5e-07 W=1.5e-06 $X=65160 $Y=59830 $dt=16
M4068 596 502 596 VDD! pfet_01v8 L=1.5e-07 W=1.5e-06 $X=65160 $Y=68110 $dt=16
M4069 597 503 597 VDD! pfet_01v8 L=1.5e-07 W=1.5e-06 $X=65160 $Y=76390 $dt=16
M4070 598 505 598 VDD! pfet_01v8 L=1.5e-07 W=1.5e-06 $X=65160 $Y=92950 $dt=16
M4071 599 506 599 VDD! pfet_01v8 L=1.5e-07 W=1.5e-06 $X=65160 $Y=101230 $dt=16
M4072 600 507 600 VDD! pfet_01v8 L=1.5e-07 W=1.5e-06 $X=65160 $Y=109510 $dt=16
M4073 601 508 601 VDD! pfet_01v8 L=1.5e-07 W=1.5e-06 $X=65160 $Y=117790 $dt=16
M4074 602 509 602 VDD! pfet_01v8 L=1.5e-07 W=1.5e-06 $X=65160 $Y=126070 $dt=16
M4075 603 510 603 VDD! pfet_01v8 L=1.5e-07 W=1.5e-06 $X=65160 $Y=134350 $dt=16
M4076 604 511 604 VDD! pfet_01v8 L=1.5e-07 W=1.5e-06 $X=65160 $Y=142630 $dt=16
M4077 605 512 605 VDD! pfet_01v8 L=1.5e-07 W=1.5e-06 $X=65160 $Y=150910 $dt=16
M4078 606 513 606 VDD! pfet_01v8 L=1.5e-07 W=1.5e-06 $X=65160 $Y=159190 $dt=16
M4079 VREF_N 457 589 VDD! pfet_01v8 L=1.5e-07 W=1.5e-06 $X=65590 $Y=10150 $dt=16
M4080 VREF_N 459 590 VDD! pfet_01v8 L=1.5e-07 W=1.5e-06 $X=65590 $Y=18430 $dt=16
M4081 VREF_N 461 591 VDD! pfet_01v8 L=1.5e-07 W=1.5e-06 $X=65590 $Y=26710 $dt=16
M4082 VREF_N 463 592 VDD! pfet_01v8 L=1.5e-07 W=1.5e-06 $X=65590 $Y=34990 $dt=16
M4083 VREF_N 465 593 VDD! pfet_01v8 L=1.5e-07 W=1.5e-06 $X=65590 $Y=43270 $dt=16
M4084 VREF_N 467 594 VDD! pfet_01v8 L=1.5e-07 W=1.5e-06 $X=65590 $Y=51550 $dt=16
M4085 VREF_N 469 595 VDD! pfet_01v8 L=1.5e-07 W=1.5e-06 $X=65590 $Y=59830 $dt=16
M4086 VREF_N 471 596 VDD! pfet_01v8 L=1.5e-07 W=1.5e-06 $X=65590 $Y=68110 $dt=16
M4087 VREF_N 473 597 VDD! pfet_01v8 L=1.5e-07 W=1.5e-06 $X=65590 $Y=76390 $dt=16
M4088 VREF_N 477 598 VDD! pfet_01v8 L=1.5e-07 W=1.5e-06 $X=65590 $Y=92950 $dt=16
M4089 VREF_N 479 599 VDD! pfet_01v8 L=1.5e-07 W=1.5e-06 $X=65590 $Y=101230 $dt=16
M4090 VREF_N 481 600 VDD! pfet_01v8 L=1.5e-07 W=1.5e-06 $X=65590 $Y=109510 $dt=16
M4091 VREF_N 483 601 VDD! pfet_01v8 L=1.5e-07 W=1.5e-06 $X=65590 $Y=117790 $dt=16
M4092 VREF_N 485 602 VDD! pfet_01v8 L=1.5e-07 W=1.5e-06 $X=65590 $Y=126070 $dt=16
M4093 VREF_N 487 603 VDD! pfet_01v8 L=1.5e-07 W=1.5e-06 $X=65590 $Y=134350 $dt=16
M4094 VREF_N 489 604 VDD! pfet_01v8 L=1.5e-07 W=1.5e-06 $X=65590 $Y=142630 $dt=16
M4095 VREF_N 491 605 VDD! pfet_01v8 L=1.5e-07 W=1.5e-06 $X=65590 $Y=150910 $dt=16
M4096 VREF_N 493 606 VDD! pfet_01v8 L=1.5e-07 W=1.5e-06 $X=65590 $Y=159190 $dt=16
M4097 571 533 VREF_P VDD! pfet_01v8 L=1.5e-07 W=1.5e-06 $X=67310 $Y=10150 $dt=16
M4098 572 535 VREF_P VDD! pfet_01v8 L=1.5e-07 W=1.5e-06 $X=67310 $Y=18430 $dt=16
M4099 573 537 VREF_P VDD! pfet_01v8 L=1.5e-07 W=1.5e-06 $X=67310 $Y=26710 $dt=16
M4100 574 539 VREF_P VDD! pfet_01v8 L=1.5e-07 W=1.5e-06 $X=67310 $Y=34990 $dt=16
M4101 575 541 VREF_P VDD! pfet_01v8 L=1.5e-07 W=1.5e-06 $X=67310 $Y=43270 $dt=16
M4102 576 543 VREF_P VDD! pfet_01v8 L=1.5e-07 W=1.5e-06 $X=67310 $Y=51550 $dt=16
M4103 577 545 VREF_P VDD! pfet_01v8 L=1.5e-07 W=1.5e-06 $X=67310 $Y=59830 $dt=16
M4104 578 547 VREF_P VDD! pfet_01v8 L=1.5e-07 W=1.5e-06 $X=67310 $Y=68110 $dt=16
M4105 579 549 VREF_P VDD! pfet_01v8 L=1.5e-07 W=1.5e-06 $X=67310 $Y=76390 $dt=16
M4106 VDD! VSS! VDD! VDD! pfet_01v8 L=5.8e-07 W=1.5e-06 $X=67310 $Y=84670 $dt=16
M4107 580 553 VREF_P VDD! pfet_01v8 L=1.5e-07 W=1.5e-06 $X=67310 $Y=92950 $dt=16
M4108 581 555 VREF_P VDD! pfet_01v8 L=1.5e-07 W=1.5e-06 $X=67310 $Y=101230 $dt=16
M4109 582 557 VREF_P VDD! pfet_01v8 L=1.5e-07 W=1.5e-06 $X=67310 $Y=109510 $dt=16
M4110 583 559 VREF_P VDD! pfet_01v8 L=1.5e-07 W=1.5e-06 $X=67310 $Y=117790 $dt=16
M4111 584 561 VREF_P VDD! pfet_01v8 L=1.5e-07 W=1.5e-06 $X=67310 $Y=126070 $dt=16
M4112 585 563 VREF_P VDD! pfet_01v8 L=1.5e-07 W=1.5e-06 $X=67310 $Y=134350 $dt=16
M4113 586 565 VREF_P VDD! pfet_01v8 L=1.5e-07 W=1.5e-06 $X=67310 $Y=142630 $dt=16
M4114 587 567 VREF_P VDD! pfet_01v8 L=1.5e-07 W=1.5e-06 $X=67310 $Y=150910 $dt=16
M4115 588 569 VREF_P VDD! pfet_01v8 L=1.5e-07 W=1.5e-06 $X=67310 $Y=159190 $dt=16
M4116 VIN 514 571 VDD! pfet_01v8 L=1.5e-07 W=1.5e-06 $X=67740 $Y=10150 $dt=16
M4117 VIN 515 572 VDD! pfet_01v8 L=1.5e-07 W=1.5e-06 $X=67740 $Y=18430 $dt=16
M4118 VIN 516 573 VDD! pfet_01v8 L=1.5e-07 W=1.5e-06 $X=67740 $Y=26710 $dt=16
M4119 VIN 517 574 VDD! pfet_01v8 L=1.5e-07 W=1.5e-06 $X=67740 $Y=34990 $dt=16
M4120 VIN 518 575 VDD! pfet_01v8 L=1.5e-07 W=1.5e-06 $X=67740 $Y=43270 $dt=16
M4121 VIN 519 576 VDD! pfet_01v8 L=1.5e-07 W=1.5e-06 $X=67740 $Y=51550 $dt=16
M4122 VIN 520 577 VDD! pfet_01v8 L=1.5e-07 W=1.5e-06 $X=67740 $Y=59830 $dt=16
M4123 VIN 521 578 VDD! pfet_01v8 L=1.5e-07 W=1.5e-06 $X=67740 $Y=68110 $dt=16
M4124 VIN 522 579 VDD! pfet_01v8 L=1.5e-07 W=1.5e-06 $X=67740 $Y=76390 $dt=16
M4125 VIN 524 580 VDD! pfet_01v8 L=1.5e-07 W=1.5e-06 $X=67740 $Y=92950 $dt=16
M4126 VIN 525 581 VDD! pfet_01v8 L=1.5e-07 W=1.5e-06 $X=67740 $Y=101230 $dt=16
M4127 VIN 526 582 VDD! pfet_01v8 L=1.5e-07 W=1.5e-06 $X=67740 $Y=109510 $dt=16
M4128 VIN 527 583 VDD! pfet_01v8 L=1.5e-07 W=1.5e-06 $X=67740 $Y=117790 $dt=16
M4129 VIN 528 584 VDD! pfet_01v8 L=1.5e-07 W=1.5e-06 $X=67740 $Y=126070 $dt=16
M4130 VIN 529 585 VDD! pfet_01v8 L=1.5e-07 W=1.5e-06 $X=67740 $Y=134350 $dt=16
M4131 VIN 530 586 VDD! pfet_01v8 L=1.5e-07 W=1.5e-06 $X=67740 $Y=142630 $dt=16
M4132 VIN 531 587 VDD! pfet_01v8 L=1.5e-07 W=1.5e-06 $X=67740 $Y=150910 $dt=16
M4133 VIN 532 588 VDD! pfet_01v8 L=1.5e-07 W=1.5e-06 $X=67740 $Y=159190 $dt=16
M4134 VDD! VSS! VDD! VDD! pfet_01v8 L=5.8e-07 W=1.5e-06 $X=73430 $Y=84670 $dt=16
M4135 571 495 571 VDD! pfet_01v8 L=1.5e-07 W=1.5e-06 $X=73440 $Y=10150 $dt=16
M4136 572 496 572 VDD! pfet_01v8 L=1.5e-07 W=1.5e-06 $X=73440 $Y=18430 $dt=16
M4137 573 497 573 VDD! pfet_01v8 L=1.5e-07 W=1.5e-06 $X=73440 $Y=26710 $dt=16
M4138 574 498 574 VDD! pfet_01v8 L=1.5e-07 W=1.5e-06 $X=73440 $Y=34990 $dt=16
M4139 575 499 575 VDD! pfet_01v8 L=1.5e-07 W=1.5e-06 $X=73440 $Y=43270 $dt=16
M4140 576 500 576 VDD! pfet_01v8 L=1.5e-07 W=1.5e-06 $X=73440 $Y=51550 $dt=16
M4141 577 501 577 VDD! pfet_01v8 L=1.5e-07 W=1.5e-06 $X=73440 $Y=59830 $dt=16
M4142 578 502 578 VDD! pfet_01v8 L=1.5e-07 W=1.5e-06 $X=73440 $Y=68110 $dt=16
M4143 579 503 579 VDD! pfet_01v8 L=1.5e-07 W=1.5e-06 $X=73440 $Y=76390 $dt=16
M4144 580 505 580 VDD! pfet_01v8 L=1.5e-07 W=1.5e-06 $X=73440 $Y=92950 $dt=16
M4145 581 506 581 VDD! pfet_01v8 L=1.5e-07 W=1.5e-06 $X=73440 $Y=101230 $dt=16
M4146 582 507 582 VDD! pfet_01v8 L=1.5e-07 W=1.5e-06 $X=73440 $Y=109510 $dt=16
M4147 583 508 583 VDD! pfet_01v8 L=1.5e-07 W=1.5e-06 $X=73440 $Y=117790 $dt=16
M4148 584 509 584 VDD! pfet_01v8 L=1.5e-07 W=1.5e-06 $X=73440 $Y=126070 $dt=16
M4149 585 510 585 VDD! pfet_01v8 L=1.5e-07 W=1.5e-06 $X=73440 $Y=134350 $dt=16
M4150 586 511 586 VDD! pfet_01v8 L=1.5e-07 W=1.5e-06 $X=73440 $Y=142630 $dt=16
M4151 587 512 587 VDD! pfet_01v8 L=1.5e-07 W=1.5e-06 $X=73440 $Y=150910 $dt=16
M4152 588 513 588 VDD! pfet_01v8 L=1.5e-07 W=1.5e-06 $X=73440 $Y=159190 $dt=16
M4153 VREF_N 457 571 VDD! pfet_01v8 L=1.5e-07 W=1.5e-06 $X=73870 $Y=10150 $dt=16
M4154 VREF_N 459 572 VDD! pfet_01v8 L=1.5e-07 W=1.5e-06 $X=73870 $Y=18430 $dt=16
M4155 VREF_N 461 573 VDD! pfet_01v8 L=1.5e-07 W=1.5e-06 $X=73870 $Y=26710 $dt=16
M4156 VREF_N 463 574 VDD! pfet_01v8 L=1.5e-07 W=1.5e-06 $X=73870 $Y=34990 $dt=16
M4157 VREF_N 465 575 VDD! pfet_01v8 L=1.5e-07 W=1.5e-06 $X=73870 $Y=43270 $dt=16
M4158 VREF_N 467 576 VDD! pfet_01v8 L=1.5e-07 W=1.5e-06 $X=73870 $Y=51550 $dt=16
M4159 VREF_N 469 577 VDD! pfet_01v8 L=1.5e-07 W=1.5e-06 $X=73870 $Y=59830 $dt=16
M4160 VREF_N 471 578 VDD! pfet_01v8 L=1.5e-07 W=1.5e-06 $X=73870 $Y=68110 $dt=16
M4161 VREF_N 473 579 VDD! pfet_01v8 L=1.5e-07 W=1.5e-06 $X=73870 $Y=76390 $dt=16
M4162 VREF_N 477 580 VDD! pfet_01v8 L=1.5e-07 W=1.5e-06 $X=73870 $Y=92950 $dt=16
M4163 VREF_N 479 581 VDD! pfet_01v8 L=1.5e-07 W=1.5e-06 $X=73870 $Y=101230 $dt=16
M4164 VREF_N 481 582 VDD! pfet_01v8 L=1.5e-07 W=1.5e-06 $X=73870 $Y=109510 $dt=16
M4165 VREF_N 483 583 VDD! pfet_01v8 L=1.5e-07 W=1.5e-06 $X=73870 $Y=117790 $dt=16
M4166 VREF_N 485 584 VDD! pfet_01v8 L=1.5e-07 W=1.5e-06 $X=73870 $Y=126070 $dt=16
M4167 VREF_N 487 585 VDD! pfet_01v8 L=1.5e-07 W=1.5e-06 $X=73870 $Y=134350 $dt=16
M4168 VREF_N 489 586 VDD! pfet_01v8 L=1.5e-07 W=1.5e-06 $X=73870 $Y=142630 $dt=16
M4169 VREF_N 491 587 VDD! pfet_01v8 L=1.5e-07 W=1.5e-06 $X=73870 $Y=150910 $dt=16
M4170 VREF_N 493 588 VDD! pfet_01v8 L=1.5e-07 W=1.5e-06 $X=73870 $Y=159190 $dt=16
M4171 438 533 VREF_P VDD! pfet_01v8 L=1.5e-07 W=1.5e-06 $X=75590 $Y=10150 $dt=16
M4172 439 535 VREF_P VDD! pfet_01v8 L=1.5e-07 W=1.5e-06 $X=75590 $Y=18430 $dt=16
M4173 440 537 VREF_P VDD! pfet_01v8 L=1.5e-07 W=1.5e-06 $X=75590 $Y=26710 $dt=16
M4174 441 539 VREF_P VDD! pfet_01v8 L=1.5e-07 W=1.5e-06 $X=75590 $Y=34990 $dt=16
M4175 442 541 VREF_P VDD! pfet_01v8 L=1.5e-07 W=1.5e-06 $X=75590 $Y=43270 $dt=16
M4176 443 543 VREF_P VDD! pfet_01v8 L=1.5e-07 W=1.5e-06 $X=75590 $Y=51550 $dt=16
M4177 444 545 VREF_P VDD! pfet_01v8 L=1.5e-07 W=1.5e-06 $X=75590 $Y=59830 $dt=16
M4178 445 547 VREF_P VDD! pfet_01v8 L=1.5e-07 W=1.5e-06 $X=75590 $Y=68110 $dt=16
M4179 446 549 VREF_P VDD! pfet_01v8 L=1.5e-07 W=1.5e-06 $X=75590 $Y=76390 $dt=16
M4180 447 551 VREF_P VDD! pfet_01v8 L=1.5e-07 W=1.5e-06 $X=75590 $Y=84670 $dt=16
M4181 448 553 VREF_P VDD! pfet_01v8 L=1.5e-07 W=1.5e-06 $X=75590 $Y=92950 $dt=16
M4182 449 555 VREF_P VDD! pfet_01v8 L=1.5e-07 W=1.5e-06 $X=75590 $Y=101230 $dt=16
M4183 450 557 VREF_P VDD! pfet_01v8 L=1.5e-07 W=1.5e-06 $X=75590 $Y=109510 $dt=16
M4184 451 559 VREF_P VDD! pfet_01v8 L=1.5e-07 W=1.5e-06 $X=75590 $Y=117790 $dt=16
M4185 452 561 VREF_P VDD! pfet_01v8 L=1.5e-07 W=1.5e-06 $X=75590 $Y=126070 $dt=16
M4186 453 563 VREF_P VDD! pfet_01v8 L=1.5e-07 W=1.5e-06 $X=75590 $Y=134350 $dt=16
M4187 454 565 VREF_P VDD! pfet_01v8 L=1.5e-07 W=1.5e-06 $X=75590 $Y=142630 $dt=16
M4188 455 567 VREF_P VDD! pfet_01v8 L=1.5e-07 W=1.5e-06 $X=75590 $Y=150910 $dt=16
M4189 456 569 VREF_P VDD! pfet_01v8 L=1.5e-07 W=1.5e-06 $X=75590 $Y=159190 $dt=16
M4190 VIN 514 438 VDD! pfet_01v8 L=1.5e-07 W=1.5e-06 $X=76020 $Y=10150 $dt=16
M4191 VIN 515 439 VDD! pfet_01v8 L=1.5e-07 W=1.5e-06 $X=76020 $Y=18430 $dt=16
M4192 VIN 516 440 VDD! pfet_01v8 L=1.5e-07 W=1.5e-06 $X=76020 $Y=26710 $dt=16
M4193 VIN 517 441 VDD! pfet_01v8 L=1.5e-07 W=1.5e-06 $X=76020 $Y=34990 $dt=16
M4194 VIN 518 442 VDD! pfet_01v8 L=1.5e-07 W=1.5e-06 $X=76020 $Y=43270 $dt=16
M4195 VIN 519 443 VDD! pfet_01v8 L=1.5e-07 W=1.5e-06 $X=76020 $Y=51550 $dt=16
M4196 VIN 520 444 VDD! pfet_01v8 L=1.5e-07 W=1.5e-06 $X=76020 $Y=59830 $dt=16
M4197 VIN 521 445 VDD! pfet_01v8 L=1.5e-07 W=1.5e-06 $X=76020 $Y=68110 $dt=16
M4198 VIN 522 446 VDD! pfet_01v8 L=1.5e-07 W=1.5e-06 $X=76020 $Y=76390 $dt=16
M4199 VIN 523 447 VDD! pfet_01v8 L=1.5e-07 W=1.5e-06 $X=76020 $Y=84670 $dt=16
M4200 VIN 524 448 VDD! pfet_01v8 L=1.5e-07 W=1.5e-06 $X=76020 $Y=92950 $dt=16
M4201 VIN 525 449 VDD! pfet_01v8 L=1.5e-07 W=1.5e-06 $X=76020 $Y=101230 $dt=16
M4202 VIN 526 450 VDD! pfet_01v8 L=1.5e-07 W=1.5e-06 $X=76020 $Y=109510 $dt=16
M4203 VIN 527 451 VDD! pfet_01v8 L=1.5e-07 W=1.5e-06 $X=76020 $Y=117790 $dt=16
M4204 VIN 528 452 VDD! pfet_01v8 L=1.5e-07 W=1.5e-06 $X=76020 $Y=126070 $dt=16
M4205 VIN 529 453 VDD! pfet_01v8 L=1.5e-07 W=1.5e-06 $X=76020 $Y=134350 $dt=16
M4206 VIN 530 454 VDD! pfet_01v8 L=1.5e-07 W=1.5e-06 $X=76020 $Y=142630 $dt=16
M4207 VIN 531 455 VDD! pfet_01v8 L=1.5e-07 W=1.5e-06 $X=76020 $Y=150910 $dt=16
M4208 VIN 532 456 VDD! pfet_01v8 L=1.5e-07 W=1.5e-06 $X=76020 $Y=159190 $dt=16
M4209 438 495 438 VDD! pfet_01v8 L=1.5e-07 W=1.5e-06 $X=81720 $Y=10150 $dt=16
M4210 439 496 439 VDD! pfet_01v8 L=1.5e-07 W=1.5e-06 $X=81720 $Y=18430 $dt=16
M4211 440 497 440 VDD! pfet_01v8 L=1.5e-07 W=1.5e-06 $X=81720 $Y=26710 $dt=16
M4212 441 498 441 VDD! pfet_01v8 L=1.5e-07 W=1.5e-06 $X=81720 $Y=34990 $dt=16
M4213 442 499 442 VDD! pfet_01v8 L=1.5e-07 W=1.5e-06 $X=81720 $Y=43270 $dt=16
M4214 443 500 443 VDD! pfet_01v8 L=1.5e-07 W=1.5e-06 $X=81720 $Y=51550 $dt=16
M4215 444 501 444 VDD! pfet_01v8 L=1.5e-07 W=1.5e-06 $X=81720 $Y=59830 $dt=16
M4216 445 502 445 VDD! pfet_01v8 L=1.5e-07 W=1.5e-06 $X=81720 $Y=68110 $dt=16
M4217 446 503 446 VDD! pfet_01v8 L=1.5e-07 W=1.5e-06 $X=81720 $Y=76390 $dt=16
M4218 447 504 447 VDD! pfet_01v8 L=1.5e-07 W=1.5e-06 $X=81720 $Y=84670 $dt=16
M4219 448 505 448 VDD! pfet_01v8 L=1.5e-07 W=1.5e-06 $X=81720 $Y=92950 $dt=16
M4220 449 506 449 VDD! pfet_01v8 L=1.5e-07 W=1.5e-06 $X=81720 $Y=101230 $dt=16
M4221 450 507 450 VDD! pfet_01v8 L=1.5e-07 W=1.5e-06 $X=81720 $Y=109510 $dt=16
M4222 451 508 451 VDD! pfet_01v8 L=1.5e-07 W=1.5e-06 $X=81720 $Y=117790 $dt=16
M4223 452 509 452 VDD! pfet_01v8 L=1.5e-07 W=1.5e-06 $X=81720 $Y=126070 $dt=16
M4224 453 510 453 VDD! pfet_01v8 L=1.5e-07 W=1.5e-06 $X=81720 $Y=134350 $dt=16
M4225 454 511 454 VDD! pfet_01v8 L=1.5e-07 W=1.5e-06 $X=81720 $Y=142630 $dt=16
M4226 455 512 455 VDD! pfet_01v8 L=1.5e-07 W=1.5e-06 $X=81720 $Y=150910 $dt=16
M4227 456 513 456 VDD! pfet_01v8 L=1.5e-07 W=1.5e-06 $X=81720 $Y=159190 $dt=16
M4228 VREF_N 457 438 VDD! pfet_01v8 L=1.5e-07 W=1.5e-06 $X=82150 $Y=10150 $dt=16
M4229 VREF_N 459 439 VDD! pfet_01v8 L=1.5e-07 W=1.5e-06 $X=82150 $Y=18430 $dt=16
M4230 VREF_N 461 440 VDD! pfet_01v8 L=1.5e-07 W=1.5e-06 $X=82150 $Y=26710 $dt=16
M4231 VREF_N 463 441 VDD! pfet_01v8 L=1.5e-07 W=1.5e-06 $X=82150 $Y=34990 $dt=16
M4232 VREF_N 465 442 VDD! pfet_01v8 L=1.5e-07 W=1.5e-06 $X=82150 $Y=43270 $dt=16
M4233 VREF_N 467 443 VDD! pfet_01v8 L=1.5e-07 W=1.5e-06 $X=82150 $Y=51550 $dt=16
M4234 VREF_N 469 444 VDD! pfet_01v8 L=1.5e-07 W=1.5e-06 $X=82150 $Y=59830 $dt=16
M4235 VREF_N 471 445 VDD! pfet_01v8 L=1.5e-07 W=1.5e-06 $X=82150 $Y=68110 $dt=16
M4236 VREF_N 473 446 VDD! pfet_01v8 L=1.5e-07 W=1.5e-06 $X=82150 $Y=76390 $dt=16
M4237 VREF_N 475 447 VDD! pfet_01v8 L=1.5e-07 W=1.5e-06 $X=82150 $Y=84670 $dt=16
M4238 VREF_N 477 448 VDD! pfet_01v8 L=1.5e-07 W=1.5e-06 $X=82150 $Y=92950 $dt=16
M4239 VREF_N 479 449 VDD! pfet_01v8 L=1.5e-07 W=1.5e-06 $X=82150 $Y=101230 $dt=16
M4240 VREF_N 481 450 VDD! pfet_01v8 L=1.5e-07 W=1.5e-06 $X=82150 $Y=109510 $dt=16
M4241 VREF_N 483 451 VDD! pfet_01v8 L=1.5e-07 W=1.5e-06 $X=82150 $Y=117790 $dt=16
M4242 VREF_N 485 452 VDD! pfet_01v8 L=1.5e-07 W=1.5e-06 $X=82150 $Y=126070 $dt=16
M4243 VREF_N 487 453 VDD! pfet_01v8 L=1.5e-07 W=1.5e-06 $X=82150 $Y=134350 $dt=16
M4244 VREF_N 489 454 VDD! pfet_01v8 L=1.5e-07 W=1.5e-06 $X=82150 $Y=142630 $dt=16
M4245 VREF_N 491 455 VDD! pfet_01v8 L=1.5e-07 W=1.5e-06 $X=82150 $Y=150910 $dt=16
M4246 VREF_N 493 456 VDD! pfet_01v8 L=1.5e-07 W=1.5e-06 $X=82150 $Y=159190 $dt=16
M4247 419 213 VREF_P VDD! pfet_01v8 L=1.5e-07 W=1.5e-06 $X=83870 $Y=10150 $dt=16
M4248 420 214 VREF_P VDD! pfet_01v8 L=1.5e-07 W=1.5e-06 $X=83870 $Y=18430 $dt=16
M4249 421 215 VREF_P VDD! pfet_01v8 L=1.5e-07 W=1.5e-06 $X=83870 $Y=26710 $dt=16
M4250 422 216 VREF_P VDD! pfet_01v8 L=1.5e-07 W=1.5e-06 $X=83870 $Y=34990 $dt=16
M4251 423 217 VREF_P VDD! pfet_01v8 L=1.5e-07 W=1.5e-06 $X=83870 $Y=43270 $dt=16
M4252 424 218 VREF_P VDD! pfet_01v8 L=1.5e-07 W=1.5e-06 $X=83870 $Y=51550 $dt=16
M4253 425 219 VREF_P VDD! pfet_01v8 L=1.5e-07 W=1.5e-06 $X=83870 $Y=59830 $dt=16
M4254 426 220 VREF_P VDD! pfet_01v8 L=1.5e-07 W=1.5e-06 $X=83870 $Y=68110 $dt=16
M4255 427 221 VREF_P VDD! pfet_01v8 L=1.5e-07 W=1.5e-06 $X=83870 $Y=76390 $dt=16
M4256 428 222 VREF_P VDD! pfet_01v8 L=1.5e-07 W=1.5e-06 $X=83870 $Y=84670 $dt=16
M4257 429 223 VREF_P VDD! pfet_01v8 L=1.5e-07 W=1.5e-06 $X=83870 $Y=92950 $dt=16
M4258 430 224 VREF_P VDD! pfet_01v8 L=1.5e-07 W=1.5e-06 $X=83870 $Y=101230 $dt=16
M4259 431 225 VREF_P VDD! pfet_01v8 L=1.5e-07 W=1.5e-06 $X=83870 $Y=109510 $dt=16
M4260 432 226 VREF_P VDD! pfet_01v8 L=1.5e-07 W=1.5e-06 $X=83870 $Y=117790 $dt=16
M4261 433 227 VREF_P VDD! pfet_01v8 L=1.5e-07 W=1.5e-06 $X=83870 $Y=126070 $dt=16
M4262 434 228 VREF_P VDD! pfet_01v8 L=1.5e-07 W=1.5e-06 $X=83870 $Y=134350 $dt=16
M4263 435 229 VREF_P VDD! pfet_01v8 L=1.5e-07 W=1.5e-06 $X=83870 $Y=142630 $dt=16
M4264 436 230 VREF_P VDD! pfet_01v8 L=1.5e-07 W=1.5e-06 $X=83870 $Y=150910 $dt=16
M4265 437 231 VREF_P VDD! pfet_01v8 L=1.5e-07 W=1.5e-06 $X=83870 $Y=159190 $dt=16
M4266 VIN 289 419 VDD! pfet_01v8 L=1.5e-07 W=1.5e-06 $X=84300 $Y=10150 $dt=16
M4267 VIN 290 420 VDD! pfet_01v8 L=1.5e-07 W=1.5e-06 $X=84300 $Y=18430 $dt=16
M4268 VIN 291 421 VDD! pfet_01v8 L=1.5e-07 W=1.5e-06 $X=84300 $Y=26710 $dt=16
M4269 VIN 292 422 VDD! pfet_01v8 L=1.5e-07 W=1.5e-06 $X=84300 $Y=34990 $dt=16
M4270 VIN 293 423 VDD! pfet_01v8 L=1.5e-07 W=1.5e-06 $X=84300 $Y=43270 $dt=16
M4271 VIN 294 424 VDD! pfet_01v8 L=1.5e-07 W=1.5e-06 $X=84300 $Y=51550 $dt=16
M4272 VIN 295 425 VDD! pfet_01v8 L=1.5e-07 W=1.5e-06 $X=84300 $Y=59830 $dt=16
M4273 VIN 296 426 VDD! pfet_01v8 L=1.5e-07 W=1.5e-06 $X=84300 $Y=68110 $dt=16
M4274 VIN 297 427 VDD! pfet_01v8 L=1.5e-07 W=1.5e-06 $X=84300 $Y=76390 $dt=16
M4275 VIN 298 428 VDD! pfet_01v8 L=1.5e-07 W=1.5e-06 $X=84300 $Y=84670 $dt=16
M4276 VIN 299 429 VDD! pfet_01v8 L=1.5e-07 W=1.5e-06 $X=84300 $Y=92950 $dt=16
M4277 VIN 300 430 VDD! pfet_01v8 L=1.5e-07 W=1.5e-06 $X=84300 $Y=101230 $dt=16
M4278 VIN 301 431 VDD! pfet_01v8 L=1.5e-07 W=1.5e-06 $X=84300 $Y=109510 $dt=16
M4279 VIN 302 432 VDD! pfet_01v8 L=1.5e-07 W=1.5e-06 $X=84300 $Y=117790 $dt=16
M4280 VIN 303 433 VDD! pfet_01v8 L=1.5e-07 W=1.5e-06 $X=84300 $Y=126070 $dt=16
M4281 VIN 304 434 VDD! pfet_01v8 L=1.5e-07 W=1.5e-06 $X=84300 $Y=134350 $dt=16
M4282 VIN 305 435 VDD! pfet_01v8 L=1.5e-07 W=1.5e-06 $X=84300 $Y=142630 $dt=16
M4283 VIN 306 436 VDD! pfet_01v8 L=1.5e-07 W=1.5e-06 $X=84300 $Y=150910 $dt=16
M4284 VIN 307 437 VDD! pfet_01v8 L=1.5e-07 W=1.5e-06 $X=84300 $Y=159190 $dt=16
M4285 419 270 419 VDD! pfet_01v8 L=1.5e-07 W=1.5e-06 $X=90000 $Y=10150 $dt=16
M4286 420 271 420 VDD! pfet_01v8 L=1.5e-07 W=1.5e-06 $X=90000 $Y=18430 $dt=16
M4287 421 272 421 VDD! pfet_01v8 L=1.5e-07 W=1.5e-06 $X=90000 $Y=26710 $dt=16
M4288 422 273 422 VDD! pfet_01v8 L=1.5e-07 W=1.5e-06 $X=90000 $Y=34990 $dt=16
M4289 423 274 423 VDD! pfet_01v8 L=1.5e-07 W=1.5e-06 $X=90000 $Y=43270 $dt=16
M4290 424 275 424 VDD! pfet_01v8 L=1.5e-07 W=1.5e-06 $X=90000 $Y=51550 $dt=16
M4291 425 276 425 VDD! pfet_01v8 L=1.5e-07 W=1.5e-06 $X=90000 $Y=59830 $dt=16
M4292 426 277 426 VDD! pfet_01v8 L=1.5e-07 W=1.5e-06 $X=90000 $Y=68110 $dt=16
M4293 427 278 427 VDD! pfet_01v8 L=1.5e-07 W=1.5e-06 $X=90000 $Y=76390 $dt=16
M4294 428 279 428 VDD! pfet_01v8 L=1.5e-07 W=1.5e-06 $X=90000 $Y=84670 $dt=16
M4295 429 280 429 VDD! pfet_01v8 L=1.5e-07 W=1.5e-06 $X=90000 $Y=92950 $dt=16
M4296 430 281 430 VDD! pfet_01v8 L=1.5e-07 W=1.5e-06 $X=90000 $Y=101230 $dt=16
M4297 431 282 431 VDD! pfet_01v8 L=1.5e-07 W=1.5e-06 $X=90000 $Y=109510 $dt=16
M4298 432 283 432 VDD! pfet_01v8 L=1.5e-07 W=1.5e-06 $X=90000 $Y=117790 $dt=16
M4299 433 284 433 VDD! pfet_01v8 L=1.5e-07 W=1.5e-06 $X=90000 $Y=126070 $dt=16
M4300 434 285 434 VDD! pfet_01v8 L=1.5e-07 W=1.5e-06 $X=90000 $Y=134350 $dt=16
M4301 435 286 435 VDD! pfet_01v8 L=1.5e-07 W=1.5e-06 $X=90000 $Y=142630 $dt=16
M4302 436 287 436 VDD! pfet_01v8 L=1.5e-07 W=1.5e-06 $X=90000 $Y=150910 $dt=16
M4303 437 288 437 VDD! pfet_01v8 L=1.5e-07 W=1.5e-06 $X=90000 $Y=159190 $dt=16
M4304 VREF_N 175 419 VDD! pfet_01v8 L=1.5e-07 W=1.5e-06 $X=90430 $Y=10150 $dt=16
M4305 VREF_N 176 420 VDD! pfet_01v8 L=1.5e-07 W=1.5e-06 $X=90430 $Y=18430 $dt=16
M4306 VREF_N 177 421 VDD! pfet_01v8 L=1.5e-07 W=1.5e-06 $X=90430 $Y=26710 $dt=16
M4307 VREF_N 178 422 VDD! pfet_01v8 L=1.5e-07 W=1.5e-06 $X=90430 $Y=34990 $dt=16
M4308 VREF_N 179 423 VDD! pfet_01v8 L=1.5e-07 W=1.5e-06 $X=90430 $Y=43270 $dt=16
M4309 VREF_N 180 424 VDD! pfet_01v8 L=1.5e-07 W=1.5e-06 $X=90430 $Y=51550 $dt=16
M4310 VREF_N 181 425 VDD! pfet_01v8 L=1.5e-07 W=1.5e-06 $X=90430 $Y=59830 $dt=16
M4311 VREF_N 182 426 VDD! pfet_01v8 L=1.5e-07 W=1.5e-06 $X=90430 $Y=68110 $dt=16
M4312 VREF_N 183 427 VDD! pfet_01v8 L=1.5e-07 W=1.5e-06 $X=90430 $Y=76390 $dt=16
M4313 VREF_N 184 428 VDD! pfet_01v8 L=1.5e-07 W=1.5e-06 $X=90430 $Y=84670 $dt=16
M4314 VREF_N 185 429 VDD! pfet_01v8 L=1.5e-07 W=1.5e-06 $X=90430 $Y=92950 $dt=16
M4315 VREF_N 186 430 VDD! pfet_01v8 L=1.5e-07 W=1.5e-06 $X=90430 $Y=101230 $dt=16
M4316 VREF_N 187 431 VDD! pfet_01v8 L=1.5e-07 W=1.5e-06 $X=90430 $Y=109510 $dt=16
M4317 VREF_N 188 432 VDD! pfet_01v8 L=1.5e-07 W=1.5e-06 $X=90430 $Y=117790 $dt=16
M4318 VREF_N 189 433 VDD! pfet_01v8 L=1.5e-07 W=1.5e-06 $X=90430 $Y=126070 $dt=16
M4319 VREF_N 190 434 VDD! pfet_01v8 L=1.5e-07 W=1.5e-06 $X=90430 $Y=134350 $dt=16
M4320 VREF_N 191 435 VDD! pfet_01v8 L=1.5e-07 W=1.5e-06 $X=90430 $Y=142630 $dt=16
M4321 VREF_N 192 436 VDD! pfet_01v8 L=1.5e-07 W=1.5e-06 $X=90430 $Y=150910 $dt=16
M4322 VREF_N 193 437 VDD! pfet_01v8 L=1.5e-07 W=1.5e-06 $X=90430 $Y=159190 $dt=16
M4323 401 213 VREF_P VDD! pfet_01v8 L=1.5e-07 W=1.5e-06 $X=92150 $Y=10150 $dt=16
M4324 402 214 VREF_P VDD! pfet_01v8 L=1.5e-07 W=1.5e-06 $X=92150 $Y=18430 $dt=16
M4325 403 215 VREF_P VDD! pfet_01v8 L=1.5e-07 W=1.5e-06 $X=92150 $Y=26710 $dt=16
M4326 404 216 VREF_P VDD! pfet_01v8 L=1.5e-07 W=1.5e-06 $X=92150 $Y=34990 $dt=16
M4327 405 217 VREF_P VDD! pfet_01v8 L=1.5e-07 W=1.5e-06 $X=92150 $Y=43270 $dt=16
M4328 406 218 VREF_P VDD! pfet_01v8 L=1.5e-07 W=1.5e-06 $X=92150 $Y=51550 $dt=16
M4329 407 219 VREF_P VDD! pfet_01v8 L=1.5e-07 W=1.5e-06 $X=92150 $Y=59830 $dt=16
M4330 408 220 VREF_P VDD! pfet_01v8 L=1.5e-07 W=1.5e-06 $X=92150 $Y=68110 $dt=16
M4331 409 221 VREF_P VDD! pfet_01v8 L=1.5e-07 W=1.5e-06 $X=92150 $Y=76390 $dt=16
M4332 VDD! VSS! VDD! VDD! pfet_01v8 L=5.8e-07 W=1.5e-06 $X=92150 $Y=84670 $dt=16
M4333 410 223 VREF_P VDD! pfet_01v8 L=1.5e-07 W=1.5e-06 $X=92150 $Y=92950 $dt=16
M4334 411 224 VREF_P VDD! pfet_01v8 L=1.5e-07 W=1.5e-06 $X=92150 $Y=101230 $dt=16
M4335 412 225 VREF_P VDD! pfet_01v8 L=1.5e-07 W=1.5e-06 $X=92150 $Y=109510 $dt=16
M4336 413 226 VREF_P VDD! pfet_01v8 L=1.5e-07 W=1.5e-06 $X=92150 $Y=117790 $dt=16
M4337 414 227 VREF_P VDD! pfet_01v8 L=1.5e-07 W=1.5e-06 $X=92150 $Y=126070 $dt=16
M4338 415 228 VREF_P VDD! pfet_01v8 L=1.5e-07 W=1.5e-06 $X=92150 $Y=134350 $dt=16
M4339 416 229 VREF_P VDD! pfet_01v8 L=1.5e-07 W=1.5e-06 $X=92150 $Y=142630 $dt=16
M4340 417 230 VREF_P VDD! pfet_01v8 L=1.5e-07 W=1.5e-06 $X=92150 $Y=150910 $dt=16
M4341 418 231 VREF_P VDD! pfet_01v8 L=1.5e-07 W=1.5e-06 $X=92150 $Y=159190 $dt=16
M4342 VIN 289 401 VDD! pfet_01v8 L=1.5e-07 W=1.5e-06 $X=92580 $Y=10150 $dt=16
M4343 VIN 290 402 VDD! pfet_01v8 L=1.5e-07 W=1.5e-06 $X=92580 $Y=18430 $dt=16
M4344 VIN 291 403 VDD! pfet_01v8 L=1.5e-07 W=1.5e-06 $X=92580 $Y=26710 $dt=16
M4345 VIN 292 404 VDD! pfet_01v8 L=1.5e-07 W=1.5e-06 $X=92580 $Y=34990 $dt=16
M4346 VIN 293 405 VDD! pfet_01v8 L=1.5e-07 W=1.5e-06 $X=92580 $Y=43270 $dt=16
M4347 VIN 294 406 VDD! pfet_01v8 L=1.5e-07 W=1.5e-06 $X=92580 $Y=51550 $dt=16
M4348 VIN 295 407 VDD! pfet_01v8 L=1.5e-07 W=1.5e-06 $X=92580 $Y=59830 $dt=16
M4349 VIN 296 408 VDD! pfet_01v8 L=1.5e-07 W=1.5e-06 $X=92580 $Y=68110 $dt=16
M4350 VIN 297 409 VDD! pfet_01v8 L=1.5e-07 W=1.5e-06 $X=92580 $Y=76390 $dt=16
M4351 VIN 299 410 VDD! pfet_01v8 L=1.5e-07 W=1.5e-06 $X=92580 $Y=92950 $dt=16
M4352 VIN 300 411 VDD! pfet_01v8 L=1.5e-07 W=1.5e-06 $X=92580 $Y=101230 $dt=16
M4353 VIN 301 412 VDD! pfet_01v8 L=1.5e-07 W=1.5e-06 $X=92580 $Y=109510 $dt=16
M4354 VIN 302 413 VDD! pfet_01v8 L=1.5e-07 W=1.5e-06 $X=92580 $Y=117790 $dt=16
M4355 VIN 303 414 VDD! pfet_01v8 L=1.5e-07 W=1.5e-06 $X=92580 $Y=126070 $dt=16
M4356 VIN 304 415 VDD! pfet_01v8 L=1.5e-07 W=1.5e-06 $X=92580 $Y=134350 $dt=16
M4357 VIN 305 416 VDD! pfet_01v8 L=1.5e-07 W=1.5e-06 $X=92580 $Y=142630 $dt=16
M4358 VIN 306 417 VDD! pfet_01v8 L=1.5e-07 W=1.5e-06 $X=92580 $Y=150910 $dt=16
M4359 VIN 307 418 VDD! pfet_01v8 L=1.5e-07 W=1.5e-06 $X=92580 $Y=159190 $dt=16
M4360 VDD! VSS! VDD! VDD! pfet_01v8 L=5.8e-07 W=1.5e-06 $X=98270 $Y=84670 $dt=16
M4361 401 270 401 VDD! pfet_01v8 L=1.5e-07 W=1.5e-06 $X=98280 $Y=10150 $dt=16
M4362 402 271 402 VDD! pfet_01v8 L=1.5e-07 W=1.5e-06 $X=98280 $Y=18430 $dt=16
M4363 403 272 403 VDD! pfet_01v8 L=1.5e-07 W=1.5e-06 $X=98280 $Y=26710 $dt=16
M4364 404 273 404 VDD! pfet_01v8 L=1.5e-07 W=1.5e-06 $X=98280 $Y=34990 $dt=16
M4365 405 274 405 VDD! pfet_01v8 L=1.5e-07 W=1.5e-06 $X=98280 $Y=43270 $dt=16
M4366 406 275 406 VDD! pfet_01v8 L=1.5e-07 W=1.5e-06 $X=98280 $Y=51550 $dt=16
M4367 407 276 407 VDD! pfet_01v8 L=1.5e-07 W=1.5e-06 $X=98280 $Y=59830 $dt=16
M4368 408 277 408 VDD! pfet_01v8 L=1.5e-07 W=1.5e-06 $X=98280 $Y=68110 $dt=16
M4369 409 278 409 VDD! pfet_01v8 L=1.5e-07 W=1.5e-06 $X=98280 $Y=76390 $dt=16
M4370 410 280 410 VDD! pfet_01v8 L=1.5e-07 W=1.5e-06 $X=98280 $Y=92950 $dt=16
M4371 411 281 411 VDD! pfet_01v8 L=1.5e-07 W=1.5e-06 $X=98280 $Y=101230 $dt=16
M4372 412 282 412 VDD! pfet_01v8 L=1.5e-07 W=1.5e-06 $X=98280 $Y=109510 $dt=16
M4373 413 283 413 VDD! pfet_01v8 L=1.5e-07 W=1.5e-06 $X=98280 $Y=117790 $dt=16
M4374 414 284 414 VDD! pfet_01v8 L=1.5e-07 W=1.5e-06 $X=98280 $Y=126070 $dt=16
M4375 415 285 415 VDD! pfet_01v8 L=1.5e-07 W=1.5e-06 $X=98280 $Y=134350 $dt=16
M4376 416 286 416 VDD! pfet_01v8 L=1.5e-07 W=1.5e-06 $X=98280 $Y=142630 $dt=16
M4377 417 287 417 VDD! pfet_01v8 L=1.5e-07 W=1.5e-06 $X=98280 $Y=150910 $dt=16
M4378 418 288 418 VDD! pfet_01v8 L=1.5e-07 W=1.5e-06 $X=98280 $Y=159190 $dt=16
M4379 VREF_N 175 401 VDD! pfet_01v8 L=1.5e-07 W=1.5e-06 $X=98710 $Y=10150 $dt=16
M4380 VREF_N 176 402 VDD! pfet_01v8 L=1.5e-07 W=1.5e-06 $X=98710 $Y=18430 $dt=16
M4381 VREF_N 177 403 VDD! pfet_01v8 L=1.5e-07 W=1.5e-06 $X=98710 $Y=26710 $dt=16
M4382 VREF_N 178 404 VDD! pfet_01v8 L=1.5e-07 W=1.5e-06 $X=98710 $Y=34990 $dt=16
M4383 VREF_N 179 405 VDD! pfet_01v8 L=1.5e-07 W=1.5e-06 $X=98710 $Y=43270 $dt=16
M4384 VREF_N 180 406 VDD! pfet_01v8 L=1.5e-07 W=1.5e-06 $X=98710 $Y=51550 $dt=16
M4385 VREF_N 181 407 VDD! pfet_01v8 L=1.5e-07 W=1.5e-06 $X=98710 $Y=59830 $dt=16
M4386 VREF_N 182 408 VDD! pfet_01v8 L=1.5e-07 W=1.5e-06 $X=98710 $Y=68110 $dt=16
M4387 VREF_N 183 409 VDD! pfet_01v8 L=1.5e-07 W=1.5e-06 $X=98710 $Y=76390 $dt=16
M4388 VREF_N 185 410 VDD! pfet_01v8 L=1.5e-07 W=1.5e-06 $X=98710 $Y=92950 $dt=16
M4389 VREF_N 186 411 VDD! pfet_01v8 L=1.5e-07 W=1.5e-06 $X=98710 $Y=101230 $dt=16
M4390 VREF_N 187 412 VDD! pfet_01v8 L=1.5e-07 W=1.5e-06 $X=98710 $Y=109510 $dt=16
M4391 VREF_N 188 413 VDD! pfet_01v8 L=1.5e-07 W=1.5e-06 $X=98710 $Y=117790 $dt=16
M4392 VREF_N 189 414 VDD! pfet_01v8 L=1.5e-07 W=1.5e-06 $X=98710 $Y=126070 $dt=16
M4393 VREF_N 190 415 VDD! pfet_01v8 L=1.5e-07 W=1.5e-06 $X=98710 $Y=134350 $dt=16
M4394 VREF_N 191 416 VDD! pfet_01v8 L=1.5e-07 W=1.5e-06 $X=98710 $Y=142630 $dt=16
M4395 VREF_N 192 417 VDD! pfet_01v8 L=1.5e-07 W=1.5e-06 $X=98710 $Y=150910 $dt=16
M4396 VREF_N 193 418 VDD! pfet_01v8 L=1.5e-07 W=1.5e-06 $X=98710 $Y=159190 $dt=16
M4397 384 213 VREF_P VDD! pfet_01v8 L=1.5e-07 W=1.5e-06 $X=100430 $Y=10150 $dt=16
M4398 385 214 VREF_P VDD! pfet_01v8 L=1.5e-07 W=1.5e-06 $X=100430 $Y=18430 $dt=16
M4399 386 215 VREF_P VDD! pfet_01v8 L=1.5e-07 W=1.5e-06 $X=100430 $Y=26710 $dt=16
M4400 387 216 VREF_P VDD! pfet_01v8 L=1.5e-07 W=1.5e-06 $X=100430 $Y=34990 $dt=16
M4401 388 217 VREF_P VDD! pfet_01v8 L=1.5e-07 W=1.5e-06 $X=100430 $Y=43270 $dt=16
M4402 389 218 VREF_P VDD! pfet_01v8 L=1.5e-07 W=1.5e-06 $X=100430 $Y=51550 $dt=16
M4403 390 219 VREF_P VDD! pfet_01v8 L=1.5e-07 W=1.5e-06 $X=100430 $Y=59830 $dt=16
M4404 391 220 VREF_P VDD! pfet_01v8 L=1.5e-07 W=1.5e-06 $X=100430 $Y=68110 $dt=16
M4405 392 221 VREF_P VDD! pfet_01v8 L=1.5e-07 W=1.5e-06 $X=100430 $Y=76390 $dt=16
M4406 VDD! VSS! VDD! VDD! pfet_01v8 L=5.8e-07 W=1.5e-06 $X=100430 $Y=84670 $dt=16
M4407 VDD! VSS! VDD! VDD! pfet_01v8 L=5.8e-07 W=1.5e-06 $X=100430 $Y=92950 $dt=16
M4408 393 224 VREF_P VDD! pfet_01v8 L=1.5e-07 W=1.5e-06 $X=100430 $Y=101230 $dt=16
M4409 394 225 VREF_P VDD! pfet_01v8 L=1.5e-07 W=1.5e-06 $X=100430 $Y=109510 $dt=16
M4410 395 226 VREF_P VDD! pfet_01v8 L=1.5e-07 W=1.5e-06 $X=100430 $Y=117790 $dt=16
M4411 396 227 VREF_P VDD! pfet_01v8 L=1.5e-07 W=1.5e-06 $X=100430 $Y=126070 $dt=16
M4412 397 228 VREF_P VDD! pfet_01v8 L=1.5e-07 W=1.5e-06 $X=100430 $Y=134350 $dt=16
M4413 398 229 VREF_P VDD! pfet_01v8 L=1.5e-07 W=1.5e-06 $X=100430 $Y=142630 $dt=16
M4414 399 230 VREF_P VDD! pfet_01v8 L=1.5e-07 W=1.5e-06 $X=100430 $Y=150910 $dt=16
M4415 400 231 VREF_P VDD! pfet_01v8 L=1.5e-07 W=1.5e-06 $X=100430 $Y=159190 $dt=16
M4416 VIN 289 384 VDD! pfet_01v8 L=1.5e-07 W=1.5e-06 $X=100860 $Y=10150 $dt=16
M4417 VIN 290 385 VDD! pfet_01v8 L=1.5e-07 W=1.5e-06 $X=100860 $Y=18430 $dt=16
M4418 VIN 291 386 VDD! pfet_01v8 L=1.5e-07 W=1.5e-06 $X=100860 $Y=26710 $dt=16
M4419 VIN 292 387 VDD! pfet_01v8 L=1.5e-07 W=1.5e-06 $X=100860 $Y=34990 $dt=16
M4420 VIN 293 388 VDD! pfet_01v8 L=1.5e-07 W=1.5e-06 $X=100860 $Y=43270 $dt=16
M4421 VIN 294 389 VDD! pfet_01v8 L=1.5e-07 W=1.5e-06 $X=100860 $Y=51550 $dt=16
M4422 VIN 295 390 VDD! pfet_01v8 L=1.5e-07 W=1.5e-06 $X=100860 $Y=59830 $dt=16
M4423 VIN 296 391 VDD! pfet_01v8 L=1.5e-07 W=1.5e-06 $X=100860 $Y=68110 $dt=16
M4424 VIN 297 392 VDD! pfet_01v8 L=1.5e-07 W=1.5e-06 $X=100860 $Y=76390 $dt=16
M4425 VIN 300 393 VDD! pfet_01v8 L=1.5e-07 W=1.5e-06 $X=100860 $Y=101230 $dt=16
M4426 VIN 301 394 VDD! pfet_01v8 L=1.5e-07 W=1.5e-06 $X=100860 $Y=109510 $dt=16
M4427 VIN 302 395 VDD! pfet_01v8 L=1.5e-07 W=1.5e-06 $X=100860 $Y=117790 $dt=16
M4428 VIN 303 396 VDD! pfet_01v8 L=1.5e-07 W=1.5e-06 $X=100860 $Y=126070 $dt=16
M4429 VIN 304 397 VDD! pfet_01v8 L=1.5e-07 W=1.5e-06 $X=100860 $Y=134350 $dt=16
M4430 VIN 305 398 VDD! pfet_01v8 L=1.5e-07 W=1.5e-06 $X=100860 $Y=142630 $dt=16
M4431 VIN 306 399 VDD! pfet_01v8 L=1.5e-07 W=1.5e-06 $X=100860 $Y=150910 $dt=16
M4432 VIN 307 400 VDD! pfet_01v8 L=1.5e-07 W=1.5e-06 $X=100860 $Y=159190 $dt=16
M4433 VDD! VSS! VDD! VDD! pfet_01v8 L=5.8e-07 W=1.5e-06 $X=106550 $Y=84670 $dt=16
M4434 VDD! VSS! VDD! VDD! pfet_01v8 L=5.8e-07 W=1.5e-06 $X=106550 $Y=92950 $dt=16
M4435 384 270 384 VDD! pfet_01v8 L=1.5e-07 W=1.5e-06 $X=106560 $Y=10150 $dt=16
M4436 385 271 385 VDD! pfet_01v8 L=1.5e-07 W=1.5e-06 $X=106560 $Y=18430 $dt=16
M4437 386 272 386 VDD! pfet_01v8 L=1.5e-07 W=1.5e-06 $X=106560 $Y=26710 $dt=16
M4438 387 273 387 VDD! pfet_01v8 L=1.5e-07 W=1.5e-06 $X=106560 $Y=34990 $dt=16
M4439 388 274 388 VDD! pfet_01v8 L=1.5e-07 W=1.5e-06 $X=106560 $Y=43270 $dt=16
M4440 389 275 389 VDD! pfet_01v8 L=1.5e-07 W=1.5e-06 $X=106560 $Y=51550 $dt=16
M4441 390 276 390 VDD! pfet_01v8 L=1.5e-07 W=1.5e-06 $X=106560 $Y=59830 $dt=16
M4442 391 277 391 VDD! pfet_01v8 L=1.5e-07 W=1.5e-06 $X=106560 $Y=68110 $dt=16
M4443 392 278 392 VDD! pfet_01v8 L=1.5e-07 W=1.5e-06 $X=106560 $Y=76390 $dt=16
M4444 393 281 393 VDD! pfet_01v8 L=1.5e-07 W=1.5e-06 $X=106560 $Y=101230 $dt=16
M4445 394 282 394 VDD! pfet_01v8 L=1.5e-07 W=1.5e-06 $X=106560 $Y=109510 $dt=16
M4446 395 283 395 VDD! pfet_01v8 L=1.5e-07 W=1.5e-06 $X=106560 $Y=117790 $dt=16
M4447 396 284 396 VDD! pfet_01v8 L=1.5e-07 W=1.5e-06 $X=106560 $Y=126070 $dt=16
M4448 397 285 397 VDD! pfet_01v8 L=1.5e-07 W=1.5e-06 $X=106560 $Y=134350 $dt=16
M4449 398 286 398 VDD! pfet_01v8 L=1.5e-07 W=1.5e-06 $X=106560 $Y=142630 $dt=16
M4450 399 287 399 VDD! pfet_01v8 L=1.5e-07 W=1.5e-06 $X=106560 $Y=150910 $dt=16
M4451 400 288 400 VDD! pfet_01v8 L=1.5e-07 W=1.5e-06 $X=106560 $Y=159190 $dt=16
M4452 VREF_N 175 384 VDD! pfet_01v8 L=1.5e-07 W=1.5e-06 $X=106990 $Y=10150 $dt=16
M4453 VREF_N 176 385 VDD! pfet_01v8 L=1.5e-07 W=1.5e-06 $X=106990 $Y=18430 $dt=16
M4454 VREF_N 177 386 VDD! pfet_01v8 L=1.5e-07 W=1.5e-06 $X=106990 $Y=26710 $dt=16
M4455 VREF_N 178 387 VDD! pfet_01v8 L=1.5e-07 W=1.5e-06 $X=106990 $Y=34990 $dt=16
M4456 VREF_N 179 388 VDD! pfet_01v8 L=1.5e-07 W=1.5e-06 $X=106990 $Y=43270 $dt=16
M4457 VREF_N 180 389 VDD! pfet_01v8 L=1.5e-07 W=1.5e-06 $X=106990 $Y=51550 $dt=16
M4458 VREF_N 181 390 VDD! pfet_01v8 L=1.5e-07 W=1.5e-06 $X=106990 $Y=59830 $dt=16
M4459 VREF_N 182 391 VDD! pfet_01v8 L=1.5e-07 W=1.5e-06 $X=106990 $Y=68110 $dt=16
M4460 VREF_N 183 392 VDD! pfet_01v8 L=1.5e-07 W=1.5e-06 $X=106990 $Y=76390 $dt=16
M4461 VREF_N 186 393 VDD! pfet_01v8 L=1.5e-07 W=1.5e-06 $X=106990 $Y=101230 $dt=16
M4462 VREF_N 187 394 VDD! pfet_01v8 L=1.5e-07 W=1.5e-06 $X=106990 $Y=109510 $dt=16
M4463 VREF_N 188 395 VDD! pfet_01v8 L=1.5e-07 W=1.5e-06 $X=106990 $Y=117790 $dt=16
M4464 VREF_N 189 396 VDD! pfet_01v8 L=1.5e-07 W=1.5e-06 $X=106990 $Y=126070 $dt=16
M4465 VREF_N 190 397 VDD! pfet_01v8 L=1.5e-07 W=1.5e-06 $X=106990 $Y=134350 $dt=16
M4466 VREF_N 191 398 VDD! pfet_01v8 L=1.5e-07 W=1.5e-06 $X=106990 $Y=142630 $dt=16
M4467 VREF_N 192 399 VDD! pfet_01v8 L=1.5e-07 W=1.5e-06 $X=106990 $Y=150910 $dt=16
M4468 VREF_N 193 400 VDD! pfet_01v8 L=1.5e-07 W=1.5e-06 $X=106990 $Y=159190 $dt=16
M4469 367 213 VREF_P VDD! pfet_01v8 L=1.5e-07 W=1.5e-06 $X=108710 $Y=10150 $dt=16
M4470 368 214 VREF_P VDD! pfet_01v8 L=1.5e-07 W=1.5e-06 $X=108710 $Y=18430 $dt=16
M4471 369 215 VREF_P VDD! pfet_01v8 L=1.5e-07 W=1.5e-06 $X=108710 $Y=26710 $dt=16
M4472 370 216 VREF_P VDD! pfet_01v8 L=1.5e-07 W=1.5e-06 $X=108710 $Y=34990 $dt=16
M4473 371 217 VREF_P VDD! pfet_01v8 L=1.5e-07 W=1.5e-06 $X=108710 $Y=43270 $dt=16
M4474 372 218 VREF_P VDD! pfet_01v8 L=1.5e-07 W=1.5e-06 $X=108710 $Y=51550 $dt=16
M4475 373 219 VREF_P VDD! pfet_01v8 L=1.5e-07 W=1.5e-06 $X=108710 $Y=59830 $dt=16
M4476 374 220 VREF_P VDD! pfet_01v8 L=1.5e-07 W=1.5e-06 $X=108710 $Y=68110 $dt=16
M4477 375 221 VREF_P VDD! pfet_01v8 L=1.5e-07 W=1.5e-06 $X=108710 $Y=76390 $dt=16
M4478 VDD! VSS! VDD! VDD! pfet_01v8 L=5.8e-07 W=1.5e-06 $X=108710 $Y=84670 $dt=16
M4479 VDD! VSS! VDD! VDD! pfet_01v8 L=5.8e-07 W=1.5e-06 $X=108710 $Y=92950 $dt=16
M4480 376 224 VREF_P VDD! pfet_01v8 L=1.5e-07 W=1.5e-06 $X=108710 $Y=101230 $dt=16
M4481 377 225 VREF_P VDD! pfet_01v8 L=1.5e-07 W=1.5e-06 $X=108710 $Y=109510 $dt=16
M4482 378 226 VREF_P VDD! pfet_01v8 L=1.5e-07 W=1.5e-06 $X=108710 $Y=117790 $dt=16
M4483 379 227 VREF_P VDD! pfet_01v8 L=1.5e-07 W=1.5e-06 $X=108710 $Y=126070 $dt=16
M4484 380 228 VREF_P VDD! pfet_01v8 L=1.5e-07 W=1.5e-06 $X=108710 $Y=134350 $dt=16
M4485 381 229 VREF_P VDD! pfet_01v8 L=1.5e-07 W=1.5e-06 $X=108710 $Y=142630 $dt=16
M4486 382 230 VREF_P VDD! pfet_01v8 L=1.5e-07 W=1.5e-06 $X=108710 $Y=150910 $dt=16
M4487 383 231 VREF_P VDD! pfet_01v8 L=1.5e-07 W=1.5e-06 $X=108710 $Y=159190 $dt=16
M4488 VIN 289 367 VDD! pfet_01v8 L=1.5e-07 W=1.5e-06 $X=109140 $Y=10150 $dt=16
M4489 VIN 290 368 VDD! pfet_01v8 L=1.5e-07 W=1.5e-06 $X=109140 $Y=18430 $dt=16
M4490 VIN 291 369 VDD! pfet_01v8 L=1.5e-07 W=1.5e-06 $X=109140 $Y=26710 $dt=16
M4491 VIN 292 370 VDD! pfet_01v8 L=1.5e-07 W=1.5e-06 $X=109140 $Y=34990 $dt=16
M4492 VIN 293 371 VDD! pfet_01v8 L=1.5e-07 W=1.5e-06 $X=109140 $Y=43270 $dt=16
M4493 VIN 294 372 VDD! pfet_01v8 L=1.5e-07 W=1.5e-06 $X=109140 $Y=51550 $dt=16
M4494 VIN 295 373 VDD! pfet_01v8 L=1.5e-07 W=1.5e-06 $X=109140 $Y=59830 $dt=16
M4495 VIN 296 374 VDD! pfet_01v8 L=1.5e-07 W=1.5e-06 $X=109140 $Y=68110 $dt=16
M4496 VIN 297 375 VDD! pfet_01v8 L=1.5e-07 W=1.5e-06 $X=109140 $Y=76390 $dt=16
M4497 VIN 300 376 VDD! pfet_01v8 L=1.5e-07 W=1.5e-06 $X=109140 $Y=101230 $dt=16
M4498 VIN 301 377 VDD! pfet_01v8 L=1.5e-07 W=1.5e-06 $X=109140 $Y=109510 $dt=16
M4499 VIN 302 378 VDD! pfet_01v8 L=1.5e-07 W=1.5e-06 $X=109140 $Y=117790 $dt=16
M4500 VIN 303 379 VDD! pfet_01v8 L=1.5e-07 W=1.5e-06 $X=109140 $Y=126070 $dt=16
M4501 VIN 304 380 VDD! pfet_01v8 L=1.5e-07 W=1.5e-06 $X=109140 $Y=134350 $dt=16
M4502 VIN 305 381 VDD! pfet_01v8 L=1.5e-07 W=1.5e-06 $X=109140 $Y=142630 $dt=16
M4503 VIN 306 382 VDD! pfet_01v8 L=1.5e-07 W=1.5e-06 $X=109140 $Y=150910 $dt=16
M4504 VIN 307 383 VDD! pfet_01v8 L=1.5e-07 W=1.5e-06 $X=109140 $Y=159190 $dt=16
M4505 VDD! VSS! VDD! VDD! pfet_01v8 L=5.8e-07 W=1.5e-06 $X=114830 $Y=84670 $dt=16
M4506 VDD! VSS! VDD! VDD! pfet_01v8 L=5.8e-07 W=1.5e-06 $X=114830 $Y=92950 $dt=16
M4507 367 270 367 VDD! pfet_01v8 L=1.5e-07 W=1.5e-06 $X=114840 $Y=10150 $dt=16
M4508 368 271 368 VDD! pfet_01v8 L=1.5e-07 W=1.5e-06 $X=114840 $Y=18430 $dt=16
M4509 369 272 369 VDD! pfet_01v8 L=1.5e-07 W=1.5e-06 $X=114840 $Y=26710 $dt=16
M4510 370 273 370 VDD! pfet_01v8 L=1.5e-07 W=1.5e-06 $X=114840 $Y=34990 $dt=16
M4511 371 274 371 VDD! pfet_01v8 L=1.5e-07 W=1.5e-06 $X=114840 $Y=43270 $dt=16
M4512 372 275 372 VDD! pfet_01v8 L=1.5e-07 W=1.5e-06 $X=114840 $Y=51550 $dt=16
M4513 373 276 373 VDD! pfet_01v8 L=1.5e-07 W=1.5e-06 $X=114840 $Y=59830 $dt=16
M4514 374 277 374 VDD! pfet_01v8 L=1.5e-07 W=1.5e-06 $X=114840 $Y=68110 $dt=16
M4515 375 278 375 VDD! pfet_01v8 L=1.5e-07 W=1.5e-06 $X=114840 $Y=76390 $dt=16
M4516 376 281 376 VDD! pfet_01v8 L=1.5e-07 W=1.5e-06 $X=114840 $Y=101230 $dt=16
M4517 377 282 377 VDD! pfet_01v8 L=1.5e-07 W=1.5e-06 $X=114840 $Y=109510 $dt=16
M4518 378 283 378 VDD! pfet_01v8 L=1.5e-07 W=1.5e-06 $X=114840 $Y=117790 $dt=16
M4519 379 284 379 VDD! pfet_01v8 L=1.5e-07 W=1.5e-06 $X=114840 $Y=126070 $dt=16
M4520 380 285 380 VDD! pfet_01v8 L=1.5e-07 W=1.5e-06 $X=114840 $Y=134350 $dt=16
M4521 381 286 381 VDD! pfet_01v8 L=1.5e-07 W=1.5e-06 $X=114840 $Y=142630 $dt=16
M4522 382 287 382 VDD! pfet_01v8 L=1.5e-07 W=1.5e-06 $X=114840 $Y=150910 $dt=16
M4523 383 288 383 VDD! pfet_01v8 L=1.5e-07 W=1.5e-06 $X=114840 $Y=159190 $dt=16
M4524 VREF_N 175 367 VDD! pfet_01v8 L=1.5e-07 W=1.5e-06 $X=115270 $Y=10150 $dt=16
M4525 VREF_N 176 368 VDD! pfet_01v8 L=1.5e-07 W=1.5e-06 $X=115270 $Y=18430 $dt=16
M4526 VREF_N 177 369 VDD! pfet_01v8 L=1.5e-07 W=1.5e-06 $X=115270 $Y=26710 $dt=16
M4527 VREF_N 178 370 VDD! pfet_01v8 L=1.5e-07 W=1.5e-06 $X=115270 $Y=34990 $dt=16
M4528 VREF_N 179 371 VDD! pfet_01v8 L=1.5e-07 W=1.5e-06 $X=115270 $Y=43270 $dt=16
M4529 VREF_N 180 372 VDD! pfet_01v8 L=1.5e-07 W=1.5e-06 $X=115270 $Y=51550 $dt=16
M4530 VREF_N 181 373 VDD! pfet_01v8 L=1.5e-07 W=1.5e-06 $X=115270 $Y=59830 $dt=16
M4531 VREF_N 182 374 VDD! pfet_01v8 L=1.5e-07 W=1.5e-06 $X=115270 $Y=68110 $dt=16
M4532 VREF_N 183 375 VDD! pfet_01v8 L=1.5e-07 W=1.5e-06 $X=115270 $Y=76390 $dt=16
M4533 VREF_N 186 376 VDD! pfet_01v8 L=1.5e-07 W=1.5e-06 $X=115270 $Y=101230 $dt=16
M4534 VREF_N 187 377 VDD! pfet_01v8 L=1.5e-07 W=1.5e-06 $X=115270 $Y=109510 $dt=16
M4535 VREF_N 188 378 VDD! pfet_01v8 L=1.5e-07 W=1.5e-06 $X=115270 $Y=117790 $dt=16
M4536 VREF_N 189 379 VDD! pfet_01v8 L=1.5e-07 W=1.5e-06 $X=115270 $Y=126070 $dt=16
M4537 VREF_N 190 380 VDD! pfet_01v8 L=1.5e-07 W=1.5e-06 $X=115270 $Y=134350 $dt=16
M4538 VREF_N 191 381 VDD! pfet_01v8 L=1.5e-07 W=1.5e-06 $X=115270 $Y=142630 $dt=16
M4539 VREF_N 192 382 VDD! pfet_01v8 L=1.5e-07 W=1.5e-06 $X=115270 $Y=150910 $dt=16
M4540 VREF_N 193 383 VDD! pfet_01v8 L=1.5e-07 W=1.5e-06 $X=115270 $Y=159190 $dt=16
M4541 353 213 VREF_P VDD! pfet_01v8 L=1.5e-07 W=1.5e-06 $X=116990 $Y=10150 $dt=16
M4542 354 214 VREF_P VDD! pfet_01v8 L=1.5e-07 W=1.5e-06 $X=116990 $Y=18430 $dt=16
M4543 355 215 VREF_P VDD! pfet_01v8 L=1.5e-07 W=1.5e-06 $X=116990 $Y=26710 $dt=16
M4544 356 216 VREF_P VDD! pfet_01v8 L=1.5e-07 W=1.5e-06 $X=116990 $Y=34990 $dt=16
M4545 357 217 VREF_P VDD! pfet_01v8 L=1.5e-07 W=1.5e-06 $X=116990 $Y=43270 $dt=16
M4546 358 218 VREF_P VDD! pfet_01v8 L=1.5e-07 W=1.5e-06 $X=116990 $Y=51550 $dt=16
M4547 359 219 VREF_P VDD! pfet_01v8 L=1.5e-07 W=1.5e-06 $X=116990 $Y=59830 $dt=16
M4548 VDD! VSS! VDD! VDD! pfet_01v8 L=5.8e-07 W=1.5e-06 $X=116990 $Y=68110 $dt=16
M4549 VDD! VSS! VDD! VDD! pfet_01v8 L=5.8e-07 W=1.5e-06 $X=116990 $Y=76390 $dt=16
M4550 VDD! VSS! VDD! VDD! pfet_01v8 L=5.8e-07 W=1.5e-06 $X=116990 $Y=84670 $dt=16
M4551 VDD! VSS! VDD! VDD! pfet_01v8 L=5.8e-07 W=1.5e-06 $X=116990 $Y=92950 $dt=16
M4552 VDD! VSS! VDD! VDD! pfet_01v8 L=5.8e-07 W=1.5e-06 $X=116990 $Y=101230 $dt=16
M4553 360 225 VREF_P VDD! pfet_01v8 L=1.5e-07 W=1.5e-06 $X=116990 $Y=109510 $dt=16
M4554 361 226 VREF_P VDD! pfet_01v8 L=1.5e-07 W=1.5e-06 $X=116990 $Y=117790 $dt=16
M4555 362 227 VREF_P VDD! pfet_01v8 L=1.5e-07 W=1.5e-06 $X=116990 $Y=126070 $dt=16
M4556 363 228 VREF_P VDD! pfet_01v8 L=1.5e-07 W=1.5e-06 $X=116990 $Y=134350 $dt=16
M4557 364 229 VREF_P VDD! pfet_01v8 L=1.5e-07 W=1.5e-06 $X=116990 $Y=142630 $dt=16
M4558 365 230 VREF_P VDD! pfet_01v8 L=1.5e-07 W=1.5e-06 $X=116990 $Y=150910 $dt=16
M4559 366 231 VREF_P VDD! pfet_01v8 L=1.5e-07 W=1.5e-06 $X=116990 $Y=159190 $dt=16
M4560 VIN 289 353 VDD! pfet_01v8 L=1.5e-07 W=1.5e-06 $X=117420 $Y=10150 $dt=16
M4561 VIN 290 354 VDD! pfet_01v8 L=1.5e-07 W=1.5e-06 $X=117420 $Y=18430 $dt=16
M4562 VIN 291 355 VDD! pfet_01v8 L=1.5e-07 W=1.5e-06 $X=117420 $Y=26710 $dt=16
M4563 VIN 292 356 VDD! pfet_01v8 L=1.5e-07 W=1.5e-06 $X=117420 $Y=34990 $dt=16
M4564 VIN 293 357 VDD! pfet_01v8 L=1.5e-07 W=1.5e-06 $X=117420 $Y=43270 $dt=16
M4565 VIN 294 358 VDD! pfet_01v8 L=1.5e-07 W=1.5e-06 $X=117420 $Y=51550 $dt=16
M4566 VIN 295 359 VDD! pfet_01v8 L=1.5e-07 W=1.5e-06 $X=117420 $Y=59830 $dt=16
M4567 VIN 301 360 VDD! pfet_01v8 L=1.5e-07 W=1.5e-06 $X=117420 $Y=109510 $dt=16
M4568 VIN 302 361 VDD! pfet_01v8 L=1.5e-07 W=1.5e-06 $X=117420 $Y=117790 $dt=16
M4569 VIN 303 362 VDD! pfet_01v8 L=1.5e-07 W=1.5e-06 $X=117420 $Y=126070 $dt=16
M4570 VIN 304 363 VDD! pfet_01v8 L=1.5e-07 W=1.5e-06 $X=117420 $Y=134350 $dt=16
M4571 VIN 305 364 VDD! pfet_01v8 L=1.5e-07 W=1.5e-06 $X=117420 $Y=142630 $dt=16
M4572 VIN 306 365 VDD! pfet_01v8 L=1.5e-07 W=1.5e-06 $X=117420 $Y=150910 $dt=16
M4573 VIN 307 366 VDD! pfet_01v8 L=1.5e-07 W=1.5e-06 $X=117420 $Y=159190 $dt=16
M4574 VDD! VSS! VDD! VDD! pfet_01v8 L=5.8e-07 W=1.5e-06 $X=123110 $Y=68110 $dt=16
M4575 VDD! VSS! VDD! VDD! pfet_01v8 L=5.8e-07 W=1.5e-06 $X=123110 $Y=76390 $dt=16
M4576 VDD! VSS! VDD! VDD! pfet_01v8 L=5.8e-07 W=1.5e-06 $X=123110 $Y=84670 $dt=16
M4577 VDD! VSS! VDD! VDD! pfet_01v8 L=5.8e-07 W=1.5e-06 $X=123110 $Y=92950 $dt=16
M4578 VDD! VSS! VDD! VDD! pfet_01v8 L=5.8e-07 W=1.5e-06 $X=123110 $Y=101230 $dt=16
M4579 353 270 353 VDD! pfet_01v8 L=1.5e-07 W=1.5e-06 $X=123120 $Y=10150 $dt=16
M4580 354 271 354 VDD! pfet_01v8 L=1.5e-07 W=1.5e-06 $X=123120 $Y=18430 $dt=16
M4581 355 272 355 VDD! pfet_01v8 L=1.5e-07 W=1.5e-06 $X=123120 $Y=26710 $dt=16
M4582 356 273 356 VDD! pfet_01v8 L=1.5e-07 W=1.5e-06 $X=123120 $Y=34990 $dt=16
M4583 357 274 357 VDD! pfet_01v8 L=1.5e-07 W=1.5e-06 $X=123120 $Y=43270 $dt=16
M4584 358 275 358 VDD! pfet_01v8 L=1.5e-07 W=1.5e-06 $X=123120 $Y=51550 $dt=16
M4585 359 276 359 VDD! pfet_01v8 L=1.5e-07 W=1.5e-06 $X=123120 $Y=59830 $dt=16
M4586 360 282 360 VDD! pfet_01v8 L=1.5e-07 W=1.5e-06 $X=123120 $Y=109510 $dt=16
M4587 361 283 361 VDD! pfet_01v8 L=1.5e-07 W=1.5e-06 $X=123120 $Y=117790 $dt=16
M4588 362 284 362 VDD! pfet_01v8 L=1.5e-07 W=1.5e-06 $X=123120 $Y=126070 $dt=16
M4589 363 285 363 VDD! pfet_01v8 L=1.5e-07 W=1.5e-06 $X=123120 $Y=134350 $dt=16
M4590 364 286 364 VDD! pfet_01v8 L=1.5e-07 W=1.5e-06 $X=123120 $Y=142630 $dt=16
M4591 365 287 365 VDD! pfet_01v8 L=1.5e-07 W=1.5e-06 $X=123120 $Y=150910 $dt=16
M4592 366 288 366 VDD! pfet_01v8 L=1.5e-07 W=1.5e-06 $X=123120 $Y=159190 $dt=16
M4593 VREF_N 175 353 VDD! pfet_01v8 L=1.5e-07 W=1.5e-06 $X=123550 $Y=10150 $dt=16
M4594 VREF_N 176 354 VDD! pfet_01v8 L=1.5e-07 W=1.5e-06 $X=123550 $Y=18430 $dt=16
M4595 VREF_N 177 355 VDD! pfet_01v8 L=1.5e-07 W=1.5e-06 $X=123550 $Y=26710 $dt=16
M4596 VREF_N 178 356 VDD! pfet_01v8 L=1.5e-07 W=1.5e-06 $X=123550 $Y=34990 $dt=16
M4597 VREF_N 179 357 VDD! pfet_01v8 L=1.5e-07 W=1.5e-06 $X=123550 $Y=43270 $dt=16
M4598 VREF_N 180 358 VDD! pfet_01v8 L=1.5e-07 W=1.5e-06 $X=123550 $Y=51550 $dt=16
M4599 VREF_N 181 359 VDD! pfet_01v8 L=1.5e-07 W=1.5e-06 $X=123550 $Y=59830 $dt=16
M4600 VREF_N 187 360 VDD! pfet_01v8 L=1.5e-07 W=1.5e-06 $X=123550 $Y=109510 $dt=16
M4601 VREF_N 188 361 VDD! pfet_01v8 L=1.5e-07 W=1.5e-06 $X=123550 $Y=117790 $dt=16
M4602 VREF_N 189 362 VDD! pfet_01v8 L=1.5e-07 W=1.5e-06 $X=123550 $Y=126070 $dt=16
M4603 VREF_N 190 363 VDD! pfet_01v8 L=1.5e-07 W=1.5e-06 $X=123550 $Y=134350 $dt=16
M4604 VREF_N 191 364 VDD! pfet_01v8 L=1.5e-07 W=1.5e-06 $X=123550 $Y=142630 $dt=16
M4605 VREF_N 192 365 VDD! pfet_01v8 L=1.5e-07 W=1.5e-06 $X=123550 $Y=150910 $dt=16
M4606 VREF_N 193 366 VDD! pfet_01v8 L=1.5e-07 W=1.5e-06 $X=123550 $Y=159190 $dt=16
M4607 339 213 VREF_P VDD! pfet_01v8 L=1.5e-07 W=1.5e-06 $X=125270 $Y=10150 $dt=16
M4608 340 214 VREF_P VDD! pfet_01v8 L=1.5e-07 W=1.5e-06 $X=125270 $Y=18430 $dt=16
M4609 341 215 VREF_P VDD! pfet_01v8 L=1.5e-07 W=1.5e-06 $X=125270 $Y=26710 $dt=16
M4610 342 216 VREF_P VDD! pfet_01v8 L=1.5e-07 W=1.5e-06 $X=125270 $Y=34990 $dt=16
M4611 343 217 VREF_P VDD! pfet_01v8 L=1.5e-07 W=1.5e-06 $X=125270 $Y=43270 $dt=16
M4612 344 218 VREF_P VDD! pfet_01v8 L=1.5e-07 W=1.5e-06 $X=125270 $Y=51550 $dt=16
M4613 345 219 VREF_P VDD! pfet_01v8 L=1.5e-07 W=1.5e-06 $X=125270 $Y=59830 $dt=16
M4614 VDD! VSS! VDD! VDD! pfet_01v8 L=5.8e-07 W=1.5e-06 $X=125270 $Y=68110 $dt=16
M4615 VDD! VSS! VDD! VDD! pfet_01v8 L=5.8e-07 W=1.5e-06 $X=125270 $Y=76390 $dt=16
M4616 VDD! VSS! VDD! VDD! pfet_01v8 L=5.8e-07 W=1.5e-06 $X=125270 $Y=84670 $dt=16
M4617 VDD! VSS! VDD! VDD! pfet_01v8 L=5.8e-07 W=1.5e-06 $X=125270 $Y=92950 $dt=16
M4618 VDD! VSS! VDD! VDD! pfet_01v8 L=5.8e-07 W=1.5e-06 $X=125270 $Y=101230 $dt=16
M4619 346 225 VREF_P VDD! pfet_01v8 L=1.5e-07 W=1.5e-06 $X=125270 $Y=109510 $dt=16
M4620 347 226 VREF_P VDD! pfet_01v8 L=1.5e-07 W=1.5e-06 $X=125270 $Y=117790 $dt=16
M4621 348 227 VREF_P VDD! pfet_01v8 L=1.5e-07 W=1.5e-06 $X=125270 $Y=126070 $dt=16
M4622 349 228 VREF_P VDD! pfet_01v8 L=1.5e-07 W=1.5e-06 $X=125270 $Y=134350 $dt=16
M4623 350 229 VREF_P VDD! pfet_01v8 L=1.5e-07 W=1.5e-06 $X=125270 $Y=142630 $dt=16
M4624 351 230 VREF_P VDD! pfet_01v8 L=1.5e-07 W=1.5e-06 $X=125270 $Y=150910 $dt=16
M4625 352 231 VREF_P VDD! pfet_01v8 L=1.5e-07 W=1.5e-06 $X=125270 $Y=159190 $dt=16
M4626 VIN 289 339 VDD! pfet_01v8 L=1.5e-07 W=1.5e-06 $X=125700 $Y=10150 $dt=16
M4627 VIN 290 340 VDD! pfet_01v8 L=1.5e-07 W=1.5e-06 $X=125700 $Y=18430 $dt=16
M4628 VIN 291 341 VDD! pfet_01v8 L=1.5e-07 W=1.5e-06 $X=125700 $Y=26710 $dt=16
M4629 VIN 292 342 VDD! pfet_01v8 L=1.5e-07 W=1.5e-06 $X=125700 $Y=34990 $dt=16
M4630 VIN 293 343 VDD! pfet_01v8 L=1.5e-07 W=1.5e-06 $X=125700 $Y=43270 $dt=16
M4631 VIN 294 344 VDD! pfet_01v8 L=1.5e-07 W=1.5e-06 $X=125700 $Y=51550 $dt=16
M4632 VIN 295 345 VDD! pfet_01v8 L=1.5e-07 W=1.5e-06 $X=125700 $Y=59830 $dt=16
M4633 VIN 301 346 VDD! pfet_01v8 L=1.5e-07 W=1.5e-06 $X=125700 $Y=109510 $dt=16
M4634 VIN 302 347 VDD! pfet_01v8 L=1.5e-07 W=1.5e-06 $X=125700 $Y=117790 $dt=16
M4635 VIN 303 348 VDD! pfet_01v8 L=1.5e-07 W=1.5e-06 $X=125700 $Y=126070 $dt=16
M4636 VIN 304 349 VDD! pfet_01v8 L=1.5e-07 W=1.5e-06 $X=125700 $Y=134350 $dt=16
M4637 VIN 305 350 VDD! pfet_01v8 L=1.5e-07 W=1.5e-06 $X=125700 $Y=142630 $dt=16
M4638 VIN 306 351 VDD! pfet_01v8 L=1.5e-07 W=1.5e-06 $X=125700 $Y=150910 $dt=16
M4639 VIN 307 352 VDD! pfet_01v8 L=1.5e-07 W=1.5e-06 $X=125700 $Y=159190 $dt=16
M4640 VDD! VSS! VDD! VDD! pfet_01v8 L=5.8e-07 W=1.5e-06 $X=131390 $Y=68110 $dt=16
M4641 VDD! VSS! VDD! VDD! pfet_01v8 L=5.8e-07 W=1.5e-06 $X=131390 $Y=76390 $dt=16
M4642 VDD! VSS! VDD! VDD! pfet_01v8 L=5.8e-07 W=1.5e-06 $X=131390 $Y=84670 $dt=16
M4643 VDD! VSS! VDD! VDD! pfet_01v8 L=5.8e-07 W=1.5e-06 $X=131390 $Y=92950 $dt=16
M4644 VDD! VSS! VDD! VDD! pfet_01v8 L=5.8e-07 W=1.5e-06 $X=131390 $Y=101230 $dt=16
M4645 339 270 339 VDD! pfet_01v8 L=1.5e-07 W=1.5e-06 $X=131400 $Y=10150 $dt=16
M4646 340 271 340 VDD! pfet_01v8 L=1.5e-07 W=1.5e-06 $X=131400 $Y=18430 $dt=16
M4647 341 272 341 VDD! pfet_01v8 L=1.5e-07 W=1.5e-06 $X=131400 $Y=26710 $dt=16
M4648 342 273 342 VDD! pfet_01v8 L=1.5e-07 W=1.5e-06 $X=131400 $Y=34990 $dt=16
M4649 343 274 343 VDD! pfet_01v8 L=1.5e-07 W=1.5e-06 $X=131400 $Y=43270 $dt=16
M4650 344 275 344 VDD! pfet_01v8 L=1.5e-07 W=1.5e-06 $X=131400 $Y=51550 $dt=16
M4651 345 276 345 VDD! pfet_01v8 L=1.5e-07 W=1.5e-06 $X=131400 $Y=59830 $dt=16
M4652 346 282 346 VDD! pfet_01v8 L=1.5e-07 W=1.5e-06 $X=131400 $Y=109510 $dt=16
M4653 347 283 347 VDD! pfet_01v8 L=1.5e-07 W=1.5e-06 $X=131400 $Y=117790 $dt=16
M4654 348 284 348 VDD! pfet_01v8 L=1.5e-07 W=1.5e-06 $X=131400 $Y=126070 $dt=16
M4655 349 285 349 VDD! pfet_01v8 L=1.5e-07 W=1.5e-06 $X=131400 $Y=134350 $dt=16
M4656 350 286 350 VDD! pfet_01v8 L=1.5e-07 W=1.5e-06 $X=131400 $Y=142630 $dt=16
M4657 351 287 351 VDD! pfet_01v8 L=1.5e-07 W=1.5e-06 $X=131400 $Y=150910 $dt=16
M4658 352 288 352 VDD! pfet_01v8 L=1.5e-07 W=1.5e-06 $X=131400 $Y=159190 $dt=16
M4659 VREF_N 175 339 VDD! pfet_01v8 L=1.5e-07 W=1.5e-06 $X=131830 $Y=10150 $dt=16
M4660 VREF_N 176 340 VDD! pfet_01v8 L=1.5e-07 W=1.5e-06 $X=131830 $Y=18430 $dt=16
M4661 VREF_N 177 341 VDD! pfet_01v8 L=1.5e-07 W=1.5e-06 $X=131830 $Y=26710 $dt=16
M4662 VREF_N 178 342 VDD! pfet_01v8 L=1.5e-07 W=1.5e-06 $X=131830 $Y=34990 $dt=16
M4663 VREF_N 179 343 VDD! pfet_01v8 L=1.5e-07 W=1.5e-06 $X=131830 $Y=43270 $dt=16
M4664 VREF_N 180 344 VDD! pfet_01v8 L=1.5e-07 W=1.5e-06 $X=131830 $Y=51550 $dt=16
M4665 VREF_N 181 345 VDD! pfet_01v8 L=1.5e-07 W=1.5e-06 $X=131830 $Y=59830 $dt=16
M4666 VREF_N 187 346 VDD! pfet_01v8 L=1.5e-07 W=1.5e-06 $X=131830 $Y=109510 $dt=16
M4667 VREF_N 188 347 VDD! pfet_01v8 L=1.5e-07 W=1.5e-06 $X=131830 $Y=117790 $dt=16
M4668 VREF_N 189 348 VDD! pfet_01v8 L=1.5e-07 W=1.5e-06 $X=131830 $Y=126070 $dt=16
M4669 VREF_N 190 349 VDD! pfet_01v8 L=1.5e-07 W=1.5e-06 $X=131830 $Y=134350 $dt=16
M4670 VREF_N 191 350 VDD! pfet_01v8 L=1.5e-07 W=1.5e-06 $X=131830 $Y=142630 $dt=16
M4671 VREF_N 192 351 VDD! pfet_01v8 L=1.5e-07 W=1.5e-06 $X=131830 $Y=150910 $dt=16
M4672 VREF_N 193 352 VDD! pfet_01v8 L=1.5e-07 W=1.5e-06 $X=131830 $Y=159190 $dt=16
M4673 325 213 VREF_P VDD! pfet_01v8 L=1.5e-07 W=1.5e-06 $X=133550 $Y=10150 $dt=16
M4674 326 214 VREF_P VDD! pfet_01v8 L=1.5e-07 W=1.5e-06 $X=133550 $Y=18430 $dt=16
M4675 327 215 VREF_P VDD! pfet_01v8 L=1.5e-07 W=1.5e-06 $X=133550 $Y=26710 $dt=16
M4676 328 216 VREF_P VDD! pfet_01v8 L=1.5e-07 W=1.5e-06 $X=133550 $Y=34990 $dt=16
M4677 329 217 VREF_P VDD! pfet_01v8 L=1.5e-07 W=1.5e-06 $X=133550 $Y=43270 $dt=16
M4678 330 218 VREF_P VDD! pfet_01v8 L=1.5e-07 W=1.5e-06 $X=133550 $Y=51550 $dt=16
M4679 331 219 VREF_P VDD! pfet_01v8 L=1.5e-07 W=1.5e-06 $X=133550 $Y=59830 $dt=16
M4680 VDD! VSS! VDD! VDD! pfet_01v8 L=5.8e-07 W=1.5e-06 $X=133550 $Y=68110 $dt=16
M4681 VDD! VSS! VDD! VDD! pfet_01v8 L=5.8e-07 W=1.5e-06 $X=133550 $Y=76390 $dt=16
M4682 VDD! VSS! VDD! VDD! pfet_01v8 L=5.8e-07 W=1.5e-06 $X=133550 $Y=84670 $dt=16
M4683 VDD! VSS! VDD! VDD! pfet_01v8 L=5.8e-07 W=1.5e-06 $X=133550 $Y=92950 $dt=16
M4684 VDD! VSS! VDD! VDD! pfet_01v8 L=5.8e-07 W=1.5e-06 $X=133550 $Y=101230 $dt=16
M4685 332 225 VREF_P VDD! pfet_01v8 L=1.5e-07 W=1.5e-06 $X=133550 $Y=109510 $dt=16
M4686 333 226 VREF_P VDD! pfet_01v8 L=1.5e-07 W=1.5e-06 $X=133550 $Y=117790 $dt=16
M4687 334 227 VREF_P VDD! pfet_01v8 L=1.5e-07 W=1.5e-06 $X=133550 $Y=126070 $dt=16
M4688 335 228 VREF_P VDD! pfet_01v8 L=1.5e-07 W=1.5e-06 $X=133550 $Y=134350 $dt=16
M4689 336 229 VREF_P VDD! pfet_01v8 L=1.5e-07 W=1.5e-06 $X=133550 $Y=142630 $dt=16
M4690 337 230 VREF_P VDD! pfet_01v8 L=1.5e-07 W=1.5e-06 $X=133550 $Y=150910 $dt=16
M4691 338 231 VREF_P VDD! pfet_01v8 L=1.5e-07 W=1.5e-06 $X=133550 $Y=159190 $dt=16
M4692 VIN 289 325 VDD! pfet_01v8 L=1.5e-07 W=1.5e-06 $X=133980 $Y=10150 $dt=16
M4693 VIN 290 326 VDD! pfet_01v8 L=1.5e-07 W=1.5e-06 $X=133980 $Y=18430 $dt=16
M4694 VIN 291 327 VDD! pfet_01v8 L=1.5e-07 W=1.5e-06 $X=133980 $Y=26710 $dt=16
M4695 VIN 292 328 VDD! pfet_01v8 L=1.5e-07 W=1.5e-06 $X=133980 $Y=34990 $dt=16
M4696 VIN 293 329 VDD! pfet_01v8 L=1.5e-07 W=1.5e-06 $X=133980 $Y=43270 $dt=16
M4697 VIN 294 330 VDD! pfet_01v8 L=1.5e-07 W=1.5e-06 $X=133980 $Y=51550 $dt=16
M4698 VIN 295 331 VDD! pfet_01v8 L=1.5e-07 W=1.5e-06 $X=133980 $Y=59830 $dt=16
M4699 VIN 301 332 VDD! pfet_01v8 L=1.5e-07 W=1.5e-06 $X=133980 $Y=109510 $dt=16
M4700 VIN 302 333 VDD! pfet_01v8 L=1.5e-07 W=1.5e-06 $X=133980 $Y=117790 $dt=16
M4701 VIN 303 334 VDD! pfet_01v8 L=1.5e-07 W=1.5e-06 $X=133980 $Y=126070 $dt=16
M4702 VIN 304 335 VDD! pfet_01v8 L=1.5e-07 W=1.5e-06 $X=133980 $Y=134350 $dt=16
M4703 VIN 305 336 VDD! pfet_01v8 L=1.5e-07 W=1.5e-06 $X=133980 $Y=142630 $dt=16
M4704 VIN 306 337 VDD! pfet_01v8 L=1.5e-07 W=1.5e-06 $X=133980 $Y=150910 $dt=16
M4705 VIN 307 338 VDD! pfet_01v8 L=1.5e-07 W=1.5e-06 $X=133980 $Y=159190 $dt=16
M4706 VDD! VSS! VDD! VDD! pfet_01v8 L=5.8e-07 W=1.5e-06 $X=139670 $Y=68110 $dt=16
M4707 VDD! VSS! VDD! VDD! pfet_01v8 L=5.8e-07 W=1.5e-06 $X=139670 $Y=76390 $dt=16
M4708 VDD! VSS! VDD! VDD! pfet_01v8 L=5.8e-07 W=1.5e-06 $X=139670 $Y=84670 $dt=16
M4709 VDD! VSS! VDD! VDD! pfet_01v8 L=5.8e-07 W=1.5e-06 $X=139670 $Y=92950 $dt=16
M4710 VDD! VSS! VDD! VDD! pfet_01v8 L=5.8e-07 W=1.5e-06 $X=139670 $Y=101230 $dt=16
M4711 325 270 325 VDD! pfet_01v8 L=1.5e-07 W=1.5e-06 $X=139680 $Y=10150 $dt=16
M4712 326 271 326 VDD! pfet_01v8 L=1.5e-07 W=1.5e-06 $X=139680 $Y=18430 $dt=16
M4713 327 272 327 VDD! pfet_01v8 L=1.5e-07 W=1.5e-06 $X=139680 $Y=26710 $dt=16
M4714 328 273 328 VDD! pfet_01v8 L=1.5e-07 W=1.5e-06 $X=139680 $Y=34990 $dt=16
M4715 329 274 329 VDD! pfet_01v8 L=1.5e-07 W=1.5e-06 $X=139680 $Y=43270 $dt=16
M4716 330 275 330 VDD! pfet_01v8 L=1.5e-07 W=1.5e-06 $X=139680 $Y=51550 $dt=16
M4717 331 276 331 VDD! pfet_01v8 L=1.5e-07 W=1.5e-06 $X=139680 $Y=59830 $dt=16
M4718 332 282 332 VDD! pfet_01v8 L=1.5e-07 W=1.5e-06 $X=139680 $Y=109510 $dt=16
M4719 333 283 333 VDD! pfet_01v8 L=1.5e-07 W=1.5e-06 $X=139680 $Y=117790 $dt=16
M4720 334 284 334 VDD! pfet_01v8 L=1.5e-07 W=1.5e-06 $X=139680 $Y=126070 $dt=16
M4721 335 285 335 VDD! pfet_01v8 L=1.5e-07 W=1.5e-06 $X=139680 $Y=134350 $dt=16
M4722 336 286 336 VDD! pfet_01v8 L=1.5e-07 W=1.5e-06 $X=139680 $Y=142630 $dt=16
M4723 337 287 337 VDD! pfet_01v8 L=1.5e-07 W=1.5e-06 $X=139680 $Y=150910 $dt=16
M4724 338 288 338 VDD! pfet_01v8 L=1.5e-07 W=1.5e-06 $X=139680 $Y=159190 $dt=16
M4725 VREF_N 175 325 VDD! pfet_01v8 L=1.5e-07 W=1.5e-06 $X=140110 $Y=10150 $dt=16
M4726 VREF_N 176 326 VDD! pfet_01v8 L=1.5e-07 W=1.5e-06 $X=140110 $Y=18430 $dt=16
M4727 VREF_N 177 327 VDD! pfet_01v8 L=1.5e-07 W=1.5e-06 $X=140110 $Y=26710 $dt=16
M4728 VREF_N 178 328 VDD! pfet_01v8 L=1.5e-07 W=1.5e-06 $X=140110 $Y=34990 $dt=16
M4729 VREF_N 179 329 VDD! pfet_01v8 L=1.5e-07 W=1.5e-06 $X=140110 $Y=43270 $dt=16
M4730 VREF_N 180 330 VDD! pfet_01v8 L=1.5e-07 W=1.5e-06 $X=140110 $Y=51550 $dt=16
M4731 VREF_N 181 331 VDD! pfet_01v8 L=1.5e-07 W=1.5e-06 $X=140110 $Y=59830 $dt=16
M4732 VREF_N 187 332 VDD! pfet_01v8 L=1.5e-07 W=1.5e-06 $X=140110 $Y=109510 $dt=16
M4733 VREF_N 188 333 VDD! pfet_01v8 L=1.5e-07 W=1.5e-06 $X=140110 $Y=117790 $dt=16
M4734 VREF_N 189 334 VDD! pfet_01v8 L=1.5e-07 W=1.5e-06 $X=140110 $Y=126070 $dt=16
M4735 VREF_N 190 335 VDD! pfet_01v8 L=1.5e-07 W=1.5e-06 $X=140110 $Y=134350 $dt=16
M4736 VREF_N 191 336 VDD! pfet_01v8 L=1.5e-07 W=1.5e-06 $X=140110 $Y=142630 $dt=16
M4737 VREF_N 192 337 VDD! pfet_01v8 L=1.5e-07 W=1.5e-06 $X=140110 $Y=150910 $dt=16
M4738 VREF_N 193 338 VDD! pfet_01v8 L=1.5e-07 W=1.5e-06 $X=140110 $Y=159190 $dt=16
M4739 310 213 VREF_P VDD! pfet_01v8 L=1.5e-07 W=1.5e-06 $X=141830 $Y=10150 $dt=16
M4740 311 214 VREF_P VDD! pfet_01v8 L=1.5e-07 W=1.5e-06 $X=141830 $Y=18430 $dt=16
M4741 312 215 VREF_P VDD! pfet_01v8 L=1.5e-07 W=1.5e-06 $X=141830 $Y=26710 $dt=16
M4742 313 216 VREF_P VDD! pfet_01v8 L=1.5e-07 W=1.5e-06 $X=141830 $Y=34990 $dt=16
M4743 314 217 VREF_P VDD! pfet_01v8 L=1.5e-07 W=1.5e-06 $X=141830 $Y=43270 $dt=16
M4744 315 218 VREF_P VDD! pfet_01v8 L=1.5e-07 W=1.5e-06 $X=141830 $Y=51550 $dt=16
M4745 316 219 VREF_P VDD! pfet_01v8 L=1.5e-07 W=1.5e-06 $X=141830 $Y=59830 $dt=16
M4746 VDD! VSS! VDD! VDD! pfet_01v8 L=5.8e-07 W=1.5e-06 $X=141830 $Y=68110 $dt=16
M4747 VDD! VSS! VDD! VDD! pfet_01v8 L=5.8e-07 W=1.5e-06 $X=141830 $Y=76390 $dt=16
M4748 VDD! VSS! VDD! VDD! pfet_01v8 L=5.8e-07 W=1.5e-06 $X=141830 $Y=84670 $dt=16
M4749 VDD! VSS! VDD! VDD! pfet_01v8 L=5.8e-07 W=1.5e-06 $X=141830 $Y=92950 $dt=16
M4750 VDD! VSS! VDD! VDD! pfet_01v8 L=5.8e-07 W=1.5e-06 $X=141830 $Y=101230 $dt=16
M4751 317 225 VREF_P VDD! pfet_01v8 L=1.5e-07 W=1.5e-06 $X=141830 $Y=109510 $dt=16
M4752 318 226 VREF_P VDD! pfet_01v8 L=1.5e-07 W=1.5e-06 $X=141830 $Y=117790 $dt=16
M4753 319 227 VREF_P VDD! pfet_01v8 L=1.5e-07 W=1.5e-06 $X=141830 $Y=126070 $dt=16
M4754 320 228 VREF_P VDD! pfet_01v8 L=1.5e-07 W=1.5e-06 $X=141830 $Y=134350 $dt=16
M4755 321 229 VREF_P VDD! pfet_01v8 L=1.5e-07 W=1.5e-06 $X=141830 $Y=142630 $dt=16
M4756 322 230 VREF_P VDD! pfet_01v8 L=1.5e-07 W=1.5e-06 $X=141830 $Y=150910 $dt=16
M4757 323 231 VREF_P VDD! pfet_01v8 L=1.5e-07 W=1.5e-06 $X=141830 $Y=159190 $dt=16
M4758 VIN 289 310 VDD! pfet_01v8 L=1.5e-07 W=1.5e-06 $X=142260 $Y=10150 $dt=16
M4759 VIN 290 311 VDD! pfet_01v8 L=1.5e-07 W=1.5e-06 $X=142260 $Y=18430 $dt=16
M4760 VIN 291 312 VDD! pfet_01v8 L=1.5e-07 W=1.5e-06 $X=142260 $Y=26710 $dt=16
M4761 VIN 292 313 VDD! pfet_01v8 L=1.5e-07 W=1.5e-06 $X=142260 $Y=34990 $dt=16
M4762 VIN 293 314 VDD! pfet_01v8 L=1.5e-07 W=1.5e-06 $X=142260 $Y=43270 $dt=16
M4763 VIN 294 315 VDD! pfet_01v8 L=1.5e-07 W=1.5e-06 $X=142260 $Y=51550 $dt=16
M4764 VIN 295 316 VDD! pfet_01v8 L=1.5e-07 W=1.5e-06 $X=142260 $Y=59830 $dt=16
M4765 VIN 301 317 VDD! pfet_01v8 L=1.5e-07 W=1.5e-06 $X=142260 $Y=109510 $dt=16
M4766 VIN 302 318 VDD! pfet_01v8 L=1.5e-07 W=1.5e-06 $X=142260 $Y=117790 $dt=16
M4767 VIN 303 319 VDD! pfet_01v8 L=1.5e-07 W=1.5e-06 $X=142260 $Y=126070 $dt=16
M4768 VIN 304 320 VDD! pfet_01v8 L=1.5e-07 W=1.5e-06 $X=142260 $Y=134350 $dt=16
M4769 VIN 305 321 VDD! pfet_01v8 L=1.5e-07 W=1.5e-06 $X=142260 $Y=142630 $dt=16
M4770 VIN 306 322 VDD! pfet_01v8 L=1.5e-07 W=1.5e-06 $X=142260 $Y=150910 $dt=16
M4771 VIN 307 323 VDD! pfet_01v8 L=1.5e-07 W=1.5e-06 $X=142260 $Y=159190 $dt=16
M4772 VDD! VSS! VDD! VDD! pfet_01v8 L=5.8e-07 W=1.5e-06 $X=147950 $Y=68110 $dt=16
M4773 VDD! VSS! VDD! VDD! pfet_01v8 L=5.8e-07 W=1.5e-06 $X=147950 $Y=76390 $dt=16
M4774 VDD! VSS! VDD! VDD! pfet_01v8 L=5.8e-07 W=1.5e-06 $X=147950 $Y=84670 $dt=16
M4775 VDD! VSS! VDD! VDD! pfet_01v8 L=5.8e-07 W=1.5e-06 $X=147950 $Y=92950 $dt=16
M4776 VDD! VSS! VDD! VDD! pfet_01v8 L=5.8e-07 W=1.5e-06 $X=147950 $Y=101230 $dt=16
M4777 310 270 310 VDD! pfet_01v8 L=1.5e-07 W=1.5e-06 $X=147960 $Y=10150 $dt=16
M4778 311 271 311 VDD! pfet_01v8 L=1.5e-07 W=1.5e-06 $X=147960 $Y=18430 $dt=16
M4779 312 272 312 VDD! pfet_01v8 L=1.5e-07 W=1.5e-06 $X=147960 $Y=26710 $dt=16
M4780 313 273 313 VDD! pfet_01v8 L=1.5e-07 W=1.5e-06 $X=147960 $Y=34990 $dt=16
M4781 314 274 314 VDD! pfet_01v8 L=1.5e-07 W=1.5e-06 $X=147960 $Y=43270 $dt=16
M4782 315 275 315 VDD! pfet_01v8 L=1.5e-07 W=1.5e-06 $X=147960 $Y=51550 $dt=16
M4783 316 276 316 VDD! pfet_01v8 L=1.5e-07 W=1.5e-06 $X=147960 $Y=59830 $dt=16
M4784 317 282 317 VDD! pfet_01v8 L=1.5e-07 W=1.5e-06 $X=147960 $Y=109510 $dt=16
M4785 318 283 318 VDD! pfet_01v8 L=1.5e-07 W=1.5e-06 $X=147960 $Y=117790 $dt=16
M4786 319 284 319 VDD! pfet_01v8 L=1.5e-07 W=1.5e-06 $X=147960 $Y=126070 $dt=16
M4787 320 285 320 VDD! pfet_01v8 L=1.5e-07 W=1.5e-06 $X=147960 $Y=134350 $dt=16
M4788 321 286 321 VDD! pfet_01v8 L=1.5e-07 W=1.5e-06 $X=147960 $Y=142630 $dt=16
M4789 322 287 322 VDD! pfet_01v8 L=1.5e-07 W=1.5e-06 $X=147960 $Y=150910 $dt=16
M4790 323 288 323 VDD! pfet_01v8 L=1.5e-07 W=1.5e-06 $X=147960 $Y=159190 $dt=16
M4791 VREF_N 175 310 VDD! pfet_01v8 L=1.5e-07 W=1.5e-06 $X=148390 $Y=10150 $dt=16
M4792 VREF_N 176 311 VDD! pfet_01v8 L=1.5e-07 W=1.5e-06 $X=148390 $Y=18430 $dt=16
M4793 VREF_N 177 312 VDD! pfet_01v8 L=1.5e-07 W=1.5e-06 $X=148390 $Y=26710 $dt=16
M4794 VREF_N 178 313 VDD! pfet_01v8 L=1.5e-07 W=1.5e-06 $X=148390 $Y=34990 $dt=16
M4795 VREF_N 179 314 VDD! pfet_01v8 L=1.5e-07 W=1.5e-06 $X=148390 $Y=43270 $dt=16
M4796 VREF_N 180 315 VDD! pfet_01v8 L=1.5e-07 W=1.5e-06 $X=148390 $Y=51550 $dt=16
M4797 VREF_N 181 316 VDD! pfet_01v8 L=1.5e-07 W=1.5e-06 $X=148390 $Y=59830 $dt=16
M4798 VREF_N 187 317 VDD! pfet_01v8 L=1.5e-07 W=1.5e-06 $X=148390 $Y=109510 $dt=16
M4799 VREF_N 188 318 VDD! pfet_01v8 L=1.5e-07 W=1.5e-06 $X=148390 $Y=117790 $dt=16
M4800 VREF_N 189 319 VDD! pfet_01v8 L=1.5e-07 W=1.5e-06 $X=148390 $Y=126070 $dt=16
M4801 VREF_N 190 320 VDD! pfet_01v8 L=1.5e-07 W=1.5e-06 $X=148390 $Y=134350 $dt=16
M4802 VREF_N 191 321 VDD! pfet_01v8 L=1.5e-07 W=1.5e-06 $X=148390 $Y=142630 $dt=16
M4803 VREF_N 192 322 VDD! pfet_01v8 L=1.5e-07 W=1.5e-06 $X=148390 $Y=150910 $dt=16
M4804 VREF_N 193 323 VDD! pfet_01v8 L=1.5e-07 W=1.5e-06 $X=148390 $Y=159190 $dt=16
M4805 289 118 VDD! VDD! pfet_01v8 L=1.5e-07 W=1.13e-06 $X=150530 $Y=8870 $dt=16
M4806 290 119 VDD! VDD! pfet_01v8 L=1.5e-07 W=1.13e-06 $X=150530 $Y=17150 $dt=16
M4807 291 120 VDD! VDD! pfet_01v8 L=1.5e-07 W=1.13e-06 $X=150530 $Y=25430 $dt=16
M4808 292 121 VDD! VDD! pfet_01v8 L=1.5e-07 W=1.13e-06 $X=150530 $Y=33710 $dt=16
M4809 293 122 VDD! VDD! pfet_01v8 L=1.5e-07 W=1.13e-06 $X=150530 $Y=41990 $dt=16
M4810 294 123 VDD! VDD! pfet_01v8 L=1.5e-07 W=1.13e-06 $X=150530 $Y=50270 $dt=16
M4811 295 124 VDD! VDD! pfet_01v8 L=1.5e-07 W=1.13e-06 $X=150530 $Y=58550 $dt=16
M4812 296 125 VDD! VDD! pfet_01v8 L=1.5e-07 W=1.13e-06 $X=150530 $Y=66830 $dt=16
M4813 297 126 VDD! VDD! pfet_01v8 L=1.5e-07 W=1.13e-06 $X=150530 $Y=75110 $dt=16
M4814 298 127 VDD! VDD! pfet_01v8 L=1.5e-07 W=1.13e-06 $X=150530 $Y=83390 $dt=16
M4815 299 128 VDD! VDD! pfet_01v8 L=1.5e-07 W=1.13e-06 $X=150530 $Y=91670 $dt=16
M4816 300 129 VDD! VDD! pfet_01v8 L=1.5e-07 W=1.13e-06 $X=150530 $Y=99950 $dt=16
M4817 301 130 VDD! VDD! pfet_01v8 L=1.5e-07 W=1.13e-06 $X=150530 $Y=108230 $dt=16
M4818 302 131 VDD! VDD! pfet_01v8 L=1.5e-07 W=1.13e-06 $X=150530 $Y=116510 $dt=16
M4819 303 132 VDD! VDD! pfet_01v8 L=1.5e-07 W=1.13e-06 $X=150530 $Y=124790 $dt=16
M4820 304 133 VDD! VDD! pfet_01v8 L=1.5e-07 W=1.13e-06 $X=150530 $Y=133070 $dt=16
M4821 305 134 VDD! VDD! pfet_01v8 L=1.5e-07 W=1.13e-06 $X=150530 $Y=141350 $dt=16
M4822 306 135 VDD! VDD! pfet_01v8 L=1.5e-07 W=1.13e-06 $X=150530 $Y=149630 $dt=16
M4823 307 136 VDD! VDD! pfet_01v8 L=1.5e-07 W=1.13e-06 $X=150530 $Y=157910 $dt=16
M4824 270 251 VDD! VDD! pfet_01v8 L=1.5e-07 W=1.13e-06 $X=150590 $Y=14840 $dt=16
M4825 271 252 VDD! VDD! pfet_01v8 L=1.5e-07 W=1.13e-06 $X=150590 $Y=23120 $dt=16
M4826 272 253 VDD! VDD! pfet_01v8 L=1.5e-07 W=1.13e-06 $X=150590 $Y=31400 $dt=16
M4827 273 254 VDD! VDD! pfet_01v8 L=1.5e-07 W=1.13e-06 $X=150590 $Y=39680 $dt=16
M4828 274 255 VDD! VDD! pfet_01v8 L=1.5e-07 W=1.13e-06 $X=150590 $Y=47960 $dt=16
M4829 275 256 VDD! VDD! pfet_01v8 L=1.5e-07 W=1.13e-06 $X=150590 $Y=56240 $dt=16
M4830 276 257 VDD! VDD! pfet_01v8 L=1.5e-07 W=1.13e-06 $X=150590 $Y=64520 $dt=16
M4831 277 258 VDD! VDD! pfet_01v8 L=1.5e-07 W=1.13e-06 $X=150590 $Y=72800 $dt=16
M4832 278 259 VDD! VDD! pfet_01v8 L=1.5e-07 W=1.13e-06 $X=150590 $Y=81080 $dt=16
M4833 279 260 VDD! VDD! pfet_01v8 L=1.5e-07 W=1.13e-06 $X=150590 $Y=89360 $dt=16
M4834 280 261 VDD! VDD! pfet_01v8 L=1.5e-07 W=1.13e-06 $X=150590 $Y=97640 $dt=16
M4835 281 262 VDD! VDD! pfet_01v8 L=1.5e-07 W=1.13e-06 $X=150590 $Y=105920 $dt=16
M4836 282 263 VDD! VDD! pfet_01v8 L=1.5e-07 W=1.13e-06 $X=150590 $Y=114200 $dt=16
M4837 283 264 VDD! VDD! pfet_01v8 L=1.5e-07 W=1.13e-06 $X=150590 $Y=122480 $dt=16
M4838 284 265 VDD! VDD! pfet_01v8 L=1.5e-07 W=1.13e-06 $X=150590 $Y=130760 $dt=16
M4839 285 266 VDD! VDD! pfet_01v8 L=1.5e-07 W=1.13e-06 $X=150590 $Y=139040 $dt=16
M4840 286 267 VDD! VDD! pfet_01v8 L=1.5e-07 W=1.13e-06 $X=150590 $Y=147320 $dt=16
M4841 287 268 VDD! VDD! pfet_01v8 L=1.5e-07 W=1.13e-06 $X=150590 $Y=155600 $dt=16
M4842 288 269 VDD! VDD! pfet_01v8 L=1.5e-07 W=1.13e-06 $X=150590 $Y=163880 $dt=16
M4843 VDD! 118 289 VDD! pfet_01v8 L=1.5e-07 W=1.13e-06 $X=150960 $Y=8870 $dt=16
M4844 VDD! 119 290 VDD! pfet_01v8 L=1.5e-07 W=1.13e-06 $X=150960 $Y=17150 $dt=16
M4845 VDD! 120 291 VDD! pfet_01v8 L=1.5e-07 W=1.13e-06 $X=150960 $Y=25430 $dt=16
M4846 VDD! 121 292 VDD! pfet_01v8 L=1.5e-07 W=1.13e-06 $X=150960 $Y=33710 $dt=16
M4847 VDD! 122 293 VDD! pfet_01v8 L=1.5e-07 W=1.13e-06 $X=150960 $Y=41990 $dt=16
M4848 VDD! 123 294 VDD! pfet_01v8 L=1.5e-07 W=1.13e-06 $X=150960 $Y=50270 $dt=16
M4849 VDD! 124 295 VDD! pfet_01v8 L=1.5e-07 W=1.13e-06 $X=150960 $Y=58550 $dt=16
M4850 VDD! 125 296 VDD! pfet_01v8 L=1.5e-07 W=1.13e-06 $X=150960 $Y=66830 $dt=16
M4851 VDD! 126 297 VDD! pfet_01v8 L=1.5e-07 W=1.13e-06 $X=150960 $Y=75110 $dt=16
M4852 VDD! 127 298 VDD! pfet_01v8 L=1.5e-07 W=1.13e-06 $X=150960 $Y=83390 $dt=16
M4853 VDD! 128 299 VDD! pfet_01v8 L=1.5e-07 W=1.13e-06 $X=150960 $Y=91670 $dt=16
M4854 VDD! 129 300 VDD! pfet_01v8 L=1.5e-07 W=1.13e-06 $X=150960 $Y=99950 $dt=16
M4855 VDD! 130 301 VDD! pfet_01v8 L=1.5e-07 W=1.13e-06 $X=150960 $Y=108230 $dt=16
M4856 VDD! 131 302 VDD! pfet_01v8 L=1.5e-07 W=1.13e-06 $X=150960 $Y=116510 $dt=16
M4857 VDD! 132 303 VDD! pfet_01v8 L=1.5e-07 W=1.13e-06 $X=150960 $Y=124790 $dt=16
M4858 VDD! 133 304 VDD! pfet_01v8 L=1.5e-07 W=1.13e-06 $X=150960 $Y=133070 $dt=16
M4859 VDD! 134 305 VDD! pfet_01v8 L=1.5e-07 W=1.13e-06 $X=150960 $Y=141350 $dt=16
M4860 VDD! 135 306 VDD! pfet_01v8 L=1.5e-07 W=1.13e-06 $X=150960 $Y=149630 $dt=16
M4861 VDD! 136 307 VDD! pfet_01v8 L=1.5e-07 W=1.13e-06 $X=150960 $Y=157910 $dt=16
M4862 VDD! 251 270 VDD! pfet_01v8 L=1.5e-07 W=1.13e-06 $X=151020 $Y=14840 $dt=16
M4863 VDD! 252 271 VDD! pfet_01v8 L=1.5e-07 W=1.13e-06 $X=151020 $Y=23120 $dt=16
M4864 VDD! 253 272 VDD! pfet_01v8 L=1.5e-07 W=1.13e-06 $X=151020 $Y=31400 $dt=16
M4865 VDD! 254 273 VDD! pfet_01v8 L=1.5e-07 W=1.13e-06 $X=151020 $Y=39680 $dt=16
M4866 VDD! 255 274 VDD! pfet_01v8 L=1.5e-07 W=1.13e-06 $X=151020 $Y=47960 $dt=16
M4867 VDD! 256 275 VDD! pfet_01v8 L=1.5e-07 W=1.13e-06 $X=151020 $Y=56240 $dt=16
M4868 VDD! 257 276 VDD! pfet_01v8 L=1.5e-07 W=1.13e-06 $X=151020 $Y=64520 $dt=16
M4869 VDD! 258 277 VDD! pfet_01v8 L=1.5e-07 W=1.13e-06 $X=151020 $Y=72800 $dt=16
M4870 VDD! 259 278 VDD! pfet_01v8 L=1.5e-07 W=1.13e-06 $X=151020 $Y=81080 $dt=16
M4871 VDD! 260 279 VDD! pfet_01v8 L=1.5e-07 W=1.13e-06 $X=151020 $Y=89360 $dt=16
M4872 VDD! 261 280 VDD! pfet_01v8 L=1.5e-07 W=1.13e-06 $X=151020 $Y=97640 $dt=16
M4873 VDD! 262 281 VDD! pfet_01v8 L=1.5e-07 W=1.13e-06 $X=151020 $Y=105920 $dt=16
M4874 VDD! 263 282 VDD! pfet_01v8 L=1.5e-07 W=1.13e-06 $X=151020 $Y=114200 $dt=16
M4875 VDD! 264 283 VDD! pfet_01v8 L=1.5e-07 W=1.13e-06 $X=151020 $Y=122480 $dt=16
M4876 VDD! 265 284 VDD! pfet_01v8 L=1.5e-07 W=1.13e-06 $X=151020 $Y=130760 $dt=16
M4877 VDD! 266 285 VDD! pfet_01v8 L=1.5e-07 W=1.13e-06 $X=151020 $Y=139040 $dt=16
M4878 VDD! 267 286 VDD! pfet_01v8 L=1.5e-07 W=1.13e-06 $X=151020 $Y=147320 $dt=16
M4879 VDD! 268 287 VDD! pfet_01v8 L=1.5e-07 W=1.13e-06 $X=151020 $Y=155600 $dt=16
M4880 VDD! 269 288 VDD! pfet_01v8 L=1.5e-07 W=1.13e-06 $X=151020 $Y=163880 $dt=16
M4881 289 118 VDD! VDD! pfet_01v8 L=1.5e-07 W=1.13e-06 $X=151390 $Y=8870 $dt=16
M4882 290 119 VDD! VDD! pfet_01v8 L=1.5e-07 W=1.13e-06 $X=151390 $Y=17150 $dt=16
M4883 291 120 VDD! VDD! pfet_01v8 L=1.5e-07 W=1.13e-06 $X=151390 $Y=25430 $dt=16
M4884 292 121 VDD! VDD! pfet_01v8 L=1.5e-07 W=1.13e-06 $X=151390 $Y=33710 $dt=16
M4885 293 122 VDD! VDD! pfet_01v8 L=1.5e-07 W=1.13e-06 $X=151390 $Y=41990 $dt=16
M4886 294 123 VDD! VDD! pfet_01v8 L=1.5e-07 W=1.13e-06 $X=151390 $Y=50270 $dt=16
M4887 295 124 VDD! VDD! pfet_01v8 L=1.5e-07 W=1.13e-06 $X=151390 $Y=58550 $dt=16
M4888 296 125 VDD! VDD! pfet_01v8 L=1.5e-07 W=1.13e-06 $X=151390 $Y=66830 $dt=16
M4889 297 126 VDD! VDD! pfet_01v8 L=1.5e-07 W=1.13e-06 $X=151390 $Y=75110 $dt=16
M4890 298 127 VDD! VDD! pfet_01v8 L=1.5e-07 W=1.13e-06 $X=151390 $Y=83390 $dt=16
M4891 299 128 VDD! VDD! pfet_01v8 L=1.5e-07 W=1.13e-06 $X=151390 $Y=91670 $dt=16
M4892 300 129 VDD! VDD! pfet_01v8 L=1.5e-07 W=1.13e-06 $X=151390 $Y=99950 $dt=16
M4893 301 130 VDD! VDD! pfet_01v8 L=1.5e-07 W=1.13e-06 $X=151390 $Y=108230 $dt=16
M4894 302 131 VDD! VDD! pfet_01v8 L=1.5e-07 W=1.13e-06 $X=151390 $Y=116510 $dt=16
M4895 303 132 VDD! VDD! pfet_01v8 L=1.5e-07 W=1.13e-06 $X=151390 $Y=124790 $dt=16
M4896 304 133 VDD! VDD! pfet_01v8 L=1.5e-07 W=1.13e-06 $X=151390 $Y=133070 $dt=16
M4897 305 134 VDD! VDD! pfet_01v8 L=1.5e-07 W=1.13e-06 $X=151390 $Y=141350 $dt=16
M4898 306 135 VDD! VDD! pfet_01v8 L=1.5e-07 W=1.13e-06 $X=151390 $Y=149630 $dt=16
M4899 307 136 VDD! VDD! pfet_01v8 L=1.5e-07 W=1.13e-06 $X=151390 $Y=157910 $dt=16
M4900 270 251 VDD! VDD! pfet_01v8 L=1.5e-07 W=1.13e-06 $X=151450 $Y=14840 $dt=16
M4901 271 252 VDD! VDD! pfet_01v8 L=1.5e-07 W=1.13e-06 $X=151450 $Y=23120 $dt=16
M4902 272 253 VDD! VDD! pfet_01v8 L=1.5e-07 W=1.13e-06 $X=151450 $Y=31400 $dt=16
M4903 273 254 VDD! VDD! pfet_01v8 L=1.5e-07 W=1.13e-06 $X=151450 $Y=39680 $dt=16
M4904 274 255 VDD! VDD! pfet_01v8 L=1.5e-07 W=1.13e-06 $X=151450 $Y=47960 $dt=16
M4905 275 256 VDD! VDD! pfet_01v8 L=1.5e-07 W=1.13e-06 $X=151450 $Y=56240 $dt=16
M4906 276 257 VDD! VDD! pfet_01v8 L=1.5e-07 W=1.13e-06 $X=151450 $Y=64520 $dt=16
M4907 277 258 VDD! VDD! pfet_01v8 L=1.5e-07 W=1.13e-06 $X=151450 $Y=72800 $dt=16
M4908 278 259 VDD! VDD! pfet_01v8 L=1.5e-07 W=1.13e-06 $X=151450 $Y=81080 $dt=16
M4909 279 260 VDD! VDD! pfet_01v8 L=1.5e-07 W=1.13e-06 $X=151450 $Y=89360 $dt=16
M4910 280 261 VDD! VDD! pfet_01v8 L=1.5e-07 W=1.13e-06 $X=151450 $Y=97640 $dt=16
M4911 281 262 VDD! VDD! pfet_01v8 L=1.5e-07 W=1.13e-06 $X=151450 $Y=105920 $dt=16
M4912 282 263 VDD! VDD! pfet_01v8 L=1.5e-07 W=1.13e-06 $X=151450 $Y=114200 $dt=16
M4913 283 264 VDD! VDD! pfet_01v8 L=1.5e-07 W=1.13e-06 $X=151450 $Y=122480 $dt=16
M4914 284 265 VDD! VDD! pfet_01v8 L=1.5e-07 W=1.13e-06 $X=151450 $Y=130760 $dt=16
M4915 285 266 VDD! VDD! pfet_01v8 L=1.5e-07 W=1.13e-06 $X=151450 $Y=139040 $dt=16
M4916 286 267 VDD! VDD! pfet_01v8 L=1.5e-07 W=1.13e-06 $X=151450 $Y=147320 $dt=16
M4917 287 268 VDD! VDD! pfet_01v8 L=1.5e-07 W=1.13e-06 $X=151450 $Y=155600 $dt=16
M4918 288 269 VDD! VDD! pfet_01v8 L=1.5e-07 W=1.13e-06 $X=151450 $Y=163880 $dt=16
M4919 VDD! 118 289 VDD! pfet_01v8 L=1.5e-07 W=1.13e-06 $X=151820 $Y=8870 $dt=16
M4920 VDD! 119 290 VDD! pfet_01v8 L=1.5e-07 W=1.13e-06 $X=151820 $Y=17150 $dt=16
M4921 VDD! 120 291 VDD! pfet_01v8 L=1.5e-07 W=1.13e-06 $X=151820 $Y=25430 $dt=16
M4922 VDD! 121 292 VDD! pfet_01v8 L=1.5e-07 W=1.13e-06 $X=151820 $Y=33710 $dt=16
M4923 VDD! 122 293 VDD! pfet_01v8 L=1.5e-07 W=1.13e-06 $X=151820 $Y=41990 $dt=16
M4924 VDD! 123 294 VDD! pfet_01v8 L=1.5e-07 W=1.13e-06 $X=151820 $Y=50270 $dt=16
M4925 VDD! 124 295 VDD! pfet_01v8 L=1.5e-07 W=1.13e-06 $X=151820 $Y=58550 $dt=16
M4926 VDD! 125 296 VDD! pfet_01v8 L=1.5e-07 W=1.13e-06 $X=151820 $Y=66830 $dt=16
M4927 VDD! 126 297 VDD! pfet_01v8 L=1.5e-07 W=1.13e-06 $X=151820 $Y=75110 $dt=16
M4928 VDD! 127 298 VDD! pfet_01v8 L=1.5e-07 W=1.13e-06 $X=151820 $Y=83390 $dt=16
M4929 VDD! 128 299 VDD! pfet_01v8 L=1.5e-07 W=1.13e-06 $X=151820 $Y=91670 $dt=16
M4930 VDD! 129 300 VDD! pfet_01v8 L=1.5e-07 W=1.13e-06 $X=151820 $Y=99950 $dt=16
M4931 VDD! 130 301 VDD! pfet_01v8 L=1.5e-07 W=1.13e-06 $X=151820 $Y=108230 $dt=16
M4932 VDD! 131 302 VDD! pfet_01v8 L=1.5e-07 W=1.13e-06 $X=151820 $Y=116510 $dt=16
M4933 VDD! 132 303 VDD! pfet_01v8 L=1.5e-07 W=1.13e-06 $X=151820 $Y=124790 $dt=16
M4934 VDD! 133 304 VDD! pfet_01v8 L=1.5e-07 W=1.13e-06 $X=151820 $Y=133070 $dt=16
M4935 VDD! 134 305 VDD! pfet_01v8 L=1.5e-07 W=1.13e-06 $X=151820 $Y=141350 $dt=16
M4936 VDD! 135 306 VDD! pfet_01v8 L=1.5e-07 W=1.13e-06 $X=151820 $Y=149630 $dt=16
M4937 VDD! 136 307 VDD! pfet_01v8 L=1.5e-07 W=1.13e-06 $X=151820 $Y=157910 $dt=16
M4938 VDD! 251 270 VDD! pfet_01v8 L=1.5e-07 W=1.13e-06 $X=151880 $Y=14840 $dt=16
M4939 VDD! 252 271 VDD! pfet_01v8 L=1.5e-07 W=1.13e-06 $X=151880 $Y=23120 $dt=16
M4940 VDD! 253 272 VDD! pfet_01v8 L=1.5e-07 W=1.13e-06 $X=151880 $Y=31400 $dt=16
M4941 VDD! 254 273 VDD! pfet_01v8 L=1.5e-07 W=1.13e-06 $X=151880 $Y=39680 $dt=16
M4942 VDD! 255 274 VDD! pfet_01v8 L=1.5e-07 W=1.13e-06 $X=151880 $Y=47960 $dt=16
M4943 VDD! 256 275 VDD! pfet_01v8 L=1.5e-07 W=1.13e-06 $X=151880 $Y=56240 $dt=16
M4944 VDD! 257 276 VDD! pfet_01v8 L=1.5e-07 W=1.13e-06 $X=151880 $Y=64520 $dt=16
M4945 VDD! 258 277 VDD! pfet_01v8 L=1.5e-07 W=1.13e-06 $X=151880 $Y=72800 $dt=16
M4946 VDD! 259 278 VDD! pfet_01v8 L=1.5e-07 W=1.13e-06 $X=151880 $Y=81080 $dt=16
M4947 VDD! 260 279 VDD! pfet_01v8 L=1.5e-07 W=1.13e-06 $X=151880 $Y=89360 $dt=16
M4948 VDD! 261 280 VDD! pfet_01v8 L=1.5e-07 W=1.13e-06 $X=151880 $Y=97640 $dt=16
M4949 VDD! 262 281 VDD! pfet_01v8 L=1.5e-07 W=1.13e-06 $X=151880 $Y=105920 $dt=16
M4950 VDD! 263 282 VDD! pfet_01v8 L=1.5e-07 W=1.13e-06 $X=151880 $Y=114200 $dt=16
M4951 VDD! 264 283 VDD! pfet_01v8 L=1.5e-07 W=1.13e-06 $X=151880 $Y=122480 $dt=16
M4952 VDD! 265 284 VDD! pfet_01v8 L=1.5e-07 W=1.13e-06 $X=151880 $Y=130760 $dt=16
M4953 VDD! 266 285 VDD! pfet_01v8 L=1.5e-07 W=1.13e-06 $X=151880 $Y=139040 $dt=16
M4954 VDD! 267 286 VDD! pfet_01v8 L=1.5e-07 W=1.13e-06 $X=151880 $Y=147320 $dt=16
M4955 VDD! 268 287 VDD! pfet_01v8 L=1.5e-07 W=1.13e-06 $X=151880 $Y=155600 $dt=16
M4956 VDD! 269 288 VDD! pfet_01v8 L=1.5e-07 W=1.13e-06 $X=151880 $Y=163880 $dt=16
M4957 289 118 VDD! VDD! pfet_01v8 L=1.5e-07 W=1.13e-06 $X=152250 $Y=8870 $dt=16
M4958 290 119 VDD! VDD! pfet_01v8 L=1.5e-07 W=1.13e-06 $X=152250 $Y=17150 $dt=16
M4959 291 120 VDD! VDD! pfet_01v8 L=1.5e-07 W=1.13e-06 $X=152250 $Y=25430 $dt=16
M4960 292 121 VDD! VDD! pfet_01v8 L=1.5e-07 W=1.13e-06 $X=152250 $Y=33710 $dt=16
M4961 293 122 VDD! VDD! pfet_01v8 L=1.5e-07 W=1.13e-06 $X=152250 $Y=41990 $dt=16
M4962 294 123 VDD! VDD! pfet_01v8 L=1.5e-07 W=1.13e-06 $X=152250 $Y=50270 $dt=16
M4963 295 124 VDD! VDD! pfet_01v8 L=1.5e-07 W=1.13e-06 $X=152250 $Y=58550 $dt=16
M4964 296 125 VDD! VDD! pfet_01v8 L=1.5e-07 W=1.13e-06 $X=152250 $Y=66830 $dt=16
M4965 297 126 VDD! VDD! pfet_01v8 L=1.5e-07 W=1.13e-06 $X=152250 $Y=75110 $dt=16
M4966 298 127 VDD! VDD! pfet_01v8 L=1.5e-07 W=1.13e-06 $X=152250 $Y=83390 $dt=16
M4967 299 128 VDD! VDD! pfet_01v8 L=1.5e-07 W=1.13e-06 $X=152250 $Y=91670 $dt=16
M4968 300 129 VDD! VDD! pfet_01v8 L=1.5e-07 W=1.13e-06 $X=152250 $Y=99950 $dt=16
M4969 301 130 VDD! VDD! pfet_01v8 L=1.5e-07 W=1.13e-06 $X=152250 $Y=108230 $dt=16
M4970 302 131 VDD! VDD! pfet_01v8 L=1.5e-07 W=1.13e-06 $X=152250 $Y=116510 $dt=16
M4971 303 132 VDD! VDD! pfet_01v8 L=1.5e-07 W=1.13e-06 $X=152250 $Y=124790 $dt=16
M4972 304 133 VDD! VDD! pfet_01v8 L=1.5e-07 W=1.13e-06 $X=152250 $Y=133070 $dt=16
M4973 305 134 VDD! VDD! pfet_01v8 L=1.5e-07 W=1.13e-06 $X=152250 $Y=141350 $dt=16
M4974 306 135 VDD! VDD! pfet_01v8 L=1.5e-07 W=1.13e-06 $X=152250 $Y=149630 $dt=16
M4975 307 136 VDD! VDD! pfet_01v8 L=1.5e-07 W=1.13e-06 $X=152250 $Y=157910 $dt=16
M4976 270 251 VDD! VDD! pfet_01v8 L=1.5e-07 W=1.13e-06 $X=152310 $Y=14840 $dt=16
M4977 271 252 VDD! VDD! pfet_01v8 L=1.5e-07 W=1.13e-06 $X=152310 $Y=23120 $dt=16
M4978 272 253 VDD! VDD! pfet_01v8 L=1.5e-07 W=1.13e-06 $X=152310 $Y=31400 $dt=16
M4979 273 254 VDD! VDD! pfet_01v8 L=1.5e-07 W=1.13e-06 $X=152310 $Y=39680 $dt=16
M4980 274 255 VDD! VDD! pfet_01v8 L=1.5e-07 W=1.13e-06 $X=152310 $Y=47960 $dt=16
M4981 275 256 VDD! VDD! pfet_01v8 L=1.5e-07 W=1.13e-06 $X=152310 $Y=56240 $dt=16
M4982 276 257 VDD! VDD! pfet_01v8 L=1.5e-07 W=1.13e-06 $X=152310 $Y=64520 $dt=16
M4983 277 258 VDD! VDD! pfet_01v8 L=1.5e-07 W=1.13e-06 $X=152310 $Y=72800 $dt=16
M4984 278 259 VDD! VDD! pfet_01v8 L=1.5e-07 W=1.13e-06 $X=152310 $Y=81080 $dt=16
M4985 279 260 VDD! VDD! pfet_01v8 L=1.5e-07 W=1.13e-06 $X=152310 $Y=89360 $dt=16
M4986 280 261 VDD! VDD! pfet_01v8 L=1.5e-07 W=1.13e-06 $X=152310 $Y=97640 $dt=16
M4987 281 262 VDD! VDD! pfet_01v8 L=1.5e-07 W=1.13e-06 $X=152310 $Y=105920 $dt=16
M4988 282 263 VDD! VDD! pfet_01v8 L=1.5e-07 W=1.13e-06 $X=152310 $Y=114200 $dt=16
M4989 283 264 VDD! VDD! pfet_01v8 L=1.5e-07 W=1.13e-06 $X=152310 $Y=122480 $dt=16
M4990 284 265 VDD! VDD! pfet_01v8 L=1.5e-07 W=1.13e-06 $X=152310 $Y=130760 $dt=16
M4991 285 266 VDD! VDD! pfet_01v8 L=1.5e-07 W=1.13e-06 $X=152310 $Y=139040 $dt=16
M4992 286 267 VDD! VDD! pfet_01v8 L=1.5e-07 W=1.13e-06 $X=152310 $Y=147320 $dt=16
M4993 287 268 VDD! VDD! pfet_01v8 L=1.5e-07 W=1.13e-06 $X=152310 $Y=155600 $dt=16
M4994 288 269 VDD! VDD! pfet_01v8 L=1.5e-07 W=1.13e-06 $X=152310 $Y=163880 $dt=16
M4995 VDD! 118 289 VDD! pfet_01v8 L=1.5e-07 W=1.13e-06 $X=152680 $Y=8870 $dt=16
M4996 VDD! 119 290 VDD! pfet_01v8 L=1.5e-07 W=1.13e-06 $X=152680 $Y=17150 $dt=16
M4997 VDD! 120 291 VDD! pfet_01v8 L=1.5e-07 W=1.13e-06 $X=152680 $Y=25430 $dt=16
M4998 VDD! 121 292 VDD! pfet_01v8 L=1.5e-07 W=1.13e-06 $X=152680 $Y=33710 $dt=16
M4999 VDD! 122 293 VDD! pfet_01v8 L=1.5e-07 W=1.13e-06 $X=152680 $Y=41990 $dt=16
M5000 VDD! 123 294 VDD! pfet_01v8 L=1.5e-07 W=1.13e-06 $X=152680 $Y=50270 $dt=16
M5001 VDD! 124 295 VDD! pfet_01v8 L=1.5e-07 W=1.13e-06 $X=152680 $Y=58550 $dt=16
M5002 VDD! 125 296 VDD! pfet_01v8 L=1.5e-07 W=1.13e-06 $X=152680 $Y=66830 $dt=16
M5003 VDD! 126 297 VDD! pfet_01v8 L=1.5e-07 W=1.13e-06 $X=152680 $Y=75110 $dt=16
M5004 VDD! 127 298 VDD! pfet_01v8 L=1.5e-07 W=1.13e-06 $X=152680 $Y=83390 $dt=16
M5005 VDD! 128 299 VDD! pfet_01v8 L=1.5e-07 W=1.13e-06 $X=152680 $Y=91670 $dt=16
M5006 VDD! 129 300 VDD! pfet_01v8 L=1.5e-07 W=1.13e-06 $X=152680 $Y=99950 $dt=16
M5007 VDD! 130 301 VDD! pfet_01v8 L=1.5e-07 W=1.13e-06 $X=152680 $Y=108230 $dt=16
M5008 VDD! 131 302 VDD! pfet_01v8 L=1.5e-07 W=1.13e-06 $X=152680 $Y=116510 $dt=16
M5009 VDD! 132 303 VDD! pfet_01v8 L=1.5e-07 W=1.13e-06 $X=152680 $Y=124790 $dt=16
M5010 VDD! 133 304 VDD! pfet_01v8 L=1.5e-07 W=1.13e-06 $X=152680 $Y=133070 $dt=16
M5011 VDD! 134 305 VDD! pfet_01v8 L=1.5e-07 W=1.13e-06 $X=152680 $Y=141350 $dt=16
M5012 VDD! 135 306 VDD! pfet_01v8 L=1.5e-07 W=1.13e-06 $X=152680 $Y=149630 $dt=16
M5013 VDD! 136 307 VDD! pfet_01v8 L=1.5e-07 W=1.13e-06 $X=152680 $Y=157910 $dt=16
M5014 VDD! 251 270 VDD! pfet_01v8 L=1.5e-07 W=1.13e-06 $X=152740 $Y=14840 $dt=16
M5015 VDD! 252 271 VDD! pfet_01v8 L=1.5e-07 W=1.13e-06 $X=152740 $Y=23120 $dt=16
M5016 VDD! 253 272 VDD! pfet_01v8 L=1.5e-07 W=1.13e-06 $X=152740 $Y=31400 $dt=16
M5017 VDD! 254 273 VDD! pfet_01v8 L=1.5e-07 W=1.13e-06 $X=152740 $Y=39680 $dt=16
M5018 VDD! 255 274 VDD! pfet_01v8 L=1.5e-07 W=1.13e-06 $X=152740 $Y=47960 $dt=16
M5019 VDD! 256 275 VDD! pfet_01v8 L=1.5e-07 W=1.13e-06 $X=152740 $Y=56240 $dt=16
M5020 VDD! 257 276 VDD! pfet_01v8 L=1.5e-07 W=1.13e-06 $X=152740 $Y=64520 $dt=16
M5021 VDD! 258 277 VDD! pfet_01v8 L=1.5e-07 W=1.13e-06 $X=152740 $Y=72800 $dt=16
M5022 VDD! 259 278 VDD! pfet_01v8 L=1.5e-07 W=1.13e-06 $X=152740 $Y=81080 $dt=16
M5023 VDD! 260 279 VDD! pfet_01v8 L=1.5e-07 W=1.13e-06 $X=152740 $Y=89360 $dt=16
M5024 VDD! 261 280 VDD! pfet_01v8 L=1.5e-07 W=1.13e-06 $X=152740 $Y=97640 $dt=16
M5025 VDD! 262 281 VDD! pfet_01v8 L=1.5e-07 W=1.13e-06 $X=152740 $Y=105920 $dt=16
M5026 VDD! 263 282 VDD! pfet_01v8 L=1.5e-07 W=1.13e-06 $X=152740 $Y=114200 $dt=16
M5027 VDD! 264 283 VDD! pfet_01v8 L=1.5e-07 W=1.13e-06 $X=152740 $Y=122480 $dt=16
M5028 VDD! 265 284 VDD! pfet_01v8 L=1.5e-07 W=1.13e-06 $X=152740 $Y=130760 $dt=16
M5029 VDD! 266 285 VDD! pfet_01v8 L=1.5e-07 W=1.13e-06 $X=152740 $Y=139040 $dt=16
M5030 VDD! 267 286 VDD! pfet_01v8 L=1.5e-07 W=1.13e-06 $X=152740 $Y=147320 $dt=16
M5031 VDD! 268 287 VDD! pfet_01v8 L=1.5e-07 W=1.13e-06 $X=152740 $Y=155600 $dt=16
M5032 VDD! 269 288 VDD! pfet_01v8 L=1.5e-07 W=1.13e-06 $X=152740 $Y=163880 $dt=16
M5033 289 118 VDD! VDD! pfet_01v8 L=1.5e-07 W=1.13e-06 $X=153110 $Y=8870 $dt=16
M5034 290 119 VDD! VDD! pfet_01v8 L=1.5e-07 W=1.13e-06 $X=153110 $Y=17150 $dt=16
M5035 291 120 VDD! VDD! pfet_01v8 L=1.5e-07 W=1.13e-06 $X=153110 $Y=25430 $dt=16
M5036 292 121 VDD! VDD! pfet_01v8 L=1.5e-07 W=1.13e-06 $X=153110 $Y=33710 $dt=16
M5037 293 122 VDD! VDD! pfet_01v8 L=1.5e-07 W=1.13e-06 $X=153110 $Y=41990 $dt=16
M5038 294 123 VDD! VDD! pfet_01v8 L=1.5e-07 W=1.13e-06 $X=153110 $Y=50270 $dt=16
M5039 295 124 VDD! VDD! pfet_01v8 L=1.5e-07 W=1.13e-06 $X=153110 $Y=58550 $dt=16
M5040 296 125 VDD! VDD! pfet_01v8 L=1.5e-07 W=1.13e-06 $X=153110 $Y=66830 $dt=16
M5041 297 126 VDD! VDD! pfet_01v8 L=1.5e-07 W=1.13e-06 $X=153110 $Y=75110 $dt=16
M5042 298 127 VDD! VDD! pfet_01v8 L=1.5e-07 W=1.13e-06 $X=153110 $Y=83390 $dt=16
M5043 299 128 VDD! VDD! pfet_01v8 L=1.5e-07 W=1.13e-06 $X=153110 $Y=91670 $dt=16
M5044 300 129 VDD! VDD! pfet_01v8 L=1.5e-07 W=1.13e-06 $X=153110 $Y=99950 $dt=16
M5045 301 130 VDD! VDD! pfet_01v8 L=1.5e-07 W=1.13e-06 $X=153110 $Y=108230 $dt=16
M5046 302 131 VDD! VDD! pfet_01v8 L=1.5e-07 W=1.13e-06 $X=153110 $Y=116510 $dt=16
M5047 303 132 VDD! VDD! pfet_01v8 L=1.5e-07 W=1.13e-06 $X=153110 $Y=124790 $dt=16
M5048 304 133 VDD! VDD! pfet_01v8 L=1.5e-07 W=1.13e-06 $X=153110 $Y=133070 $dt=16
M5049 305 134 VDD! VDD! pfet_01v8 L=1.5e-07 W=1.13e-06 $X=153110 $Y=141350 $dt=16
M5050 306 135 VDD! VDD! pfet_01v8 L=1.5e-07 W=1.13e-06 $X=153110 $Y=149630 $dt=16
M5051 307 136 VDD! VDD! pfet_01v8 L=1.5e-07 W=1.13e-06 $X=153110 $Y=157910 $dt=16
M5052 270 251 VDD! VDD! pfet_01v8 L=1.5e-07 W=1.13e-06 $X=153170 $Y=14840 $dt=16
M5053 271 252 VDD! VDD! pfet_01v8 L=1.5e-07 W=1.13e-06 $X=153170 $Y=23120 $dt=16
M5054 272 253 VDD! VDD! pfet_01v8 L=1.5e-07 W=1.13e-06 $X=153170 $Y=31400 $dt=16
M5055 273 254 VDD! VDD! pfet_01v8 L=1.5e-07 W=1.13e-06 $X=153170 $Y=39680 $dt=16
M5056 274 255 VDD! VDD! pfet_01v8 L=1.5e-07 W=1.13e-06 $X=153170 $Y=47960 $dt=16
M5057 275 256 VDD! VDD! pfet_01v8 L=1.5e-07 W=1.13e-06 $X=153170 $Y=56240 $dt=16
M5058 276 257 VDD! VDD! pfet_01v8 L=1.5e-07 W=1.13e-06 $X=153170 $Y=64520 $dt=16
M5059 277 258 VDD! VDD! pfet_01v8 L=1.5e-07 W=1.13e-06 $X=153170 $Y=72800 $dt=16
M5060 278 259 VDD! VDD! pfet_01v8 L=1.5e-07 W=1.13e-06 $X=153170 $Y=81080 $dt=16
M5061 279 260 VDD! VDD! pfet_01v8 L=1.5e-07 W=1.13e-06 $X=153170 $Y=89360 $dt=16
M5062 280 261 VDD! VDD! pfet_01v8 L=1.5e-07 W=1.13e-06 $X=153170 $Y=97640 $dt=16
M5063 281 262 VDD! VDD! pfet_01v8 L=1.5e-07 W=1.13e-06 $X=153170 $Y=105920 $dt=16
M5064 282 263 VDD! VDD! pfet_01v8 L=1.5e-07 W=1.13e-06 $X=153170 $Y=114200 $dt=16
M5065 283 264 VDD! VDD! pfet_01v8 L=1.5e-07 W=1.13e-06 $X=153170 $Y=122480 $dt=16
M5066 284 265 VDD! VDD! pfet_01v8 L=1.5e-07 W=1.13e-06 $X=153170 $Y=130760 $dt=16
M5067 285 266 VDD! VDD! pfet_01v8 L=1.5e-07 W=1.13e-06 $X=153170 $Y=139040 $dt=16
M5068 286 267 VDD! VDD! pfet_01v8 L=1.5e-07 W=1.13e-06 $X=153170 $Y=147320 $dt=16
M5069 287 268 VDD! VDD! pfet_01v8 L=1.5e-07 W=1.13e-06 $X=153170 $Y=155600 $dt=16
M5070 288 269 VDD! VDD! pfet_01v8 L=1.5e-07 W=1.13e-06 $X=153170 $Y=163880 $dt=16
M5071 VDD! 118 289 VDD! pfet_01v8 L=1.5e-07 W=1.13e-06 $X=153540 $Y=8870 $dt=16
M5072 VDD! 119 290 VDD! pfet_01v8 L=1.5e-07 W=1.13e-06 $X=153540 $Y=17150 $dt=16
M5073 VDD! 120 291 VDD! pfet_01v8 L=1.5e-07 W=1.13e-06 $X=153540 $Y=25430 $dt=16
M5074 VDD! 121 292 VDD! pfet_01v8 L=1.5e-07 W=1.13e-06 $X=153540 $Y=33710 $dt=16
M5075 VDD! 122 293 VDD! pfet_01v8 L=1.5e-07 W=1.13e-06 $X=153540 $Y=41990 $dt=16
M5076 VDD! 123 294 VDD! pfet_01v8 L=1.5e-07 W=1.13e-06 $X=153540 $Y=50270 $dt=16
M5077 VDD! 124 295 VDD! pfet_01v8 L=1.5e-07 W=1.13e-06 $X=153540 $Y=58550 $dt=16
M5078 VDD! 125 296 VDD! pfet_01v8 L=1.5e-07 W=1.13e-06 $X=153540 $Y=66830 $dt=16
M5079 VDD! 126 297 VDD! pfet_01v8 L=1.5e-07 W=1.13e-06 $X=153540 $Y=75110 $dt=16
M5080 VDD! 127 298 VDD! pfet_01v8 L=1.5e-07 W=1.13e-06 $X=153540 $Y=83390 $dt=16
M5081 VDD! 128 299 VDD! pfet_01v8 L=1.5e-07 W=1.13e-06 $X=153540 $Y=91670 $dt=16
M5082 VDD! 129 300 VDD! pfet_01v8 L=1.5e-07 W=1.13e-06 $X=153540 $Y=99950 $dt=16
M5083 VDD! 130 301 VDD! pfet_01v8 L=1.5e-07 W=1.13e-06 $X=153540 $Y=108230 $dt=16
M5084 VDD! 131 302 VDD! pfet_01v8 L=1.5e-07 W=1.13e-06 $X=153540 $Y=116510 $dt=16
M5085 VDD! 132 303 VDD! pfet_01v8 L=1.5e-07 W=1.13e-06 $X=153540 $Y=124790 $dt=16
M5086 VDD! 133 304 VDD! pfet_01v8 L=1.5e-07 W=1.13e-06 $X=153540 $Y=133070 $dt=16
M5087 VDD! 134 305 VDD! pfet_01v8 L=1.5e-07 W=1.13e-06 $X=153540 $Y=141350 $dt=16
M5088 VDD! 135 306 VDD! pfet_01v8 L=1.5e-07 W=1.13e-06 $X=153540 $Y=149630 $dt=16
M5089 VDD! 136 307 VDD! pfet_01v8 L=1.5e-07 W=1.13e-06 $X=153540 $Y=157910 $dt=16
M5090 VDD! 251 270 VDD! pfet_01v8 L=1.5e-07 W=1.13e-06 $X=153600 $Y=14840 $dt=16
M5091 VDD! 252 271 VDD! pfet_01v8 L=1.5e-07 W=1.13e-06 $X=153600 $Y=23120 $dt=16
M5092 VDD! 253 272 VDD! pfet_01v8 L=1.5e-07 W=1.13e-06 $X=153600 $Y=31400 $dt=16
M5093 VDD! 254 273 VDD! pfet_01v8 L=1.5e-07 W=1.13e-06 $X=153600 $Y=39680 $dt=16
M5094 VDD! 255 274 VDD! pfet_01v8 L=1.5e-07 W=1.13e-06 $X=153600 $Y=47960 $dt=16
M5095 VDD! 256 275 VDD! pfet_01v8 L=1.5e-07 W=1.13e-06 $X=153600 $Y=56240 $dt=16
M5096 VDD! 257 276 VDD! pfet_01v8 L=1.5e-07 W=1.13e-06 $X=153600 $Y=64520 $dt=16
M5097 VDD! 258 277 VDD! pfet_01v8 L=1.5e-07 W=1.13e-06 $X=153600 $Y=72800 $dt=16
M5098 VDD! 259 278 VDD! pfet_01v8 L=1.5e-07 W=1.13e-06 $X=153600 $Y=81080 $dt=16
M5099 VDD! 260 279 VDD! pfet_01v8 L=1.5e-07 W=1.13e-06 $X=153600 $Y=89360 $dt=16
M5100 VDD! 261 280 VDD! pfet_01v8 L=1.5e-07 W=1.13e-06 $X=153600 $Y=97640 $dt=16
M5101 VDD! 262 281 VDD! pfet_01v8 L=1.5e-07 W=1.13e-06 $X=153600 $Y=105920 $dt=16
M5102 VDD! 263 282 VDD! pfet_01v8 L=1.5e-07 W=1.13e-06 $X=153600 $Y=114200 $dt=16
M5103 VDD! 264 283 VDD! pfet_01v8 L=1.5e-07 W=1.13e-06 $X=153600 $Y=122480 $dt=16
M5104 VDD! 265 284 VDD! pfet_01v8 L=1.5e-07 W=1.13e-06 $X=153600 $Y=130760 $dt=16
M5105 VDD! 266 285 VDD! pfet_01v8 L=1.5e-07 W=1.13e-06 $X=153600 $Y=139040 $dt=16
M5106 VDD! 267 286 VDD! pfet_01v8 L=1.5e-07 W=1.13e-06 $X=153600 $Y=147320 $dt=16
M5107 VDD! 268 287 VDD! pfet_01v8 L=1.5e-07 W=1.13e-06 $X=153600 $Y=155600 $dt=16
M5108 VDD! 269 288 VDD! pfet_01v8 L=1.5e-07 W=1.13e-06 $X=153600 $Y=163880 $dt=16
M5109 251 118 VDD! VDD! pfet_01v8 L=1.5e-07 W=1.13e-06 $X=154030 $Y=14840 $dt=16
M5110 252 119 VDD! VDD! pfet_01v8 L=1.5e-07 W=1.13e-06 $X=154030 $Y=23120 $dt=16
M5111 253 120 VDD! VDD! pfet_01v8 L=1.5e-07 W=1.13e-06 $X=154030 $Y=31400 $dt=16
M5112 254 121 VDD! VDD! pfet_01v8 L=1.5e-07 W=1.13e-06 $X=154030 $Y=39680 $dt=16
M5113 255 122 VDD! VDD! pfet_01v8 L=1.5e-07 W=1.13e-06 $X=154030 $Y=47960 $dt=16
M5114 256 123 VDD! VDD! pfet_01v8 L=1.5e-07 W=1.13e-06 $X=154030 $Y=56240 $dt=16
M5115 257 124 VDD! VDD! pfet_01v8 L=1.5e-07 W=1.13e-06 $X=154030 $Y=64520 $dt=16
M5116 258 125 VDD! VDD! pfet_01v8 L=1.5e-07 W=1.13e-06 $X=154030 $Y=72800 $dt=16
M5117 259 126 VDD! VDD! pfet_01v8 L=1.5e-07 W=1.13e-06 $X=154030 $Y=81080 $dt=16
M5118 260 127 VDD! VDD! pfet_01v8 L=1.5e-07 W=1.13e-06 $X=154030 $Y=89360 $dt=16
M5119 261 128 VDD! VDD! pfet_01v8 L=1.5e-07 W=1.13e-06 $X=154030 $Y=97640 $dt=16
M5120 262 129 VDD! VDD! pfet_01v8 L=1.5e-07 W=1.13e-06 $X=154030 $Y=105920 $dt=16
M5121 263 130 VDD! VDD! pfet_01v8 L=1.5e-07 W=1.13e-06 $X=154030 $Y=114200 $dt=16
M5122 264 131 VDD! VDD! pfet_01v8 L=1.5e-07 W=1.13e-06 $X=154030 $Y=122480 $dt=16
M5123 265 132 VDD! VDD! pfet_01v8 L=1.5e-07 W=1.13e-06 $X=154030 $Y=130760 $dt=16
M5124 266 133 VDD! VDD! pfet_01v8 L=1.5e-07 W=1.13e-06 $X=154030 $Y=139040 $dt=16
M5125 267 134 VDD! VDD! pfet_01v8 L=1.5e-07 W=1.13e-06 $X=154030 $Y=147320 $dt=16
M5126 268 135 VDD! VDD! pfet_01v8 L=1.5e-07 W=1.13e-06 $X=154030 $Y=155600 $dt=16
M5127 269 136 VDD! VDD! pfet_01v8 L=1.5e-07 W=1.13e-06 $X=154030 $Y=163880 $dt=16
M5128 VDD! 118 251 VDD! pfet_01v8 L=1.5e-07 W=1.13e-06 $X=154460 $Y=14840 $dt=16
M5129 VDD! 119 252 VDD! pfet_01v8 L=1.5e-07 W=1.13e-06 $X=154460 $Y=23120 $dt=16
M5130 VDD! 120 253 VDD! pfet_01v8 L=1.5e-07 W=1.13e-06 $X=154460 $Y=31400 $dt=16
M5131 VDD! 121 254 VDD! pfet_01v8 L=1.5e-07 W=1.13e-06 $X=154460 $Y=39680 $dt=16
M5132 VDD! 122 255 VDD! pfet_01v8 L=1.5e-07 W=1.13e-06 $X=154460 $Y=47960 $dt=16
M5133 VDD! 123 256 VDD! pfet_01v8 L=1.5e-07 W=1.13e-06 $X=154460 $Y=56240 $dt=16
M5134 VDD! 124 257 VDD! pfet_01v8 L=1.5e-07 W=1.13e-06 $X=154460 $Y=64520 $dt=16
M5135 VDD! 125 258 VDD! pfet_01v8 L=1.5e-07 W=1.13e-06 $X=154460 $Y=72800 $dt=16
M5136 VDD! 126 259 VDD! pfet_01v8 L=1.5e-07 W=1.13e-06 $X=154460 $Y=81080 $dt=16
M5137 VDD! 127 260 VDD! pfet_01v8 L=1.5e-07 W=1.13e-06 $X=154460 $Y=89360 $dt=16
M5138 VDD! 128 261 VDD! pfet_01v8 L=1.5e-07 W=1.13e-06 $X=154460 $Y=97640 $dt=16
M5139 VDD! 129 262 VDD! pfet_01v8 L=1.5e-07 W=1.13e-06 $X=154460 $Y=105920 $dt=16
M5140 VDD! 130 263 VDD! pfet_01v8 L=1.5e-07 W=1.13e-06 $X=154460 $Y=114200 $dt=16
M5141 VDD! 131 264 VDD! pfet_01v8 L=1.5e-07 W=1.13e-06 $X=154460 $Y=122480 $dt=16
M5142 VDD! 132 265 VDD! pfet_01v8 L=1.5e-07 W=1.13e-06 $X=154460 $Y=130760 $dt=16
M5143 VDD! 133 266 VDD! pfet_01v8 L=1.5e-07 W=1.13e-06 $X=154460 $Y=139040 $dt=16
M5144 VDD! 134 267 VDD! pfet_01v8 L=1.5e-07 W=1.13e-06 $X=154460 $Y=147320 $dt=16
M5145 VDD! 135 268 VDD! pfet_01v8 L=1.5e-07 W=1.13e-06 $X=154460 $Y=155600 $dt=16
M5146 VDD! 136 269 VDD! pfet_01v8 L=1.5e-07 W=1.13e-06 $X=154460 $Y=163880 $dt=16
M5147 232 194 VDD! VDD! pfet_01v8 L=1.5e-07 W=1.13e-06 $X=155500 $Y=14840 $dt=16
M5148 233 195 VDD! VDD! pfet_01v8 L=1.5e-07 W=1.13e-06 $X=155500 $Y=23120 $dt=16
M5149 234 196 VDD! VDD! pfet_01v8 L=1.5e-07 W=1.13e-06 $X=155500 $Y=31400 $dt=16
M5150 235 197 VDD! VDD! pfet_01v8 L=1.5e-07 W=1.13e-06 $X=155500 $Y=39680 $dt=16
M5151 236 198 VDD! VDD! pfet_01v8 L=1.5e-07 W=1.13e-06 $X=155500 $Y=47960 $dt=16
M5152 237 199 VDD! VDD! pfet_01v8 L=1.5e-07 W=1.13e-06 $X=155500 $Y=56240 $dt=16
M5153 238 200 VDD! VDD! pfet_01v8 L=1.5e-07 W=1.13e-06 $X=155500 $Y=64520 $dt=16
M5154 239 201 VDD! VDD! pfet_01v8 L=1.5e-07 W=1.13e-06 $X=155500 $Y=72800 $dt=16
M5155 240 202 VDD! VDD! pfet_01v8 L=1.5e-07 W=1.13e-06 $X=155500 $Y=81080 $dt=16
M5156 241 203 VDD! VDD! pfet_01v8 L=1.5e-07 W=1.13e-06 $X=155500 $Y=89360 $dt=16
M5157 242 204 VDD! VDD! pfet_01v8 L=1.5e-07 W=1.13e-06 $X=155500 $Y=97640 $dt=16
M5158 243 205 VDD! VDD! pfet_01v8 L=1.5e-07 W=1.13e-06 $X=155500 $Y=105920 $dt=16
M5159 244 206 VDD! VDD! pfet_01v8 L=1.5e-07 W=1.13e-06 $X=155500 $Y=114200 $dt=16
M5160 245 207 VDD! VDD! pfet_01v8 L=1.5e-07 W=1.13e-06 $X=155500 $Y=122480 $dt=16
M5161 246 208 VDD! VDD! pfet_01v8 L=1.5e-07 W=1.13e-06 $X=155500 $Y=130760 $dt=16
M5162 247 209 VDD! VDD! pfet_01v8 L=1.5e-07 W=1.13e-06 $X=155500 $Y=139040 $dt=16
M5163 248 210 VDD! VDD! pfet_01v8 L=1.5e-07 W=1.13e-06 $X=155500 $Y=147320 $dt=16
M5164 249 211 VDD! VDD! pfet_01v8 L=1.5e-07 W=1.13e-06 $X=155500 $Y=155600 $dt=16
M5165 250 212 VDD! VDD! pfet_01v8 L=1.5e-07 W=1.13e-06 $X=155500 $Y=163880 $dt=16
M5166 213 99 VDD! VDD! pfet_01v8 L=1.5e-07 W=1.13e-06 $X=155930 $Y=8870 $dt=16
M5167 VDD! 194 232 VDD! pfet_01v8 L=1.5e-07 W=1.13e-06 $X=155930 $Y=14840 $dt=16
M5168 214 100 VDD! VDD! pfet_01v8 L=1.5e-07 W=1.13e-06 $X=155930 $Y=17150 $dt=16
M5169 VDD! 195 233 VDD! pfet_01v8 L=1.5e-07 W=1.13e-06 $X=155930 $Y=23120 $dt=16
M5170 215 101 VDD! VDD! pfet_01v8 L=1.5e-07 W=1.13e-06 $X=155930 $Y=25430 $dt=16
M5171 VDD! 196 234 VDD! pfet_01v8 L=1.5e-07 W=1.13e-06 $X=155930 $Y=31400 $dt=16
M5172 216 102 VDD! VDD! pfet_01v8 L=1.5e-07 W=1.13e-06 $X=155930 $Y=33710 $dt=16
M5173 VDD! 197 235 VDD! pfet_01v8 L=1.5e-07 W=1.13e-06 $X=155930 $Y=39680 $dt=16
M5174 217 103 VDD! VDD! pfet_01v8 L=1.5e-07 W=1.13e-06 $X=155930 $Y=41990 $dt=16
M5175 VDD! 198 236 VDD! pfet_01v8 L=1.5e-07 W=1.13e-06 $X=155930 $Y=47960 $dt=16
M5176 218 104 VDD! VDD! pfet_01v8 L=1.5e-07 W=1.13e-06 $X=155930 $Y=50270 $dt=16
M5177 VDD! 199 237 VDD! pfet_01v8 L=1.5e-07 W=1.13e-06 $X=155930 $Y=56240 $dt=16
M5178 219 105 VDD! VDD! pfet_01v8 L=1.5e-07 W=1.13e-06 $X=155930 $Y=58550 $dt=16
M5179 VDD! 200 238 VDD! pfet_01v8 L=1.5e-07 W=1.13e-06 $X=155930 $Y=64520 $dt=16
M5180 220 106 VDD! VDD! pfet_01v8 L=1.5e-07 W=1.13e-06 $X=155930 $Y=66830 $dt=16
M5181 VDD! 201 239 VDD! pfet_01v8 L=1.5e-07 W=1.13e-06 $X=155930 $Y=72800 $dt=16
M5182 221 107 VDD! VDD! pfet_01v8 L=1.5e-07 W=1.13e-06 $X=155930 $Y=75110 $dt=16
M5183 VDD! 202 240 VDD! pfet_01v8 L=1.5e-07 W=1.13e-06 $X=155930 $Y=81080 $dt=16
M5184 222 108 VDD! VDD! pfet_01v8 L=1.5e-07 W=1.13e-06 $X=155930 $Y=83390 $dt=16
M5185 VDD! 203 241 VDD! pfet_01v8 L=1.5e-07 W=1.13e-06 $X=155930 $Y=89360 $dt=16
M5186 223 109 VDD! VDD! pfet_01v8 L=1.5e-07 W=1.13e-06 $X=155930 $Y=91670 $dt=16
M5187 VDD! 204 242 VDD! pfet_01v8 L=1.5e-07 W=1.13e-06 $X=155930 $Y=97640 $dt=16
M5188 224 110 VDD! VDD! pfet_01v8 L=1.5e-07 W=1.13e-06 $X=155930 $Y=99950 $dt=16
M5189 VDD! 205 243 VDD! pfet_01v8 L=1.5e-07 W=1.13e-06 $X=155930 $Y=105920 $dt=16
M5190 225 111 VDD! VDD! pfet_01v8 L=1.5e-07 W=1.13e-06 $X=155930 $Y=108230 $dt=16
M5191 VDD! 206 244 VDD! pfet_01v8 L=1.5e-07 W=1.13e-06 $X=155930 $Y=114200 $dt=16
M5192 226 112 VDD! VDD! pfet_01v8 L=1.5e-07 W=1.13e-06 $X=155930 $Y=116510 $dt=16
M5193 VDD! 207 245 VDD! pfet_01v8 L=1.5e-07 W=1.13e-06 $X=155930 $Y=122480 $dt=16
M5194 227 113 VDD! VDD! pfet_01v8 L=1.5e-07 W=1.13e-06 $X=155930 $Y=124790 $dt=16
M5195 VDD! 208 246 VDD! pfet_01v8 L=1.5e-07 W=1.13e-06 $X=155930 $Y=130760 $dt=16
M5196 228 114 VDD! VDD! pfet_01v8 L=1.5e-07 W=1.13e-06 $X=155930 $Y=133070 $dt=16
M5197 VDD! 209 247 VDD! pfet_01v8 L=1.5e-07 W=1.13e-06 $X=155930 $Y=139040 $dt=16
M5198 229 115 VDD! VDD! pfet_01v8 L=1.5e-07 W=1.13e-06 $X=155930 $Y=141350 $dt=16
M5199 VDD! 210 248 VDD! pfet_01v8 L=1.5e-07 W=1.13e-06 $X=155930 $Y=147320 $dt=16
M5200 230 116 VDD! VDD! pfet_01v8 L=1.5e-07 W=1.13e-06 $X=155930 $Y=149630 $dt=16
M5201 VDD! 211 249 VDD! pfet_01v8 L=1.5e-07 W=1.13e-06 $X=155930 $Y=155600 $dt=16
M5202 231 117 VDD! VDD! pfet_01v8 L=1.5e-07 W=1.13e-06 $X=155930 $Y=157910 $dt=16
M5203 VDD! 212 250 VDD! pfet_01v8 L=1.5e-07 W=1.13e-06 $X=155930 $Y=163880 $dt=16
M5204 VDD! 99 213 VDD! pfet_01v8 L=1.5e-07 W=1.13e-06 $X=156360 $Y=8870 $dt=16
M5205 232 194 VDD! VDD! pfet_01v8 L=1.5e-07 W=1.13e-06 $X=156360 $Y=14840 $dt=16
M5206 VDD! 100 214 VDD! pfet_01v8 L=1.5e-07 W=1.13e-06 $X=156360 $Y=17150 $dt=16
M5207 233 195 VDD! VDD! pfet_01v8 L=1.5e-07 W=1.13e-06 $X=156360 $Y=23120 $dt=16
M5208 VDD! 101 215 VDD! pfet_01v8 L=1.5e-07 W=1.13e-06 $X=156360 $Y=25430 $dt=16
M5209 234 196 VDD! VDD! pfet_01v8 L=1.5e-07 W=1.13e-06 $X=156360 $Y=31400 $dt=16
M5210 VDD! 102 216 VDD! pfet_01v8 L=1.5e-07 W=1.13e-06 $X=156360 $Y=33710 $dt=16
M5211 235 197 VDD! VDD! pfet_01v8 L=1.5e-07 W=1.13e-06 $X=156360 $Y=39680 $dt=16
M5212 VDD! 103 217 VDD! pfet_01v8 L=1.5e-07 W=1.13e-06 $X=156360 $Y=41990 $dt=16
M5213 236 198 VDD! VDD! pfet_01v8 L=1.5e-07 W=1.13e-06 $X=156360 $Y=47960 $dt=16
M5214 VDD! 104 218 VDD! pfet_01v8 L=1.5e-07 W=1.13e-06 $X=156360 $Y=50270 $dt=16
M5215 237 199 VDD! VDD! pfet_01v8 L=1.5e-07 W=1.13e-06 $X=156360 $Y=56240 $dt=16
M5216 VDD! 105 219 VDD! pfet_01v8 L=1.5e-07 W=1.13e-06 $X=156360 $Y=58550 $dt=16
M5217 238 200 VDD! VDD! pfet_01v8 L=1.5e-07 W=1.13e-06 $X=156360 $Y=64520 $dt=16
M5218 VDD! 106 220 VDD! pfet_01v8 L=1.5e-07 W=1.13e-06 $X=156360 $Y=66830 $dt=16
M5219 239 201 VDD! VDD! pfet_01v8 L=1.5e-07 W=1.13e-06 $X=156360 $Y=72800 $dt=16
M5220 VDD! 107 221 VDD! pfet_01v8 L=1.5e-07 W=1.13e-06 $X=156360 $Y=75110 $dt=16
M5221 240 202 VDD! VDD! pfet_01v8 L=1.5e-07 W=1.13e-06 $X=156360 $Y=81080 $dt=16
M5222 VDD! 108 222 VDD! pfet_01v8 L=1.5e-07 W=1.13e-06 $X=156360 $Y=83390 $dt=16
M5223 241 203 VDD! VDD! pfet_01v8 L=1.5e-07 W=1.13e-06 $X=156360 $Y=89360 $dt=16
M5224 VDD! 109 223 VDD! pfet_01v8 L=1.5e-07 W=1.13e-06 $X=156360 $Y=91670 $dt=16
M5225 242 204 VDD! VDD! pfet_01v8 L=1.5e-07 W=1.13e-06 $X=156360 $Y=97640 $dt=16
M5226 VDD! 110 224 VDD! pfet_01v8 L=1.5e-07 W=1.13e-06 $X=156360 $Y=99950 $dt=16
M5227 243 205 VDD! VDD! pfet_01v8 L=1.5e-07 W=1.13e-06 $X=156360 $Y=105920 $dt=16
M5228 VDD! 111 225 VDD! pfet_01v8 L=1.5e-07 W=1.13e-06 $X=156360 $Y=108230 $dt=16
M5229 244 206 VDD! VDD! pfet_01v8 L=1.5e-07 W=1.13e-06 $X=156360 $Y=114200 $dt=16
M5230 VDD! 112 226 VDD! pfet_01v8 L=1.5e-07 W=1.13e-06 $X=156360 $Y=116510 $dt=16
M5231 245 207 VDD! VDD! pfet_01v8 L=1.5e-07 W=1.13e-06 $X=156360 $Y=122480 $dt=16
M5232 VDD! 113 227 VDD! pfet_01v8 L=1.5e-07 W=1.13e-06 $X=156360 $Y=124790 $dt=16
M5233 246 208 VDD! VDD! pfet_01v8 L=1.5e-07 W=1.13e-06 $X=156360 $Y=130760 $dt=16
M5234 VDD! 114 228 VDD! pfet_01v8 L=1.5e-07 W=1.13e-06 $X=156360 $Y=133070 $dt=16
M5235 247 209 VDD! VDD! pfet_01v8 L=1.5e-07 W=1.13e-06 $X=156360 $Y=139040 $dt=16
M5236 VDD! 115 229 VDD! pfet_01v8 L=1.5e-07 W=1.13e-06 $X=156360 $Y=141350 $dt=16
M5237 248 210 VDD! VDD! pfet_01v8 L=1.5e-07 W=1.13e-06 $X=156360 $Y=147320 $dt=16
M5238 VDD! 116 230 VDD! pfet_01v8 L=1.5e-07 W=1.13e-06 $X=156360 $Y=149630 $dt=16
M5239 249 211 VDD! VDD! pfet_01v8 L=1.5e-07 W=1.13e-06 $X=156360 $Y=155600 $dt=16
M5240 VDD! 117 231 VDD! pfet_01v8 L=1.5e-07 W=1.13e-06 $X=156360 $Y=157910 $dt=16
M5241 250 212 VDD! VDD! pfet_01v8 L=1.5e-07 W=1.13e-06 $X=156360 $Y=163880 $dt=16
M5242 213 99 VDD! VDD! pfet_01v8 L=1.5e-07 W=1.13e-06 $X=156790 $Y=8870 $dt=16
M5243 VDD! 194 232 VDD! pfet_01v8 L=1.5e-07 W=1.13e-06 $X=156790 $Y=14840 $dt=16
M5244 214 100 VDD! VDD! pfet_01v8 L=1.5e-07 W=1.13e-06 $X=156790 $Y=17150 $dt=16
M5245 VDD! 195 233 VDD! pfet_01v8 L=1.5e-07 W=1.13e-06 $X=156790 $Y=23120 $dt=16
M5246 215 101 VDD! VDD! pfet_01v8 L=1.5e-07 W=1.13e-06 $X=156790 $Y=25430 $dt=16
M5247 VDD! 196 234 VDD! pfet_01v8 L=1.5e-07 W=1.13e-06 $X=156790 $Y=31400 $dt=16
M5248 216 102 VDD! VDD! pfet_01v8 L=1.5e-07 W=1.13e-06 $X=156790 $Y=33710 $dt=16
M5249 VDD! 197 235 VDD! pfet_01v8 L=1.5e-07 W=1.13e-06 $X=156790 $Y=39680 $dt=16
M5250 217 103 VDD! VDD! pfet_01v8 L=1.5e-07 W=1.13e-06 $X=156790 $Y=41990 $dt=16
M5251 VDD! 198 236 VDD! pfet_01v8 L=1.5e-07 W=1.13e-06 $X=156790 $Y=47960 $dt=16
M5252 218 104 VDD! VDD! pfet_01v8 L=1.5e-07 W=1.13e-06 $X=156790 $Y=50270 $dt=16
M5253 VDD! 199 237 VDD! pfet_01v8 L=1.5e-07 W=1.13e-06 $X=156790 $Y=56240 $dt=16
M5254 219 105 VDD! VDD! pfet_01v8 L=1.5e-07 W=1.13e-06 $X=156790 $Y=58550 $dt=16
M5255 VDD! 200 238 VDD! pfet_01v8 L=1.5e-07 W=1.13e-06 $X=156790 $Y=64520 $dt=16
M5256 220 106 VDD! VDD! pfet_01v8 L=1.5e-07 W=1.13e-06 $X=156790 $Y=66830 $dt=16
M5257 VDD! 201 239 VDD! pfet_01v8 L=1.5e-07 W=1.13e-06 $X=156790 $Y=72800 $dt=16
M5258 221 107 VDD! VDD! pfet_01v8 L=1.5e-07 W=1.13e-06 $X=156790 $Y=75110 $dt=16
M5259 VDD! 202 240 VDD! pfet_01v8 L=1.5e-07 W=1.13e-06 $X=156790 $Y=81080 $dt=16
M5260 222 108 VDD! VDD! pfet_01v8 L=1.5e-07 W=1.13e-06 $X=156790 $Y=83390 $dt=16
M5261 VDD! 203 241 VDD! pfet_01v8 L=1.5e-07 W=1.13e-06 $X=156790 $Y=89360 $dt=16
M5262 223 109 VDD! VDD! pfet_01v8 L=1.5e-07 W=1.13e-06 $X=156790 $Y=91670 $dt=16
M5263 VDD! 204 242 VDD! pfet_01v8 L=1.5e-07 W=1.13e-06 $X=156790 $Y=97640 $dt=16
M5264 224 110 VDD! VDD! pfet_01v8 L=1.5e-07 W=1.13e-06 $X=156790 $Y=99950 $dt=16
M5265 VDD! 205 243 VDD! pfet_01v8 L=1.5e-07 W=1.13e-06 $X=156790 $Y=105920 $dt=16
M5266 225 111 VDD! VDD! pfet_01v8 L=1.5e-07 W=1.13e-06 $X=156790 $Y=108230 $dt=16
M5267 VDD! 206 244 VDD! pfet_01v8 L=1.5e-07 W=1.13e-06 $X=156790 $Y=114200 $dt=16
M5268 226 112 VDD! VDD! pfet_01v8 L=1.5e-07 W=1.13e-06 $X=156790 $Y=116510 $dt=16
M5269 VDD! 207 245 VDD! pfet_01v8 L=1.5e-07 W=1.13e-06 $X=156790 $Y=122480 $dt=16
M5270 227 113 VDD! VDD! pfet_01v8 L=1.5e-07 W=1.13e-06 $X=156790 $Y=124790 $dt=16
M5271 VDD! 208 246 VDD! pfet_01v8 L=1.5e-07 W=1.13e-06 $X=156790 $Y=130760 $dt=16
M5272 228 114 VDD! VDD! pfet_01v8 L=1.5e-07 W=1.13e-06 $X=156790 $Y=133070 $dt=16
M5273 VDD! 209 247 VDD! pfet_01v8 L=1.5e-07 W=1.13e-06 $X=156790 $Y=139040 $dt=16
M5274 229 115 VDD! VDD! pfet_01v8 L=1.5e-07 W=1.13e-06 $X=156790 $Y=141350 $dt=16
M5275 VDD! 210 248 VDD! pfet_01v8 L=1.5e-07 W=1.13e-06 $X=156790 $Y=147320 $dt=16
M5276 230 116 VDD! VDD! pfet_01v8 L=1.5e-07 W=1.13e-06 $X=156790 $Y=149630 $dt=16
M5277 VDD! 211 249 VDD! pfet_01v8 L=1.5e-07 W=1.13e-06 $X=156790 $Y=155600 $dt=16
M5278 231 117 VDD! VDD! pfet_01v8 L=1.5e-07 W=1.13e-06 $X=156790 $Y=157910 $dt=16
M5279 VDD! 212 250 VDD! pfet_01v8 L=1.5e-07 W=1.13e-06 $X=156790 $Y=163880 $dt=16
M5280 VDD! 99 213 VDD! pfet_01v8 L=1.5e-07 W=1.13e-06 $X=157220 $Y=8870 $dt=16
M5281 194 23 VDD! VDD! pfet_01v8 L=1.5e-07 W=1.13e-06 $X=157220 $Y=14840 $dt=16
M5282 VDD! 100 214 VDD! pfet_01v8 L=1.5e-07 W=1.13e-06 $X=157220 $Y=17150 $dt=16
M5283 195 24 VDD! VDD! pfet_01v8 L=1.5e-07 W=1.13e-06 $X=157220 $Y=23120 $dt=16
M5284 VDD! 101 215 VDD! pfet_01v8 L=1.5e-07 W=1.13e-06 $X=157220 $Y=25430 $dt=16
M5285 196 25 VDD! VDD! pfet_01v8 L=1.5e-07 W=1.13e-06 $X=157220 $Y=31400 $dt=16
M5286 VDD! 102 216 VDD! pfet_01v8 L=1.5e-07 W=1.13e-06 $X=157220 $Y=33710 $dt=16
M5287 197 26 VDD! VDD! pfet_01v8 L=1.5e-07 W=1.13e-06 $X=157220 $Y=39680 $dt=16
M5288 VDD! 103 217 VDD! pfet_01v8 L=1.5e-07 W=1.13e-06 $X=157220 $Y=41990 $dt=16
M5289 198 27 VDD! VDD! pfet_01v8 L=1.5e-07 W=1.13e-06 $X=157220 $Y=47960 $dt=16
M5290 VDD! 104 218 VDD! pfet_01v8 L=1.5e-07 W=1.13e-06 $X=157220 $Y=50270 $dt=16
M5291 199 28 VDD! VDD! pfet_01v8 L=1.5e-07 W=1.13e-06 $X=157220 $Y=56240 $dt=16
M5292 VDD! 105 219 VDD! pfet_01v8 L=1.5e-07 W=1.13e-06 $X=157220 $Y=58550 $dt=16
M5293 200 29 VDD! VDD! pfet_01v8 L=1.5e-07 W=1.13e-06 $X=157220 $Y=64520 $dt=16
M5294 VDD! 106 220 VDD! pfet_01v8 L=1.5e-07 W=1.13e-06 $X=157220 $Y=66830 $dt=16
M5295 201 30 VDD! VDD! pfet_01v8 L=1.5e-07 W=1.13e-06 $X=157220 $Y=72800 $dt=16
M5296 VDD! 107 221 VDD! pfet_01v8 L=1.5e-07 W=1.13e-06 $X=157220 $Y=75110 $dt=16
M5297 202 31 VDD! VDD! pfet_01v8 L=1.5e-07 W=1.13e-06 $X=157220 $Y=81080 $dt=16
M5298 VDD! 108 222 VDD! pfet_01v8 L=1.5e-07 W=1.13e-06 $X=157220 $Y=83390 $dt=16
M5299 203 32 VDD! VDD! pfet_01v8 L=1.5e-07 W=1.13e-06 $X=157220 $Y=89360 $dt=16
M5300 VDD! 109 223 VDD! pfet_01v8 L=1.5e-07 W=1.13e-06 $X=157220 $Y=91670 $dt=16
M5301 204 33 VDD! VDD! pfet_01v8 L=1.5e-07 W=1.13e-06 $X=157220 $Y=97640 $dt=16
M5302 VDD! 110 224 VDD! pfet_01v8 L=1.5e-07 W=1.13e-06 $X=157220 $Y=99950 $dt=16
M5303 205 34 VDD! VDD! pfet_01v8 L=1.5e-07 W=1.13e-06 $X=157220 $Y=105920 $dt=16
M5304 VDD! 111 225 VDD! pfet_01v8 L=1.5e-07 W=1.13e-06 $X=157220 $Y=108230 $dt=16
M5305 206 35 VDD! VDD! pfet_01v8 L=1.5e-07 W=1.13e-06 $X=157220 $Y=114200 $dt=16
M5306 VDD! 112 226 VDD! pfet_01v8 L=1.5e-07 W=1.13e-06 $X=157220 $Y=116510 $dt=16
M5307 207 36 VDD! VDD! pfet_01v8 L=1.5e-07 W=1.13e-06 $X=157220 $Y=122480 $dt=16
M5308 VDD! 113 227 VDD! pfet_01v8 L=1.5e-07 W=1.13e-06 $X=157220 $Y=124790 $dt=16
M5309 208 37 VDD! VDD! pfet_01v8 L=1.5e-07 W=1.13e-06 $X=157220 $Y=130760 $dt=16
M5310 VDD! 114 228 VDD! pfet_01v8 L=1.5e-07 W=1.13e-06 $X=157220 $Y=133070 $dt=16
M5311 209 38 VDD! VDD! pfet_01v8 L=1.5e-07 W=1.13e-06 $X=157220 $Y=139040 $dt=16
M5312 VDD! 115 229 VDD! pfet_01v8 L=1.5e-07 W=1.13e-06 $X=157220 $Y=141350 $dt=16
M5313 210 39 VDD! VDD! pfet_01v8 L=1.5e-07 W=1.13e-06 $X=157220 $Y=147320 $dt=16
M5314 VDD! 116 230 VDD! pfet_01v8 L=1.5e-07 W=1.13e-06 $X=157220 $Y=149630 $dt=16
M5315 211 40 VDD! VDD! pfet_01v8 L=1.5e-07 W=1.13e-06 $X=157220 $Y=155600 $dt=16
M5316 VDD! 117 231 VDD! pfet_01v8 L=1.5e-07 W=1.13e-06 $X=157220 $Y=157910 $dt=16
M5317 212 41 VDD! VDD! pfet_01v8 L=1.5e-07 W=1.13e-06 $X=157220 $Y=163880 $dt=16
M5318 175 23 VDD! VDD! pfet_01v8 L=1.5e-07 W=1.13e-06 $X=158230 $Y=8870 $dt=16
M5319 176 24 VDD! VDD! pfet_01v8 L=1.5e-07 W=1.13e-06 $X=158230 $Y=17150 $dt=16
M5320 177 25 VDD! VDD! pfet_01v8 L=1.5e-07 W=1.13e-06 $X=158230 $Y=25430 $dt=16
M5321 178 26 VDD! VDD! pfet_01v8 L=1.5e-07 W=1.13e-06 $X=158230 $Y=33710 $dt=16
M5322 179 27 VDD! VDD! pfet_01v8 L=1.5e-07 W=1.13e-06 $X=158230 $Y=41990 $dt=16
M5323 180 28 VDD! VDD! pfet_01v8 L=1.5e-07 W=1.13e-06 $X=158230 $Y=50270 $dt=16
M5324 181 29 VDD! VDD! pfet_01v8 L=1.5e-07 W=1.13e-06 $X=158230 $Y=58550 $dt=16
M5325 182 30 VDD! VDD! pfet_01v8 L=1.5e-07 W=1.13e-06 $X=158230 $Y=66830 $dt=16
M5326 183 31 VDD! VDD! pfet_01v8 L=1.5e-07 W=1.13e-06 $X=158230 $Y=75110 $dt=16
M5327 184 32 VDD! VDD! pfet_01v8 L=1.5e-07 W=1.13e-06 $X=158230 $Y=83390 $dt=16
M5328 185 33 VDD! VDD! pfet_01v8 L=1.5e-07 W=1.13e-06 $X=158230 $Y=91670 $dt=16
M5329 186 34 VDD! VDD! pfet_01v8 L=1.5e-07 W=1.13e-06 $X=158230 $Y=99950 $dt=16
M5330 187 35 VDD! VDD! pfet_01v8 L=1.5e-07 W=1.13e-06 $X=158230 $Y=108230 $dt=16
M5331 188 36 VDD! VDD! pfet_01v8 L=1.5e-07 W=1.13e-06 $X=158230 $Y=116510 $dt=16
M5332 189 37 VDD! VDD! pfet_01v8 L=1.5e-07 W=1.13e-06 $X=158230 $Y=124790 $dt=16
M5333 190 38 VDD! VDD! pfet_01v8 L=1.5e-07 W=1.13e-06 $X=158230 $Y=133070 $dt=16
M5334 191 39 VDD! VDD! pfet_01v8 L=1.5e-07 W=1.13e-06 $X=158230 $Y=141350 $dt=16
M5335 192 40 VDD! VDD! pfet_01v8 L=1.5e-07 W=1.13e-06 $X=158230 $Y=149630 $dt=16
M5336 193 41 VDD! VDD! pfet_01v8 L=1.5e-07 W=1.13e-06 $X=158230 $Y=157910 $dt=16
M5337 156 137 VDD! VDD! pfet_01v8 L=1.5e-07 W=1.13e-06 $X=158260 $Y=14840 $dt=16
M5338 157 138 VDD! VDD! pfet_01v8 L=1.5e-07 W=1.13e-06 $X=158260 $Y=23120 $dt=16
M5339 158 139 VDD! VDD! pfet_01v8 L=1.5e-07 W=1.13e-06 $X=158260 $Y=31400 $dt=16
M5340 159 140 VDD! VDD! pfet_01v8 L=1.5e-07 W=1.13e-06 $X=158260 $Y=39680 $dt=16
M5341 160 141 VDD! VDD! pfet_01v8 L=1.5e-07 W=1.13e-06 $X=158260 $Y=47960 $dt=16
M5342 161 142 VDD! VDD! pfet_01v8 L=1.5e-07 W=1.13e-06 $X=158260 $Y=56240 $dt=16
M5343 162 143 VDD! VDD! pfet_01v8 L=1.5e-07 W=1.13e-06 $X=158260 $Y=64520 $dt=16
M5344 163 144 VDD! VDD! pfet_01v8 L=1.5e-07 W=1.13e-06 $X=158260 $Y=72800 $dt=16
M5345 164 145 VDD! VDD! pfet_01v8 L=1.5e-07 W=1.13e-06 $X=158260 $Y=81080 $dt=16
M5346 165 146 VDD! VDD! pfet_01v8 L=1.5e-07 W=1.13e-06 $X=158260 $Y=89360 $dt=16
M5347 166 147 VDD! VDD! pfet_01v8 L=1.5e-07 W=1.13e-06 $X=158260 $Y=97640 $dt=16
M5348 167 148 VDD! VDD! pfet_01v8 L=1.5e-07 W=1.13e-06 $X=158260 $Y=105920 $dt=16
M5349 168 149 VDD! VDD! pfet_01v8 L=1.5e-07 W=1.13e-06 $X=158260 $Y=114200 $dt=16
M5350 169 150 VDD! VDD! pfet_01v8 L=1.5e-07 W=1.13e-06 $X=158260 $Y=122480 $dt=16
M5351 170 151 VDD! VDD! pfet_01v8 L=1.5e-07 W=1.13e-06 $X=158260 $Y=130760 $dt=16
M5352 171 152 VDD! VDD! pfet_01v8 L=1.5e-07 W=1.13e-06 $X=158260 $Y=139040 $dt=16
M5353 172 153 VDD! VDD! pfet_01v8 L=1.5e-07 W=1.13e-06 $X=158260 $Y=147320 $dt=16
M5354 173 154 VDD! VDD! pfet_01v8 L=1.5e-07 W=1.13e-06 $X=158260 $Y=155600 $dt=16
M5355 174 155 VDD! VDD! pfet_01v8 L=1.5e-07 W=1.13e-06 $X=158260 $Y=163880 $dt=16
M5356 VDD! 23 175 VDD! pfet_01v8 L=1.5e-07 W=1.13e-06 $X=158660 $Y=8870 $dt=16
M5357 VDD! 24 176 VDD! pfet_01v8 L=1.5e-07 W=1.13e-06 $X=158660 $Y=17150 $dt=16
M5358 VDD! 25 177 VDD! pfet_01v8 L=1.5e-07 W=1.13e-06 $X=158660 $Y=25430 $dt=16
M5359 VDD! 26 178 VDD! pfet_01v8 L=1.5e-07 W=1.13e-06 $X=158660 $Y=33710 $dt=16
M5360 VDD! 27 179 VDD! pfet_01v8 L=1.5e-07 W=1.13e-06 $X=158660 $Y=41990 $dt=16
M5361 VDD! 28 180 VDD! pfet_01v8 L=1.5e-07 W=1.13e-06 $X=158660 $Y=50270 $dt=16
M5362 VDD! 29 181 VDD! pfet_01v8 L=1.5e-07 W=1.13e-06 $X=158660 $Y=58550 $dt=16
M5363 VDD! 30 182 VDD! pfet_01v8 L=1.5e-07 W=1.13e-06 $X=158660 $Y=66830 $dt=16
M5364 VDD! 31 183 VDD! pfet_01v8 L=1.5e-07 W=1.13e-06 $X=158660 $Y=75110 $dt=16
M5365 VDD! 32 184 VDD! pfet_01v8 L=1.5e-07 W=1.13e-06 $X=158660 $Y=83390 $dt=16
M5366 VDD! 33 185 VDD! pfet_01v8 L=1.5e-07 W=1.13e-06 $X=158660 $Y=91670 $dt=16
M5367 VDD! 34 186 VDD! pfet_01v8 L=1.5e-07 W=1.13e-06 $X=158660 $Y=99950 $dt=16
M5368 VDD! 35 187 VDD! pfet_01v8 L=1.5e-07 W=1.13e-06 $X=158660 $Y=108230 $dt=16
M5369 VDD! 36 188 VDD! pfet_01v8 L=1.5e-07 W=1.13e-06 $X=158660 $Y=116510 $dt=16
M5370 VDD! 37 189 VDD! pfet_01v8 L=1.5e-07 W=1.13e-06 $X=158660 $Y=124790 $dt=16
M5371 VDD! 38 190 VDD! pfet_01v8 L=1.5e-07 W=1.13e-06 $X=158660 $Y=133070 $dt=16
M5372 VDD! 39 191 VDD! pfet_01v8 L=1.5e-07 W=1.13e-06 $X=158660 $Y=141350 $dt=16
M5373 VDD! 40 192 VDD! pfet_01v8 L=1.5e-07 W=1.13e-06 $X=158660 $Y=149630 $dt=16
M5374 VDD! 41 193 VDD! pfet_01v8 L=1.5e-07 W=1.13e-06 $X=158660 $Y=157910 $dt=16
M5375 VDD! 137 156 VDD! pfet_01v8 L=1.5e-07 W=1.13e-06 $X=158690 $Y=14840 $dt=16
M5376 VDD! 138 157 VDD! pfet_01v8 L=1.5e-07 W=1.13e-06 $X=158690 $Y=23120 $dt=16
M5377 VDD! 139 158 VDD! pfet_01v8 L=1.5e-07 W=1.13e-06 $X=158690 $Y=31400 $dt=16
M5378 VDD! 140 159 VDD! pfet_01v8 L=1.5e-07 W=1.13e-06 $X=158690 $Y=39680 $dt=16
M5379 VDD! 141 160 VDD! pfet_01v8 L=1.5e-07 W=1.13e-06 $X=158690 $Y=47960 $dt=16
M5380 VDD! 142 161 VDD! pfet_01v8 L=1.5e-07 W=1.13e-06 $X=158690 $Y=56240 $dt=16
M5381 VDD! 143 162 VDD! pfet_01v8 L=1.5e-07 W=1.13e-06 $X=158690 $Y=64520 $dt=16
M5382 VDD! 144 163 VDD! pfet_01v8 L=1.5e-07 W=1.13e-06 $X=158690 $Y=72800 $dt=16
M5383 VDD! 145 164 VDD! pfet_01v8 L=1.5e-07 W=1.13e-06 $X=158690 $Y=81080 $dt=16
M5384 VDD! 146 165 VDD! pfet_01v8 L=1.5e-07 W=1.13e-06 $X=158690 $Y=89360 $dt=16
M5385 VDD! 147 166 VDD! pfet_01v8 L=1.5e-07 W=1.13e-06 $X=158690 $Y=97640 $dt=16
M5386 VDD! 148 167 VDD! pfet_01v8 L=1.5e-07 W=1.13e-06 $X=158690 $Y=105920 $dt=16
M5387 VDD! 149 168 VDD! pfet_01v8 L=1.5e-07 W=1.13e-06 $X=158690 $Y=114200 $dt=16
M5388 VDD! 150 169 VDD! pfet_01v8 L=1.5e-07 W=1.13e-06 $X=158690 $Y=122480 $dt=16
M5389 VDD! 151 170 VDD! pfet_01v8 L=1.5e-07 W=1.13e-06 $X=158690 $Y=130760 $dt=16
M5390 VDD! 152 171 VDD! pfet_01v8 L=1.5e-07 W=1.13e-06 $X=158690 $Y=139040 $dt=16
M5391 VDD! 153 172 VDD! pfet_01v8 L=1.5e-07 W=1.13e-06 $X=158690 $Y=147320 $dt=16
M5392 VDD! 154 173 VDD! pfet_01v8 L=1.5e-07 W=1.13e-06 $X=158690 $Y=155600 $dt=16
M5393 VDD! 155 174 VDD! pfet_01v8 L=1.5e-07 W=1.13e-06 $X=158690 $Y=163880 $dt=16
M5394 175 23 VDD! VDD! pfet_01v8 L=1.5e-07 W=1.13e-06 $X=159090 $Y=8870 $dt=16
M5395 176 24 VDD! VDD! pfet_01v8 L=1.5e-07 W=1.13e-06 $X=159090 $Y=17150 $dt=16
M5396 177 25 VDD! VDD! pfet_01v8 L=1.5e-07 W=1.13e-06 $X=159090 $Y=25430 $dt=16
M5397 178 26 VDD! VDD! pfet_01v8 L=1.5e-07 W=1.13e-06 $X=159090 $Y=33710 $dt=16
M5398 179 27 VDD! VDD! pfet_01v8 L=1.5e-07 W=1.13e-06 $X=159090 $Y=41990 $dt=16
M5399 180 28 VDD! VDD! pfet_01v8 L=1.5e-07 W=1.13e-06 $X=159090 $Y=50270 $dt=16
M5400 181 29 VDD! VDD! pfet_01v8 L=1.5e-07 W=1.13e-06 $X=159090 $Y=58550 $dt=16
M5401 182 30 VDD! VDD! pfet_01v8 L=1.5e-07 W=1.13e-06 $X=159090 $Y=66830 $dt=16
M5402 183 31 VDD! VDD! pfet_01v8 L=1.5e-07 W=1.13e-06 $X=159090 $Y=75110 $dt=16
M5403 184 32 VDD! VDD! pfet_01v8 L=1.5e-07 W=1.13e-06 $X=159090 $Y=83390 $dt=16
M5404 185 33 VDD! VDD! pfet_01v8 L=1.5e-07 W=1.13e-06 $X=159090 $Y=91670 $dt=16
M5405 186 34 VDD! VDD! pfet_01v8 L=1.5e-07 W=1.13e-06 $X=159090 $Y=99950 $dt=16
M5406 187 35 VDD! VDD! pfet_01v8 L=1.5e-07 W=1.13e-06 $X=159090 $Y=108230 $dt=16
M5407 188 36 VDD! VDD! pfet_01v8 L=1.5e-07 W=1.13e-06 $X=159090 $Y=116510 $dt=16
M5408 189 37 VDD! VDD! pfet_01v8 L=1.5e-07 W=1.13e-06 $X=159090 $Y=124790 $dt=16
M5409 190 38 VDD! VDD! pfet_01v8 L=1.5e-07 W=1.13e-06 $X=159090 $Y=133070 $dt=16
M5410 191 39 VDD! VDD! pfet_01v8 L=1.5e-07 W=1.13e-06 $X=159090 $Y=141350 $dt=16
M5411 192 40 VDD! VDD! pfet_01v8 L=1.5e-07 W=1.13e-06 $X=159090 $Y=149630 $dt=16
M5412 193 41 VDD! VDD! pfet_01v8 L=1.5e-07 W=1.13e-06 $X=159090 $Y=157910 $dt=16
M5413 156 137 VDD! VDD! pfet_01v8 L=1.5e-07 W=1.13e-06 $X=159120 $Y=14840 $dt=16
M5414 157 138 VDD! VDD! pfet_01v8 L=1.5e-07 W=1.13e-06 $X=159120 $Y=23120 $dt=16
M5415 158 139 VDD! VDD! pfet_01v8 L=1.5e-07 W=1.13e-06 $X=159120 $Y=31400 $dt=16
M5416 159 140 VDD! VDD! pfet_01v8 L=1.5e-07 W=1.13e-06 $X=159120 $Y=39680 $dt=16
M5417 160 141 VDD! VDD! pfet_01v8 L=1.5e-07 W=1.13e-06 $X=159120 $Y=47960 $dt=16
M5418 161 142 VDD! VDD! pfet_01v8 L=1.5e-07 W=1.13e-06 $X=159120 $Y=56240 $dt=16
M5419 162 143 VDD! VDD! pfet_01v8 L=1.5e-07 W=1.13e-06 $X=159120 $Y=64520 $dt=16
M5420 163 144 VDD! VDD! pfet_01v8 L=1.5e-07 W=1.13e-06 $X=159120 $Y=72800 $dt=16
M5421 164 145 VDD! VDD! pfet_01v8 L=1.5e-07 W=1.13e-06 $X=159120 $Y=81080 $dt=16
M5422 165 146 VDD! VDD! pfet_01v8 L=1.5e-07 W=1.13e-06 $X=159120 $Y=89360 $dt=16
M5423 166 147 VDD! VDD! pfet_01v8 L=1.5e-07 W=1.13e-06 $X=159120 $Y=97640 $dt=16
M5424 167 148 VDD! VDD! pfet_01v8 L=1.5e-07 W=1.13e-06 $X=159120 $Y=105920 $dt=16
M5425 168 149 VDD! VDD! pfet_01v8 L=1.5e-07 W=1.13e-06 $X=159120 $Y=114200 $dt=16
M5426 169 150 VDD! VDD! pfet_01v8 L=1.5e-07 W=1.13e-06 $X=159120 $Y=122480 $dt=16
M5427 170 151 VDD! VDD! pfet_01v8 L=1.5e-07 W=1.13e-06 $X=159120 $Y=130760 $dt=16
M5428 171 152 VDD! VDD! pfet_01v8 L=1.5e-07 W=1.13e-06 $X=159120 $Y=139040 $dt=16
M5429 172 153 VDD! VDD! pfet_01v8 L=1.5e-07 W=1.13e-06 $X=159120 $Y=147320 $dt=16
M5430 173 154 VDD! VDD! pfet_01v8 L=1.5e-07 W=1.13e-06 $X=159120 $Y=155600 $dt=16
M5431 174 155 VDD! VDD! pfet_01v8 L=1.5e-07 W=1.13e-06 $X=159120 $Y=163880 $dt=16
M5432 VDD! 23 175 VDD! pfet_01v8 L=1.5e-07 W=1.13e-06 $X=159520 $Y=8870 $dt=16
M5433 VDD! 24 176 VDD! pfet_01v8 L=1.5e-07 W=1.13e-06 $X=159520 $Y=17150 $dt=16
M5434 VDD! 25 177 VDD! pfet_01v8 L=1.5e-07 W=1.13e-06 $X=159520 $Y=25430 $dt=16
M5435 VDD! 26 178 VDD! pfet_01v8 L=1.5e-07 W=1.13e-06 $X=159520 $Y=33710 $dt=16
M5436 VDD! 27 179 VDD! pfet_01v8 L=1.5e-07 W=1.13e-06 $X=159520 $Y=41990 $dt=16
M5437 VDD! 28 180 VDD! pfet_01v8 L=1.5e-07 W=1.13e-06 $X=159520 $Y=50270 $dt=16
M5438 VDD! 29 181 VDD! pfet_01v8 L=1.5e-07 W=1.13e-06 $X=159520 $Y=58550 $dt=16
M5439 VDD! 30 182 VDD! pfet_01v8 L=1.5e-07 W=1.13e-06 $X=159520 $Y=66830 $dt=16
M5440 VDD! 31 183 VDD! pfet_01v8 L=1.5e-07 W=1.13e-06 $X=159520 $Y=75110 $dt=16
M5441 VDD! 32 184 VDD! pfet_01v8 L=1.5e-07 W=1.13e-06 $X=159520 $Y=83390 $dt=16
M5442 VDD! 33 185 VDD! pfet_01v8 L=1.5e-07 W=1.13e-06 $X=159520 $Y=91670 $dt=16
M5443 VDD! 34 186 VDD! pfet_01v8 L=1.5e-07 W=1.13e-06 $X=159520 $Y=99950 $dt=16
M5444 VDD! 35 187 VDD! pfet_01v8 L=1.5e-07 W=1.13e-06 $X=159520 $Y=108230 $dt=16
M5445 VDD! 36 188 VDD! pfet_01v8 L=1.5e-07 W=1.13e-06 $X=159520 $Y=116510 $dt=16
M5446 VDD! 37 189 VDD! pfet_01v8 L=1.5e-07 W=1.13e-06 $X=159520 $Y=124790 $dt=16
M5447 VDD! 38 190 VDD! pfet_01v8 L=1.5e-07 W=1.13e-06 $X=159520 $Y=133070 $dt=16
M5448 VDD! 39 191 VDD! pfet_01v8 L=1.5e-07 W=1.13e-06 $X=159520 $Y=141350 $dt=16
M5449 VDD! 40 192 VDD! pfet_01v8 L=1.5e-07 W=1.13e-06 $X=159520 $Y=149630 $dt=16
M5450 VDD! 41 193 VDD! pfet_01v8 L=1.5e-07 W=1.13e-06 $X=159520 $Y=157910 $dt=16
M5451 VDD! 137 156 VDD! pfet_01v8 L=1.5e-07 W=1.13e-06 $X=159550 $Y=14840 $dt=16
M5452 VDD! 138 157 VDD! pfet_01v8 L=1.5e-07 W=1.13e-06 $X=159550 $Y=23120 $dt=16
M5453 VDD! 139 158 VDD! pfet_01v8 L=1.5e-07 W=1.13e-06 $X=159550 $Y=31400 $dt=16
M5454 VDD! 140 159 VDD! pfet_01v8 L=1.5e-07 W=1.13e-06 $X=159550 $Y=39680 $dt=16
M5455 VDD! 141 160 VDD! pfet_01v8 L=1.5e-07 W=1.13e-06 $X=159550 $Y=47960 $dt=16
M5456 VDD! 142 161 VDD! pfet_01v8 L=1.5e-07 W=1.13e-06 $X=159550 $Y=56240 $dt=16
M5457 VDD! 143 162 VDD! pfet_01v8 L=1.5e-07 W=1.13e-06 $X=159550 $Y=64520 $dt=16
M5458 VDD! 144 163 VDD! pfet_01v8 L=1.5e-07 W=1.13e-06 $X=159550 $Y=72800 $dt=16
M5459 VDD! 145 164 VDD! pfet_01v8 L=1.5e-07 W=1.13e-06 $X=159550 $Y=81080 $dt=16
M5460 VDD! 146 165 VDD! pfet_01v8 L=1.5e-07 W=1.13e-06 $X=159550 $Y=89360 $dt=16
M5461 VDD! 147 166 VDD! pfet_01v8 L=1.5e-07 W=1.13e-06 $X=159550 $Y=97640 $dt=16
M5462 VDD! 148 167 VDD! pfet_01v8 L=1.5e-07 W=1.13e-06 $X=159550 $Y=105920 $dt=16
M5463 VDD! 149 168 VDD! pfet_01v8 L=1.5e-07 W=1.13e-06 $X=159550 $Y=114200 $dt=16
M5464 VDD! 150 169 VDD! pfet_01v8 L=1.5e-07 W=1.13e-06 $X=159550 $Y=122480 $dt=16
M5465 VDD! 151 170 VDD! pfet_01v8 L=1.5e-07 W=1.13e-06 $X=159550 $Y=130760 $dt=16
M5466 VDD! 152 171 VDD! pfet_01v8 L=1.5e-07 W=1.13e-06 $X=159550 $Y=139040 $dt=16
M5467 VDD! 153 172 VDD! pfet_01v8 L=1.5e-07 W=1.13e-06 $X=159550 $Y=147320 $dt=16
M5468 VDD! 154 173 VDD! pfet_01v8 L=1.5e-07 W=1.13e-06 $X=159550 $Y=155600 $dt=16
M5469 VDD! 155 174 VDD! pfet_01v8 L=1.5e-07 W=1.13e-06 $X=159550 $Y=163880 $dt=16
M5470 137 99 VDD! VDD! pfet_01v8 L=1.5e-07 W=1.13e-06 $X=159980 $Y=14840 $dt=16
M5471 138 100 VDD! VDD! pfet_01v8 L=1.5e-07 W=1.13e-06 $X=159980 $Y=23120 $dt=16
M5472 139 101 VDD! VDD! pfet_01v8 L=1.5e-07 W=1.13e-06 $X=159980 $Y=31400 $dt=16
M5473 140 102 VDD! VDD! pfet_01v8 L=1.5e-07 W=1.13e-06 $X=159980 $Y=39680 $dt=16
M5474 141 103 VDD! VDD! pfet_01v8 L=1.5e-07 W=1.13e-06 $X=159980 $Y=47960 $dt=16
M5475 142 104 VDD! VDD! pfet_01v8 L=1.5e-07 W=1.13e-06 $X=159980 $Y=56240 $dt=16
M5476 143 105 VDD! VDD! pfet_01v8 L=1.5e-07 W=1.13e-06 $X=159980 $Y=64520 $dt=16
M5477 144 106 VDD! VDD! pfet_01v8 L=1.5e-07 W=1.13e-06 $X=159980 $Y=72800 $dt=16
M5478 145 107 VDD! VDD! pfet_01v8 L=1.5e-07 W=1.13e-06 $X=159980 $Y=81080 $dt=16
M5479 146 108 VDD! VDD! pfet_01v8 L=1.5e-07 W=1.13e-06 $X=159980 $Y=89360 $dt=16
M5480 147 109 VDD! VDD! pfet_01v8 L=1.5e-07 W=1.13e-06 $X=159980 $Y=97640 $dt=16
M5481 148 110 VDD! VDD! pfet_01v8 L=1.5e-07 W=1.13e-06 $X=159980 $Y=105920 $dt=16
M5482 149 111 VDD! VDD! pfet_01v8 L=1.5e-07 W=1.13e-06 $X=159980 $Y=114200 $dt=16
M5483 150 112 VDD! VDD! pfet_01v8 L=1.5e-07 W=1.13e-06 $X=159980 $Y=122480 $dt=16
M5484 151 113 VDD! VDD! pfet_01v8 L=1.5e-07 W=1.13e-06 $X=159980 $Y=130760 $dt=16
M5485 152 114 VDD! VDD! pfet_01v8 L=1.5e-07 W=1.13e-06 $X=159980 $Y=139040 $dt=16
M5486 153 115 VDD! VDD! pfet_01v8 L=1.5e-07 W=1.13e-06 $X=159980 $Y=147320 $dt=16
M5487 154 116 VDD! VDD! pfet_01v8 L=1.5e-07 W=1.13e-06 $X=159980 $Y=155600 $dt=16
M5488 155 117 VDD! VDD! pfet_01v8 L=1.5e-07 W=1.13e-06 $X=159980 $Y=163880 $dt=16
M5489 VDD! 80 118 VDD! pfet_01v8 L=1.5e-07 W=1.13e-06 $X=160900 $Y=8870 $dt=16
M5490 VDD! 81 119 VDD! pfet_01v8 L=1.5e-07 W=1.13e-06 $X=160900 $Y=17150 $dt=16
M5491 VDD! 82 120 VDD! pfet_01v8 L=1.5e-07 W=1.13e-06 $X=160900 $Y=25430 $dt=16
M5492 VDD! 83 121 VDD! pfet_01v8 L=1.5e-07 W=1.13e-06 $X=160900 $Y=33710 $dt=16
M5493 VDD! 84 122 VDD! pfet_01v8 L=1.5e-07 W=1.13e-06 $X=160900 $Y=41990 $dt=16
M5494 VDD! 85 123 VDD! pfet_01v8 L=1.5e-07 W=1.13e-06 $X=160900 $Y=50270 $dt=16
M5495 VDD! 86 124 VDD! pfet_01v8 L=1.5e-07 W=1.13e-06 $X=160900 $Y=58550 $dt=16
M5496 VDD! 87 125 VDD! pfet_01v8 L=1.5e-07 W=1.13e-06 $X=160900 $Y=66830 $dt=16
M5497 VDD! 88 126 VDD! pfet_01v8 L=1.5e-07 W=1.13e-06 $X=160900 $Y=75110 $dt=16
M5498 VDD! 89 127 VDD! pfet_01v8 L=1.5e-07 W=1.13e-06 $X=160900 $Y=83390 $dt=16
M5499 VDD! 90 128 VDD! pfet_01v8 L=1.5e-07 W=1.13e-06 $X=160900 $Y=91670 $dt=16
M5500 VDD! 91 129 VDD! pfet_01v8 L=1.5e-07 W=1.13e-06 $X=160900 $Y=99950 $dt=16
M5501 VDD! 92 130 VDD! pfet_01v8 L=1.5e-07 W=1.13e-06 $X=160900 $Y=108230 $dt=16
M5502 VDD! 93 131 VDD! pfet_01v8 L=1.5e-07 W=1.13e-06 $X=160900 $Y=116510 $dt=16
M5503 VDD! 94 132 VDD! pfet_01v8 L=1.5e-07 W=1.13e-06 $X=160900 $Y=124790 $dt=16
M5504 VDD! 95 133 VDD! pfet_01v8 L=1.5e-07 W=1.13e-06 $X=160900 $Y=133070 $dt=16
M5505 VDD! 96 134 VDD! pfet_01v8 L=1.5e-07 W=1.13e-06 $X=160900 $Y=141350 $dt=16
M5506 VDD! 97 135 VDD! pfet_01v8 L=1.5e-07 W=1.13e-06 $X=160900 $Y=149630 $dt=16
M5507 VDD! 98 136 VDD! pfet_01v8 L=1.5e-07 W=1.13e-06 $X=160900 $Y=157910 $dt=16
M5508 VDD! 61 99 VDD! pfet_01v8 L=1.5e-07 W=1.13e-06 $X=161360 $Y=14840 $dt=16
M5509 VDD! 62 100 VDD! pfet_01v8 L=1.5e-07 W=1.13e-06 $X=161360 $Y=23120 $dt=16
M5510 VDD! 63 101 VDD! pfet_01v8 L=1.5e-07 W=1.13e-06 $X=161360 $Y=31400 $dt=16
M5511 VDD! 64 102 VDD! pfet_01v8 L=1.5e-07 W=1.13e-06 $X=161360 $Y=39680 $dt=16
M5512 VDD! 65 103 VDD! pfet_01v8 L=1.5e-07 W=1.13e-06 $X=161360 $Y=47960 $dt=16
M5513 VDD! 66 104 VDD! pfet_01v8 L=1.5e-07 W=1.13e-06 $X=161360 $Y=56240 $dt=16
M5514 VDD! 67 105 VDD! pfet_01v8 L=1.5e-07 W=1.13e-06 $X=161360 $Y=64520 $dt=16
M5515 VDD! 68 106 VDD! pfet_01v8 L=1.5e-07 W=1.13e-06 $X=161360 $Y=72800 $dt=16
M5516 VDD! 69 107 VDD! pfet_01v8 L=1.5e-07 W=1.13e-06 $X=161360 $Y=81080 $dt=16
M5517 VDD! 70 108 VDD! pfet_01v8 L=1.5e-07 W=1.13e-06 $X=161360 $Y=89360 $dt=16
M5518 VDD! 71 109 VDD! pfet_01v8 L=1.5e-07 W=1.13e-06 $X=161360 $Y=97640 $dt=16
M5519 VDD! 72 110 VDD! pfet_01v8 L=1.5e-07 W=1.13e-06 $X=161360 $Y=105920 $dt=16
M5520 VDD! 73 111 VDD! pfet_01v8 L=1.5e-07 W=1.13e-06 $X=161360 $Y=114200 $dt=16
M5521 VDD! 74 112 VDD! pfet_01v8 L=1.5e-07 W=1.13e-06 $X=161360 $Y=122480 $dt=16
M5522 VDD! 75 113 VDD! pfet_01v8 L=1.5e-07 W=1.13e-06 $X=161360 $Y=130760 $dt=16
M5523 VDD! 76 114 VDD! pfet_01v8 L=1.5e-07 W=1.13e-06 $X=161360 $Y=139040 $dt=16
M5524 VDD! 77 115 VDD! pfet_01v8 L=1.5e-07 W=1.13e-06 $X=161360 $Y=147320 $dt=16
M5525 VDD! 78 116 VDD! pfet_01v8 L=1.5e-07 W=1.13e-06 $X=161360 $Y=155600 $dt=16
M5526 VDD! 79 117 VDD! pfet_01v8 L=1.5e-07 W=1.13e-06 $X=161360 $Y=163880 $dt=16
M5527 80 VREF_SEL_8<27> VDD! VDD! pfet_01v8 L=1.5e-07 W=6.25e-07 $X=161390 $Y=8870 $dt=16
M5528 81 VREF_SEL_8<26> VDD! VDD! pfet_01v8 L=1.5e-07 W=6.25e-07 $X=161390 $Y=17150 $dt=16
M5529 82 VREF_SEL_8<25> VDD! VDD! pfet_01v8 L=1.5e-07 W=6.25e-07 $X=161390 $Y=25430 $dt=16
M5530 83 VREF_SEL_8<24> VDD! VDD! pfet_01v8 L=1.5e-07 W=6.25e-07 $X=161390 $Y=33710 $dt=16
M5531 84 VREF_SEL_8<23> VDD! VDD! pfet_01v8 L=1.5e-07 W=6.25e-07 $X=161390 $Y=41990 $dt=16
M5532 85 VREF_SEL_8<22> VDD! VDD! pfet_01v8 L=1.5e-07 W=6.25e-07 $X=161390 $Y=50270 $dt=16
M5533 86 VREF_SEL_8<21> VDD! VDD! pfet_01v8 L=1.5e-07 W=6.25e-07 $X=161390 $Y=58550 $dt=16
M5534 87 VREF_SEL_4<6> VDD! VDD! pfet_01v8 L=1.5e-07 W=6.25e-07 $X=161390 $Y=66830 $dt=16
M5535 88 VREF_SEL_4<5> VDD! VDD! pfet_01v8 L=1.5e-07 W=6.25e-07 $X=161390 $Y=75110 $dt=16
M5536 89 VREF_SEL_1<1> VDD! VDD! pfet_01v8 L=1.5e-07 W=6.25e-07 $X=161390 $Y=83390 $dt=16
M5537 90 VREF_SEL_2 VDD! VDD! pfet_01v8 L=1.5e-07 W=6.25e-07 $X=161390 $Y=91670 $dt=16
M5538 91 VREF_SEL_4<4> VDD! VDD! pfet_01v8 L=1.5e-07 W=6.25e-07 $X=161390 $Y=99950 $dt=16
M5539 92 VREF_SEL_8<20> VDD! VDD! pfet_01v8 L=1.5e-07 W=6.25e-07 $X=161390 $Y=108230 $dt=16
M5540 93 VREF_SEL_8<19> VDD! VDD! pfet_01v8 L=1.5e-07 W=6.25e-07 $X=161390 $Y=116510 $dt=16
M5541 94 VREF_SEL_8<18> VDD! VDD! pfet_01v8 L=1.5e-07 W=6.25e-07 $X=161390 $Y=124790 $dt=16
M5542 95 VREF_SEL_8<17> VDD! VDD! pfet_01v8 L=1.5e-07 W=6.25e-07 $X=161390 $Y=133070 $dt=16
M5543 96 VREF_SEL_8<16> VDD! VDD! pfet_01v8 L=1.5e-07 W=6.25e-07 $X=161390 $Y=141350 $dt=16
M5544 97 VREF_SEL_8<15> VDD! VDD! pfet_01v8 L=1.5e-07 W=6.25e-07 $X=161390 $Y=149630 $dt=16
M5545 98 VREF_SEL_8<14> VDD! VDD! pfet_01v8 L=1.5e-07 W=6.25e-07 $X=161390 $Y=157910 $dt=16
M5546 VDD! SAMPLE 80 VDD! pfet_01v8 L=1.5e-07 W=6.25e-07 $X=161820 $Y=8870 $dt=16
M5547 VDD! SAMPLE 81 VDD! pfet_01v8 L=1.5e-07 W=6.25e-07 $X=161820 $Y=17150 $dt=16
M5548 VDD! SAMPLE 82 VDD! pfet_01v8 L=1.5e-07 W=6.25e-07 $X=161820 $Y=25430 $dt=16
M5549 VDD! SAMPLE 83 VDD! pfet_01v8 L=1.5e-07 W=6.25e-07 $X=161820 $Y=33710 $dt=16
M5550 VDD! SAMPLE 84 VDD! pfet_01v8 L=1.5e-07 W=6.25e-07 $X=161820 $Y=41990 $dt=16
M5551 VDD! SAMPLE 85 VDD! pfet_01v8 L=1.5e-07 W=6.25e-07 $X=161820 $Y=50270 $dt=16
M5552 VDD! SAMPLE 86 VDD! pfet_01v8 L=1.5e-07 W=6.25e-07 $X=161820 $Y=58550 $dt=16
M5553 VDD! SAMPLE 87 VDD! pfet_01v8 L=1.5e-07 W=6.25e-07 $X=161820 $Y=66830 $dt=16
M5554 VDD! SAMPLE 88 VDD! pfet_01v8 L=1.5e-07 W=6.25e-07 $X=161820 $Y=75110 $dt=16
M5555 VDD! SAMPLE 89 VDD! pfet_01v8 L=1.5e-07 W=6.25e-07 $X=161820 $Y=83390 $dt=16
M5556 VDD! SAMPLE 90 VDD! pfet_01v8 L=1.5e-07 W=6.25e-07 $X=161820 $Y=91670 $dt=16
M5557 VDD! SAMPLE 91 VDD! pfet_01v8 L=1.5e-07 W=6.25e-07 $X=161820 $Y=99950 $dt=16
M5558 VDD! SAMPLE 92 VDD! pfet_01v8 L=1.5e-07 W=6.25e-07 $X=161820 $Y=108230 $dt=16
M5559 VDD! SAMPLE 93 VDD! pfet_01v8 L=1.5e-07 W=6.25e-07 $X=161820 $Y=116510 $dt=16
M5560 VDD! SAMPLE 94 VDD! pfet_01v8 L=1.5e-07 W=6.25e-07 $X=161820 $Y=124790 $dt=16
M5561 VDD! SAMPLE 95 VDD! pfet_01v8 L=1.5e-07 W=6.25e-07 $X=161820 $Y=133070 $dt=16
M5562 VDD! SAMPLE 96 VDD! pfet_01v8 L=1.5e-07 W=6.25e-07 $X=161820 $Y=141350 $dt=16
M5563 VDD! SAMPLE 97 VDD! pfet_01v8 L=1.5e-07 W=6.25e-07 $X=161820 $Y=149630 $dt=16
M5564 VDD! SAMPLE 98 VDD! pfet_01v8 L=1.5e-07 W=6.25e-07 $X=161820 $Y=157910 $dt=16
M5565 61 VREF_SEL_8<27> VDD! VDD! pfet_01v8 L=1.5e-07 W=6.25e-07 $X=161850 $Y=15345 $dt=16
M5566 62 VREF_SEL_8<26> VDD! VDD! pfet_01v8 L=1.5e-07 W=6.25e-07 $X=161850 $Y=23625 $dt=16
M5567 63 VREF_SEL_8<25> VDD! VDD! pfet_01v8 L=1.5e-07 W=6.25e-07 $X=161850 $Y=31905 $dt=16
M5568 64 VREF_SEL_8<24> VDD! VDD! pfet_01v8 L=1.5e-07 W=6.25e-07 $X=161850 $Y=40185 $dt=16
M5569 65 VREF_SEL_8<23> VDD! VDD! pfet_01v8 L=1.5e-07 W=6.25e-07 $X=161850 $Y=48465 $dt=16
M5570 66 VREF_SEL_8<22> VDD! VDD! pfet_01v8 L=1.5e-07 W=6.25e-07 $X=161850 $Y=56745 $dt=16
M5571 67 VREF_SEL_8<21> VDD! VDD! pfet_01v8 L=1.5e-07 W=6.25e-07 $X=161850 $Y=65025 $dt=16
M5572 68 VREF_SEL_4<6> VDD! VDD! pfet_01v8 L=1.5e-07 W=6.25e-07 $X=161850 $Y=73305 $dt=16
M5573 69 VREF_SEL_4<5> VDD! VDD! pfet_01v8 L=1.5e-07 W=6.25e-07 $X=161850 $Y=81585 $dt=16
M5574 70 VREF_SEL_1<1> VDD! VDD! pfet_01v8 L=1.5e-07 W=6.25e-07 $X=161850 $Y=89865 $dt=16
M5575 71 VREF_SEL_2 VDD! VDD! pfet_01v8 L=1.5e-07 W=6.25e-07 $X=161850 $Y=98145 $dt=16
M5576 72 VREF_SEL_4<4> VDD! VDD! pfet_01v8 L=1.5e-07 W=6.25e-07 $X=161850 $Y=106425 $dt=16
M5577 73 VREF_SEL_8<20> VDD! VDD! pfet_01v8 L=1.5e-07 W=6.25e-07 $X=161850 $Y=114705 $dt=16
M5578 74 VREF_SEL_8<19> VDD! VDD! pfet_01v8 L=1.5e-07 W=6.25e-07 $X=161850 $Y=122985 $dt=16
M5579 75 VREF_SEL_8<18> VDD! VDD! pfet_01v8 L=1.5e-07 W=6.25e-07 $X=161850 $Y=131265 $dt=16
M5580 76 VREF_SEL_8<17> VDD! VDD! pfet_01v8 L=1.5e-07 W=6.25e-07 $X=161850 $Y=139545 $dt=16
M5581 77 VREF_SEL_8<16> VDD! VDD! pfet_01v8 L=1.5e-07 W=6.25e-07 $X=161850 $Y=147825 $dt=16
M5582 78 VREF_SEL_8<15> VDD! VDD! pfet_01v8 L=1.5e-07 W=6.25e-07 $X=161850 $Y=156105 $dt=16
M5583 79 VREF_SEL_8<14> VDD! VDD! pfet_01v8 L=1.5e-07 W=6.25e-07 $X=161850 $Y=164385 $dt=16
M5584 VDD! 4 61 VDD! pfet_01v8 L=1.5e-07 W=6.25e-07 $X=162280 $Y=15345 $dt=16
M5585 VDD! 5 62 VDD! pfet_01v8 L=1.5e-07 W=6.25e-07 $X=162280 $Y=23625 $dt=16
M5586 VDD! 6 63 VDD! pfet_01v8 L=1.5e-07 W=6.25e-07 $X=162280 $Y=31905 $dt=16
M5587 VDD! 7 64 VDD! pfet_01v8 L=1.5e-07 W=6.25e-07 $X=162280 $Y=40185 $dt=16
M5588 VDD! 8 65 VDD! pfet_01v8 L=1.5e-07 W=6.25e-07 $X=162280 $Y=48465 $dt=16
M5589 VDD! 9 66 VDD! pfet_01v8 L=1.5e-07 W=6.25e-07 $X=162280 $Y=56745 $dt=16
M5590 VDD! 10 67 VDD! pfet_01v8 L=1.5e-07 W=6.25e-07 $X=162280 $Y=65025 $dt=16
M5591 VDD! 11 68 VDD! pfet_01v8 L=1.5e-07 W=6.25e-07 $X=162280 $Y=73305 $dt=16
M5592 VDD! 12 69 VDD! pfet_01v8 L=1.5e-07 W=6.25e-07 $X=162280 $Y=81585 $dt=16
M5593 VDD! 13 70 VDD! pfet_01v8 L=1.5e-07 W=6.25e-07 $X=162280 $Y=89865 $dt=16
M5594 VDD! 14 71 VDD! pfet_01v8 L=1.5e-07 W=6.25e-07 $X=162280 $Y=98145 $dt=16
M5595 VDD! 15 72 VDD! pfet_01v8 L=1.5e-07 W=6.25e-07 $X=162280 $Y=106425 $dt=16
M5596 VDD! 16 73 VDD! pfet_01v8 L=1.5e-07 W=6.25e-07 $X=162280 $Y=114705 $dt=16
M5597 VDD! 17 74 VDD! pfet_01v8 L=1.5e-07 W=6.25e-07 $X=162280 $Y=122985 $dt=16
M5598 VDD! 18 75 VDD! pfet_01v8 L=1.5e-07 W=6.25e-07 $X=162280 $Y=131265 $dt=16
M5599 VDD! 19 76 VDD! pfet_01v8 L=1.5e-07 W=6.25e-07 $X=162280 $Y=139545 $dt=16
M5600 VDD! 20 77 VDD! pfet_01v8 L=1.5e-07 W=6.25e-07 $X=162280 $Y=147825 $dt=16
M5601 VDD! 21 78 VDD! pfet_01v8 L=1.5e-07 W=6.25e-07 $X=162280 $Y=156105 $dt=16
M5602 VDD! 22 79 VDD! pfet_01v8 L=1.5e-07 W=6.25e-07 $X=162280 $Y=164385 $dt=16
M5603 872 VREF_SEL_8<27> 23 VDD! pfet_01v8 L=1.5e-07 W=1.13e-06 $X=163150 $Y=8870 $dt=16
M5604 873 VREF_SEL_8<26> 24 VDD! pfet_01v8 L=1.5e-07 W=1.13e-06 $X=163150 $Y=17150 $dt=16
M5605 874 VREF_SEL_8<25> 25 VDD! pfet_01v8 L=1.5e-07 W=1.13e-06 $X=163150 $Y=25430 $dt=16
M5606 875 VREF_SEL_8<24> 26 VDD! pfet_01v8 L=1.5e-07 W=1.13e-06 $X=163150 $Y=33710 $dt=16
M5607 876 VREF_SEL_8<23> 27 VDD! pfet_01v8 L=1.5e-07 W=1.13e-06 $X=163150 $Y=41990 $dt=16
M5608 877 VREF_SEL_8<22> 28 VDD! pfet_01v8 L=1.5e-07 W=1.13e-06 $X=163150 $Y=50270 $dt=16
M5609 878 VREF_SEL_8<21> 29 VDD! pfet_01v8 L=1.5e-07 W=1.13e-06 $X=163150 $Y=58550 $dt=16
M5610 879 VREF_SEL_4<6> 30 VDD! pfet_01v8 L=1.5e-07 W=1.13e-06 $X=163150 $Y=66830 $dt=16
M5611 880 VREF_SEL_4<5> 31 VDD! pfet_01v8 L=1.5e-07 W=1.13e-06 $X=163150 $Y=75110 $dt=16
M5612 881 VREF_SEL_1<1> 32 VDD! pfet_01v8 L=1.5e-07 W=1.13e-06 $X=163150 $Y=83390 $dt=16
M5613 882 VREF_SEL_2 33 VDD! pfet_01v8 L=1.5e-07 W=1.13e-06 $X=163150 $Y=91670 $dt=16
M5614 883 VREF_SEL_4<4> 34 VDD! pfet_01v8 L=1.5e-07 W=1.13e-06 $X=163150 $Y=99950 $dt=16
M5615 884 VREF_SEL_8<20> 35 VDD! pfet_01v8 L=1.5e-07 W=1.13e-06 $X=163150 $Y=108230 $dt=16
M5616 885 VREF_SEL_8<19> 36 VDD! pfet_01v8 L=1.5e-07 W=1.13e-06 $X=163150 $Y=116510 $dt=16
M5617 886 VREF_SEL_8<18> 37 VDD! pfet_01v8 L=1.5e-07 W=1.13e-06 $X=163150 $Y=124790 $dt=16
M5618 887 VREF_SEL_8<17> 38 VDD! pfet_01v8 L=1.5e-07 W=1.13e-06 $X=163150 $Y=133070 $dt=16
M5619 888 VREF_SEL_8<16> 39 VDD! pfet_01v8 L=1.5e-07 W=1.13e-06 $X=163150 $Y=141350 $dt=16
M5620 889 VREF_SEL_8<15> 40 VDD! pfet_01v8 L=1.5e-07 W=1.13e-06 $X=163150 $Y=149630 $dt=16
M5621 890 VREF_SEL_8<14> 41 VDD! pfet_01v8 L=1.5e-07 W=1.13e-06 $X=163150 $Y=157910 $dt=16
M5622 VDD! SAMPLE 872 VDD! pfet_01v8 L=1.5e-07 W=1.13e-06 $X=163620 $Y=8870 $dt=16
M5623 VDD! SAMPLE 873 VDD! pfet_01v8 L=1.5e-07 W=1.13e-06 $X=163620 $Y=17150 $dt=16
M5624 VDD! SAMPLE 874 VDD! pfet_01v8 L=1.5e-07 W=1.13e-06 $X=163620 $Y=25430 $dt=16
M5625 VDD! SAMPLE 875 VDD! pfet_01v8 L=1.5e-07 W=1.13e-06 $X=163620 $Y=33710 $dt=16
M5626 VDD! SAMPLE 876 VDD! pfet_01v8 L=1.5e-07 W=1.13e-06 $X=163620 $Y=41990 $dt=16
M5627 VDD! SAMPLE 877 VDD! pfet_01v8 L=1.5e-07 W=1.13e-06 $X=163620 $Y=50270 $dt=16
M5628 VDD! SAMPLE 878 VDD! pfet_01v8 L=1.5e-07 W=1.13e-06 $X=163620 $Y=58550 $dt=16
M5629 VDD! SAMPLE 879 VDD! pfet_01v8 L=1.5e-07 W=1.13e-06 $X=163620 $Y=66830 $dt=16
M5630 VDD! SAMPLE 880 VDD! pfet_01v8 L=1.5e-07 W=1.13e-06 $X=163620 $Y=75110 $dt=16
M5631 VDD! SAMPLE 881 VDD! pfet_01v8 L=1.5e-07 W=1.13e-06 $X=163620 $Y=83390 $dt=16
M5632 VDD! SAMPLE 882 VDD! pfet_01v8 L=1.5e-07 W=1.13e-06 $X=163620 $Y=91670 $dt=16
M5633 VDD! SAMPLE 883 VDD! pfet_01v8 L=1.5e-07 W=1.13e-06 $X=163620 $Y=99950 $dt=16
M5634 VDD! SAMPLE 884 VDD! pfet_01v8 L=1.5e-07 W=1.13e-06 $X=163620 $Y=108230 $dt=16
M5635 VDD! SAMPLE 885 VDD! pfet_01v8 L=1.5e-07 W=1.13e-06 $X=163620 $Y=116510 $dt=16
M5636 VDD! SAMPLE 886 VDD! pfet_01v8 L=1.5e-07 W=1.13e-06 $X=163620 $Y=124790 $dt=16
M5637 VDD! SAMPLE 887 VDD! pfet_01v8 L=1.5e-07 W=1.13e-06 $X=163620 $Y=133070 $dt=16
M5638 VDD! SAMPLE 888 VDD! pfet_01v8 L=1.5e-07 W=1.13e-06 $X=163620 $Y=141350 $dt=16
M5639 VDD! SAMPLE 889 VDD! pfet_01v8 L=1.5e-07 W=1.13e-06 $X=163620 $Y=149630 $dt=16
M5640 VDD! SAMPLE 890 VDD! pfet_01v8 L=1.5e-07 W=1.13e-06 $X=163620 $Y=157910 $dt=16
M5641 VDD! SAMPLE 4 VDD! pfet_01v8 L=1.5e-07 W=1.13e-06 $X=163660 $Y=14840 $dt=16
M5642 VDD! SAMPLE 5 VDD! pfet_01v8 L=1.5e-07 W=1.13e-06 $X=163660 $Y=23120 $dt=16
M5643 VDD! SAMPLE 6 VDD! pfet_01v8 L=1.5e-07 W=1.13e-06 $X=163660 $Y=31400 $dt=16
M5644 VDD! SAMPLE 7 VDD! pfet_01v8 L=1.5e-07 W=1.13e-06 $X=163660 $Y=39680 $dt=16
M5645 VDD! SAMPLE 8 VDD! pfet_01v8 L=1.5e-07 W=1.13e-06 $X=163660 $Y=47960 $dt=16
M5646 VDD! SAMPLE 9 VDD! pfet_01v8 L=1.5e-07 W=1.13e-06 $X=163660 $Y=56240 $dt=16
M5647 VDD! SAMPLE 10 VDD! pfet_01v8 L=1.5e-07 W=1.13e-06 $X=163660 $Y=64520 $dt=16
M5648 VDD! SAMPLE 11 VDD! pfet_01v8 L=1.5e-07 W=1.13e-06 $X=163660 $Y=72800 $dt=16
M5649 VDD! SAMPLE 12 VDD! pfet_01v8 L=1.5e-07 W=1.13e-06 $X=163660 $Y=81080 $dt=16
M5650 VDD! SAMPLE 13 VDD! pfet_01v8 L=1.5e-07 W=1.13e-06 $X=163660 $Y=89360 $dt=16
M5651 VDD! SAMPLE 14 VDD! pfet_01v8 L=1.5e-07 W=1.13e-06 $X=163660 $Y=97640 $dt=16
M5652 VDD! SAMPLE 15 VDD! pfet_01v8 L=1.5e-07 W=1.13e-06 $X=163660 $Y=105920 $dt=16
M5653 VDD! SAMPLE 16 VDD! pfet_01v8 L=1.5e-07 W=1.13e-06 $X=163660 $Y=114200 $dt=16
M5654 VDD! SAMPLE 17 VDD! pfet_01v8 L=1.5e-07 W=1.13e-06 $X=163660 $Y=122480 $dt=16
M5655 VDD! SAMPLE 18 VDD! pfet_01v8 L=1.5e-07 W=1.13e-06 $X=163660 $Y=130760 $dt=16
M5656 VDD! SAMPLE 19 VDD! pfet_01v8 L=1.5e-07 W=1.13e-06 $X=163660 $Y=139040 $dt=16
M5657 VDD! SAMPLE 20 VDD! pfet_01v8 L=1.5e-07 W=1.13e-06 $X=163660 $Y=147320 $dt=16
M5658 VDD! SAMPLE 21 VDD! pfet_01v8 L=1.5e-07 W=1.13e-06 $X=163660 $Y=155600 $dt=16
M5659 VDD! SAMPLE 22 VDD! pfet_01v8 L=1.5e-07 W=1.13e-06 $X=163660 $Y=163880 $dt=16
C5660 VDD! VSS! L=4e-06 W=4e-06 $[cap_mim_m3__base] $X=10705 $Y=2140 $dt=40
C5661 VDD! VSS! L=4e-06 W=4e-06 $[cap_mim_m3__base] $X=10705 $Y=10420 $dt=40
C5662 VDD! VSS! L=4e-06 W=4e-06 $[cap_mim_m3__base] $X=10705 $Y=18700 $dt=40
C5663 VDD! VSS! L=4e-06 W=4e-06 $[cap_mim_m3__base] $X=10705 $Y=26980 $dt=40
C5664 VDD! VSS! L=4e-06 W=4e-06 $[cap_mim_m3__base] $X=10705 $Y=35260 $dt=40
C5665 VDD! VSS! L=4e-06 W=4e-06 $[cap_mim_m3__base] $X=10705 $Y=43540 $dt=40
C5666 VDD! VSS! L=4e-06 W=4e-06 $[cap_mim_m3__base] $X=10705 $Y=51820 $dt=40
C5667 VDD! VSS! L=4e-06 W=4e-06 $[cap_mim_m3__base] $X=10705 $Y=60100 $dt=40
C5668 VDD! VSS! L=4e-06 W=4e-06 $[cap_mim_m3__base] $X=10705 $Y=68380 $dt=40
C5669 VDD! VSS! L=4e-06 W=4e-06 $[cap_mim_m3__base] $X=10705 $Y=76660 $dt=40
C5670 VDD! VSS! L=4e-06 W=4e-06 $[cap_mim_m3__base] $X=10705 $Y=84940 $dt=40
C5671 VDD! VSS! L=4e-06 W=4e-06 $[cap_mim_m3__base] $X=10705 $Y=93220 $dt=40
C5672 VDD! VSS! L=4e-06 W=4e-06 $[cap_mim_m3__base] $X=10705 $Y=101500 $dt=40
C5673 VDD! VSS! L=4e-06 W=4e-06 $[cap_mim_m3__base] $X=10705 $Y=109780 $dt=40
C5674 VDD! VSS! L=4e-06 W=4e-06 $[cap_mim_m3__base] $X=10705 $Y=118060 $dt=40
C5675 VDD! VSS! L=4e-06 W=4e-06 $[cap_mim_m3__base] $X=10705 $Y=126340 $dt=40
C5676 VDD! VSS! L=4e-06 W=4e-06 $[cap_mim_m3__base] $X=10705 $Y=134620 $dt=40
C5677 VDD! VSS! L=4e-06 W=4e-06 $[cap_mim_m3__base] $X=10705 $Y=142900 $dt=40
C5678 VDD! VSS! L=4e-06 W=4e-06 $[cap_mim_m3__base] $X=10705 $Y=151180 $dt=40
C5679 VDD! VSS! L=4e-06 W=4e-06 $[cap_mim_m3__base] $X=10705 $Y=159460 $dt=40
C5680 VDD! VSS! L=4e-06 W=4e-06 $[cap_mim_m3__base] $X=10705 $Y=167740 $dt=40
C5681 VREF_N VSS! L=4e-06 W=4e-06 $[cap_mim_m3__base] $X=18985 $Y=2140 $dt=40
C5682 TOP_PLATE 667 L=4e-06 W=4e-06 $[cap_mim_m3__base] $X=18985 $Y=10420 $dt=40
C5683 TOP_PLATE 668 L=4e-06 W=4e-06 $[cap_mim_m3__base] $X=18985 $Y=18700 $dt=40
C5684 TOP_PLATE 669 L=4e-06 W=4e-06 $[cap_mim_m3__base] $X=18985 $Y=26980 $dt=40
C5685 TOP_PLATE 670 L=4e-06 W=4e-06 $[cap_mim_m3__base] $X=18985 $Y=35260 $dt=40
C5686 TOP_PLATE 671 L=4e-06 W=4e-06 $[cap_mim_m3__base] $X=18985 $Y=43540 $dt=40
C5687 TOP_PLATE 672 L=4e-06 W=4e-06 $[cap_mim_m3__base] $X=18985 $Y=51820 $dt=40
C5688 TOP_PLATE 673 L=4e-06 W=4e-06 $[cap_mim_m3__base] $X=18985 $Y=60100 $dt=40
C5689 VREF_P VREF_N L=4e-06 W=4e-06 $[cap_mim_m3__base] $X=18985 $Y=68380 $dt=40
C5690 VREF_N VREF_P L=4e-06 W=4e-06 $[cap_mim_m3__base] $X=18985 $Y=76660 $dt=40
C5691 VREF_P VREF_N L=4e-06 W=4e-06 $[cap_mim_m3__base] $X=18985 $Y=84940 $dt=40
C5692 VREF_N VREF_P L=4e-06 W=4e-06 $[cap_mim_m3__base] $X=18985 $Y=93220 $dt=40
C5693 VREF_P VREF_N L=4e-06 W=4e-06 $[cap_mim_m3__base] $X=18985 $Y=101500 $dt=40
C5694 TOP_PLATE 674 L=4e-06 W=4e-06 $[cap_mim_m3__base] $X=18985 $Y=109780 $dt=40
C5695 TOP_PLATE 675 L=4e-06 W=4e-06 $[cap_mim_m3__base] $X=18985 $Y=118060 $dt=40
C5696 TOP_PLATE 676 L=4e-06 W=4e-06 $[cap_mim_m3__base] $X=18985 $Y=126340 $dt=40
C5697 TOP_PLATE 677 L=4e-06 W=4e-06 $[cap_mim_m3__base] $X=18985 $Y=134620 $dt=40
C5698 TOP_PLATE 678 L=4e-06 W=4e-06 $[cap_mim_m3__base] $X=18985 $Y=142900 $dt=40
C5699 TOP_PLATE 679 L=4e-06 W=4e-06 $[cap_mim_m3__base] $X=18985 $Y=151180 $dt=40
C5700 TOP_PLATE 680 L=4e-06 W=4e-06 $[cap_mim_m3__base] $X=18985 $Y=159460 $dt=40
C5701 VREF_P VSS! L=4e-06 W=4e-06 $[cap_mim_m3__base] $X=18985 $Y=167740 $dt=40
C5702 VREF_P VSS! L=4e-06 W=4e-06 $[cap_mim_m3__base] $X=27265 $Y=2140 $dt=40
C5703 TOP_PLATE 653 L=4e-06 W=4e-06 $[cap_mim_m3__base] $X=27265 $Y=10420 $dt=40
C5704 TOP_PLATE 654 L=4e-06 W=4e-06 $[cap_mim_m3__base] $X=27265 $Y=18700 $dt=40
C5705 TOP_PLATE 655 L=4e-06 W=4e-06 $[cap_mim_m3__base] $X=27265 $Y=26980 $dt=40
C5706 TOP_PLATE 656 L=4e-06 W=4e-06 $[cap_mim_m3__base] $X=27265 $Y=35260 $dt=40
C5707 TOP_PLATE 657 L=4e-06 W=4e-06 $[cap_mim_m3__base] $X=27265 $Y=43540 $dt=40
C5708 TOP_PLATE 658 L=4e-06 W=4e-06 $[cap_mim_m3__base] $X=27265 $Y=51820 $dt=40
C5709 TOP_PLATE 659 L=4e-06 W=4e-06 $[cap_mim_m3__base] $X=27265 $Y=60100 $dt=40
C5710 VREF_N VREF_P L=4e-06 W=4e-06 $[cap_mim_m3__base] $X=27265 $Y=68380 $dt=40
C5711 VREF_P VREF_N L=4e-06 W=4e-06 $[cap_mim_m3__base] $X=27265 $Y=76660 $dt=40
C5712 VREF_N VREF_P L=4e-06 W=4e-06 $[cap_mim_m3__base] $X=27265 $Y=84940 $dt=40
C5713 VREF_P VREF_N L=4e-06 W=4e-06 $[cap_mim_m3__base] $X=27265 $Y=93220 $dt=40
C5714 VREF_N VREF_P L=4e-06 W=4e-06 $[cap_mim_m3__base] $X=27265 $Y=101500 $dt=40
C5715 TOP_PLATE 660 L=4e-06 W=4e-06 $[cap_mim_m3__base] $X=27265 $Y=109780 $dt=40
C5716 TOP_PLATE 661 L=4e-06 W=4e-06 $[cap_mim_m3__base] $X=27265 $Y=118060 $dt=40
C5717 TOP_PLATE 662 L=4e-06 W=4e-06 $[cap_mim_m3__base] $X=27265 $Y=126340 $dt=40
C5718 TOP_PLATE 663 L=4e-06 W=4e-06 $[cap_mim_m3__base] $X=27265 $Y=134620 $dt=40
C5719 TOP_PLATE 664 L=4e-06 W=4e-06 $[cap_mim_m3__base] $X=27265 $Y=142900 $dt=40
C5720 TOP_PLATE 665 L=4e-06 W=4e-06 $[cap_mim_m3__base] $X=27265 $Y=151180 $dt=40
C5721 TOP_PLATE 666 L=4e-06 W=4e-06 $[cap_mim_m3__base] $X=27265 $Y=159460 $dt=40
C5722 VREF_N VSS! L=4e-06 W=4e-06 $[cap_mim_m3__base] $X=27265 $Y=167740 $dt=40
C5723 VREF_N VSS! L=4e-06 W=4e-06 $[cap_mim_m3__base] $X=35545 $Y=2140 $dt=40
C5724 TOP_PLATE 639 L=4e-06 W=4e-06 $[cap_mim_m3__base] $X=35545 $Y=10420 $dt=40
C5725 TOP_PLATE 640 L=4e-06 W=4e-06 $[cap_mim_m3__base] $X=35545 $Y=18700 $dt=40
C5726 TOP_PLATE 641 L=4e-06 W=4e-06 $[cap_mim_m3__base] $X=35545 $Y=26980 $dt=40
C5727 TOP_PLATE 642 L=4e-06 W=4e-06 $[cap_mim_m3__base] $X=35545 $Y=35260 $dt=40
C5728 TOP_PLATE 643 L=4e-06 W=4e-06 $[cap_mim_m3__base] $X=35545 $Y=43540 $dt=40
C5729 TOP_PLATE 644 L=4e-06 W=4e-06 $[cap_mim_m3__base] $X=35545 $Y=51820 $dt=40
C5730 TOP_PLATE 645 L=4e-06 W=4e-06 $[cap_mim_m3__base] $X=35545 $Y=60100 $dt=40
C5731 VREF_P VREF_N L=4e-06 W=4e-06 $[cap_mim_m3__base] $X=35545 $Y=68380 $dt=40
C5732 VREF_N VREF_P L=4e-06 W=4e-06 $[cap_mim_m3__base] $X=35545 $Y=76660 $dt=40
C5733 VREF_P VREF_N L=4e-06 W=4e-06 $[cap_mim_m3__base] $X=35545 $Y=84940 $dt=40
C5734 VREF_N VREF_P L=4e-06 W=4e-06 $[cap_mim_m3__base] $X=35545 $Y=93220 $dt=40
C5735 VREF_P VREF_N L=4e-06 W=4e-06 $[cap_mim_m3__base] $X=35545 $Y=101500 $dt=40
C5736 TOP_PLATE 646 L=4e-06 W=4e-06 $[cap_mim_m3__base] $X=35545 $Y=109780 $dt=40
C5737 TOP_PLATE 647 L=4e-06 W=4e-06 $[cap_mim_m3__base] $X=35545 $Y=118060 $dt=40
C5738 TOP_PLATE 648 L=4e-06 W=4e-06 $[cap_mim_m3__base] $X=35545 $Y=126340 $dt=40
C5739 TOP_PLATE 649 L=4e-06 W=4e-06 $[cap_mim_m3__base] $X=35545 $Y=134620 $dt=40
C5740 TOP_PLATE 650 L=4e-06 W=4e-06 $[cap_mim_m3__base] $X=35545 $Y=142900 $dt=40
C5741 TOP_PLATE 651 L=4e-06 W=4e-06 $[cap_mim_m3__base] $X=35545 $Y=151180 $dt=40
C5742 TOP_PLATE 652 L=4e-06 W=4e-06 $[cap_mim_m3__base] $X=35545 $Y=159460 $dt=40
C5743 VREF_P VSS! L=4e-06 W=4e-06 $[cap_mim_m3__base] $X=35545 $Y=167740 $dt=40
C5744 VREF_P VSS! L=4e-06 W=4e-06 $[cap_mim_m3__base] $X=43825 $Y=2140 $dt=40
C5745 TOP_PLATE 625 L=4e-06 W=4e-06 $[cap_mim_m3__base] $X=43825 $Y=10420 $dt=40
C5746 TOP_PLATE 626 L=4e-06 W=4e-06 $[cap_mim_m3__base] $X=43825 $Y=18700 $dt=40
C5747 TOP_PLATE 627 L=4e-06 W=4e-06 $[cap_mim_m3__base] $X=43825 $Y=26980 $dt=40
C5748 TOP_PLATE 628 L=4e-06 W=4e-06 $[cap_mim_m3__base] $X=43825 $Y=35260 $dt=40
C5749 TOP_PLATE 629 L=4e-06 W=4e-06 $[cap_mim_m3__base] $X=43825 $Y=43540 $dt=40
C5750 TOP_PLATE 630 L=4e-06 W=4e-06 $[cap_mim_m3__base] $X=43825 $Y=51820 $dt=40
C5751 TOP_PLATE 631 L=4e-06 W=4e-06 $[cap_mim_m3__base] $X=43825 $Y=60100 $dt=40
C5752 VREF_N VREF_P L=4e-06 W=4e-06 $[cap_mim_m3__base] $X=43825 $Y=68380 $dt=40
C5753 VREF_P VREF_N L=4e-06 W=4e-06 $[cap_mim_m3__base] $X=43825 $Y=76660 $dt=40
C5754 VREF_N VREF_P L=4e-06 W=4e-06 $[cap_mim_m3__base] $X=43825 $Y=84940 $dt=40
C5755 VREF_P VREF_N L=4e-06 W=4e-06 $[cap_mim_m3__base] $X=43825 $Y=93220 $dt=40
C5756 VREF_N VREF_P L=4e-06 W=4e-06 $[cap_mim_m3__base] $X=43825 $Y=101500 $dt=40
C5757 TOP_PLATE 632 L=4e-06 W=4e-06 $[cap_mim_m3__base] $X=43825 $Y=109780 $dt=40
C5758 TOP_PLATE 633 L=4e-06 W=4e-06 $[cap_mim_m3__base] $X=43825 $Y=118060 $dt=40
C5759 TOP_PLATE 634 L=4e-06 W=4e-06 $[cap_mim_m3__base] $X=43825 $Y=126340 $dt=40
C5760 TOP_PLATE 635 L=4e-06 W=4e-06 $[cap_mim_m3__base] $X=43825 $Y=134620 $dt=40
C5761 TOP_PLATE 636 L=4e-06 W=4e-06 $[cap_mim_m3__base] $X=43825 $Y=142900 $dt=40
C5762 TOP_PLATE 637 L=4e-06 W=4e-06 $[cap_mim_m3__base] $X=43825 $Y=151180 $dt=40
C5763 TOP_PLATE 638 L=4e-06 W=4e-06 $[cap_mim_m3__base] $X=43825 $Y=159460 $dt=40
C5764 VREF_N VSS! L=4e-06 W=4e-06 $[cap_mim_m3__base] $X=43825 $Y=167740 $dt=40
C5765 VREF_N VSS! L=4e-06 W=4e-06 $[cap_mim_m3__base] $X=52105 $Y=2140 $dt=40
C5766 TOP_PLATE 607 L=4e-06 W=4e-06 $[cap_mim_m3__base] $X=52105 $Y=10420 $dt=40
C5767 TOP_PLATE 608 L=4e-06 W=4e-06 $[cap_mim_m3__base] $X=52105 $Y=18700 $dt=40
C5768 TOP_PLATE 609 L=4e-06 W=4e-06 $[cap_mim_m3__base] $X=52105 $Y=26980 $dt=40
C5769 TOP_PLATE 610 L=4e-06 W=4e-06 $[cap_mim_m3__base] $X=52105 $Y=35260 $dt=40
C5770 TOP_PLATE 611 L=4e-06 W=4e-06 $[cap_mim_m3__base] $X=52105 $Y=43540 $dt=40
C5771 TOP_PLATE 612 L=4e-06 W=4e-06 $[cap_mim_m3__base] $X=52105 $Y=51820 $dt=40
C5772 TOP_PLATE 613 L=4e-06 W=4e-06 $[cap_mim_m3__base] $X=52105 $Y=60100 $dt=40
C5773 TOP_PLATE 614 L=4e-06 W=4e-06 $[cap_mim_m3__base] $X=52105 $Y=68380 $dt=40
C5774 TOP_PLATE 615 L=4e-06 W=4e-06 $[cap_mim_m3__base] $X=52105 $Y=76660 $dt=40
C5775 VREF_P VREF_N L=4e-06 W=4e-06 $[cap_mim_m3__base] $X=52105 $Y=84940 $dt=40
C5776 TOP_PLATE 616 L=4e-06 W=4e-06 $[cap_mim_m3__base] $X=52105 $Y=93220 $dt=40
C5777 TOP_PLATE 617 L=4e-06 W=4e-06 $[cap_mim_m3__base] $X=52105 $Y=101500 $dt=40
C5778 TOP_PLATE 618 L=4e-06 W=4e-06 $[cap_mim_m3__base] $X=52105 $Y=109780 $dt=40
C5779 TOP_PLATE 619 L=4e-06 W=4e-06 $[cap_mim_m3__base] $X=52105 $Y=118060 $dt=40
C5780 TOP_PLATE 620 L=4e-06 W=4e-06 $[cap_mim_m3__base] $X=52105 $Y=126340 $dt=40
C5781 TOP_PLATE 621 L=4e-06 W=4e-06 $[cap_mim_m3__base] $X=52105 $Y=134620 $dt=40
C5782 TOP_PLATE 622 L=4e-06 W=4e-06 $[cap_mim_m3__base] $X=52105 $Y=142900 $dt=40
C5783 TOP_PLATE 623 L=4e-06 W=4e-06 $[cap_mim_m3__base] $X=52105 $Y=151180 $dt=40
C5784 TOP_PLATE 624 L=4e-06 W=4e-06 $[cap_mim_m3__base] $X=52105 $Y=159460 $dt=40
C5785 VREF_P VSS! L=4e-06 W=4e-06 $[cap_mim_m3__base] $X=52105 $Y=167740 $dt=40
C5786 VREF_P VSS! L=4e-06 W=4e-06 $[cap_mim_m3__base] $X=60385 $Y=2140 $dt=40
C5787 TOP_PLATE 589 L=4e-06 W=4e-06 $[cap_mim_m3__base] $X=60385 $Y=10420 $dt=40
C5788 TOP_PLATE 590 L=4e-06 W=4e-06 $[cap_mim_m3__base] $X=60385 $Y=18700 $dt=40
C5789 TOP_PLATE 591 L=4e-06 W=4e-06 $[cap_mim_m3__base] $X=60385 $Y=26980 $dt=40
C5790 TOP_PLATE 592 L=4e-06 W=4e-06 $[cap_mim_m3__base] $X=60385 $Y=35260 $dt=40
C5791 TOP_PLATE 593 L=4e-06 W=4e-06 $[cap_mim_m3__base] $X=60385 $Y=43540 $dt=40
C5792 TOP_PLATE 594 L=4e-06 W=4e-06 $[cap_mim_m3__base] $X=60385 $Y=51820 $dt=40
C5793 TOP_PLATE 595 L=4e-06 W=4e-06 $[cap_mim_m3__base] $X=60385 $Y=60100 $dt=40
C5794 TOP_PLATE 596 L=4e-06 W=4e-06 $[cap_mim_m3__base] $X=60385 $Y=68380 $dt=40
C5795 TOP_PLATE 597 L=4e-06 W=4e-06 $[cap_mim_m3__base] $X=60385 $Y=76660 $dt=40
C5796 VREF_N VREF_P L=4e-06 W=4e-06 $[cap_mim_m3__base] $X=60385 $Y=84940 $dt=40
C5797 TOP_PLATE 598 L=4e-06 W=4e-06 $[cap_mim_m3__base] $X=60385 $Y=93220 $dt=40
C5798 TOP_PLATE 599 L=4e-06 W=4e-06 $[cap_mim_m3__base] $X=60385 $Y=101500 $dt=40
C5799 TOP_PLATE 600 L=4e-06 W=4e-06 $[cap_mim_m3__base] $X=60385 $Y=109780 $dt=40
C5800 TOP_PLATE 601 L=4e-06 W=4e-06 $[cap_mim_m3__base] $X=60385 $Y=118060 $dt=40
C5801 TOP_PLATE 602 L=4e-06 W=4e-06 $[cap_mim_m3__base] $X=60385 $Y=126340 $dt=40
C5802 TOP_PLATE 603 L=4e-06 W=4e-06 $[cap_mim_m3__base] $X=60385 $Y=134620 $dt=40
C5803 TOP_PLATE 604 L=4e-06 W=4e-06 $[cap_mim_m3__base] $X=60385 $Y=142900 $dt=40
C5804 TOP_PLATE 605 L=4e-06 W=4e-06 $[cap_mim_m3__base] $X=60385 $Y=151180 $dt=40
C5805 TOP_PLATE 606 L=4e-06 W=4e-06 $[cap_mim_m3__base] $X=60385 $Y=159460 $dt=40
C5806 VREF_N VSS! L=4e-06 W=4e-06 $[cap_mim_m3__base] $X=60385 $Y=167740 $dt=40
C5807 VREF_N VSS! L=4e-06 W=4e-06 $[cap_mim_m3__base] $X=68665 $Y=2140 $dt=40
C5808 TOP_PLATE 571 L=4e-06 W=4e-06 $[cap_mim_m3__base] $X=68665 $Y=10420 $dt=40
C5809 TOP_PLATE 572 L=4e-06 W=4e-06 $[cap_mim_m3__base] $X=68665 $Y=18700 $dt=40
C5810 TOP_PLATE 573 L=4e-06 W=4e-06 $[cap_mim_m3__base] $X=68665 $Y=26980 $dt=40
C5811 TOP_PLATE 574 L=4e-06 W=4e-06 $[cap_mim_m3__base] $X=68665 $Y=35260 $dt=40
C5812 TOP_PLATE 575 L=4e-06 W=4e-06 $[cap_mim_m3__base] $X=68665 $Y=43540 $dt=40
C5813 TOP_PLATE 576 L=4e-06 W=4e-06 $[cap_mim_m3__base] $X=68665 $Y=51820 $dt=40
C5814 TOP_PLATE 577 L=4e-06 W=4e-06 $[cap_mim_m3__base] $X=68665 $Y=60100 $dt=40
C5815 TOP_PLATE 578 L=4e-06 W=4e-06 $[cap_mim_m3__base] $X=68665 $Y=68380 $dt=40
C5816 TOP_PLATE 579 L=4e-06 W=4e-06 $[cap_mim_m3__base] $X=68665 $Y=76660 $dt=40
C5817 VREF_P VREF_N L=4e-06 W=4e-06 $[cap_mim_m3__base] $X=68665 $Y=84940 $dt=40
C5818 TOP_PLATE 580 L=4e-06 W=4e-06 $[cap_mim_m3__base] $X=68665 $Y=93220 $dt=40
C5819 TOP_PLATE 581 L=4e-06 W=4e-06 $[cap_mim_m3__base] $X=68665 $Y=101500 $dt=40
C5820 TOP_PLATE 582 L=4e-06 W=4e-06 $[cap_mim_m3__base] $X=68665 $Y=109780 $dt=40
C5821 TOP_PLATE 583 L=4e-06 W=4e-06 $[cap_mim_m3__base] $X=68665 $Y=118060 $dt=40
C5822 TOP_PLATE 584 L=4e-06 W=4e-06 $[cap_mim_m3__base] $X=68665 $Y=126340 $dt=40
C5823 TOP_PLATE 585 L=4e-06 W=4e-06 $[cap_mim_m3__base] $X=68665 $Y=134620 $dt=40
C5824 TOP_PLATE 586 L=4e-06 W=4e-06 $[cap_mim_m3__base] $X=68665 $Y=142900 $dt=40
C5825 TOP_PLATE 587 L=4e-06 W=4e-06 $[cap_mim_m3__base] $X=68665 $Y=151180 $dt=40
C5826 TOP_PLATE 588 L=4e-06 W=4e-06 $[cap_mim_m3__base] $X=68665 $Y=159460 $dt=40
C5827 VREF_P VSS! L=4e-06 W=4e-06 $[cap_mim_m3__base] $X=68665 $Y=167740 $dt=40
C5828 VREF_P VSS! L=4e-06 W=4e-06 $[cap_mim_m3__base] $X=76945 $Y=2140 $dt=40
C5829 TOP_PLATE 438 L=4e-06 W=4e-06 $[cap_mim_m3__base] $X=76945 $Y=10420 $dt=40
C5830 TOP_PLATE 439 L=4e-06 W=4e-06 $[cap_mim_m3__base] $X=76945 $Y=18700 $dt=40
C5831 TOP_PLATE 440 L=4e-06 W=4e-06 $[cap_mim_m3__base] $X=76945 $Y=26980 $dt=40
C5832 TOP_PLATE 441 L=4e-06 W=4e-06 $[cap_mim_m3__base] $X=76945 $Y=35260 $dt=40
C5833 TOP_PLATE 442 L=4e-06 W=4e-06 $[cap_mim_m3__base] $X=76945 $Y=43540 $dt=40
C5834 TOP_PLATE 443 L=4e-06 W=4e-06 $[cap_mim_m3__base] $X=76945 $Y=51820 $dt=40
C5835 TOP_PLATE 444 L=4e-06 W=4e-06 $[cap_mim_m3__base] $X=76945 $Y=60100 $dt=40
C5836 TOP_PLATE 445 L=4e-06 W=4e-06 $[cap_mim_m3__base] $X=76945 $Y=68380 $dt=40
C5837 TOP_PLATE 446 L=4e-06 W=4e-06 $[cap_mim_m3__base] $X=76945 $Y=76660 $dt=40
C5838 TOP_PLATE 447 L=4e-06 W=4e-06 $[cap_mim_m3__base] $X=76945 $Y=84940 $dt=40
C5839 TOP_PLATE 448 L=4e-06 W=4e-06 $[cap_mim_m3__base] $X=76945 $Y=93220 $dt=40
C5840 TOP_PLATE 449 L=4e-06 W=4e-06 $[cap_mim_m3__base] $X=76945 $Y=101500 $dt=40
C5841 TOP_PLATE 450 L=4e-06 W=4e-06 $[cap_mim_m3__base] $X=76945 $Y=109780 $dt=40
C5842 TOP_PLATE 451 L=4e-06 W=4e-06 $[cap_mim_m3__base] $X=76945 $Y=118060 $dt=40
C5843 TOP_PLATE 452 L=4e-06 W=4e-06 $[cap_mim_m3__base] $X=76945 $Y=126340 $dt=40
C5844 TOP_PLATE 453 L=4e-06 W=4e-06 $[cap_mim_m3__base] $X=76945 $Y=134620 $dt=40
C5845 TOP_PLATE 454 L=4e-06 W=4e-06 $[cap_mim_m3__base] $X=76945 $Y=142900 $dt=40
C5846 TOP_PLATE 455 L=4e-06 W=4e-06 $[cap_mim_m3__base] $X=76945 $Y=151180 $dt=40
C5847 TOP_PLATE 456 L=4e-06 W=4e-06 $[cap_mim_m3__base] $X=76945 $Y=159460 $dt=40
C5848 VREF_N VSS! L=4e-06 W=4e-06 $[cap_mim_m3__base] $X=76945 $Y=167740 $dt=40
C5849 VREF_N VSS! L=4e-06 W=4e-06 $[cap_mim_m3__base] $X=85225 $Y=2140 $dt=40
C5850 TOP_PLATE 419 L=4e-06 W=4e-06 $[cap_mim_m3__base] $X=85225 $Y=10420 $dt=40
C5851 TOP_PLATE 420 L=4e-06 W=4e-06 $[cap_mim_m3__base] $X=85225 $Y=18700 $dt=40
C5852 TOP_PLATE 421 L=4e-06 W=4e-06 $[cap_mim_m3__base] $X=85225 $Y=26980 $dt=40
C5853 TOP_PLATE 422 L=4e-06 W=4e-06 $[cap_mim_m3__base] $X=85225 $Y=35260 $dt=40
C5854 TOP_PLATE 423 L=4e-06 W=4e-06 $[cap_mim_m3__base] $X=85225 $Y=43540 $dt=40
C5855 TOP_PLATE 424 L=4e-06 W=4e-06 $[cap_mim_m3__base] $X=85225 $Y=51820 $dt=40
C5856 TOP_PLATE 425 L=4e-06 W=4e-06 $[cap_mim_m3__base] $X=85225 $Y=60100 $dt=40
C5857 TOP_PLATE 426 L=4e-06 W=4e-06 $[cap_mim_m3__base] $X=85225 $Y=68380 $dt=40
C5858 TOP_PLATE 427 L=4e-06 W=4e-06 $[cap_mim_m3__base] $X=85225 $Y=76660 $dt=40
C5859 TOP_PLATE 428 L=4e-06 W=4e-06 $[cap_mim_m3__base] $X=85225 $Y=84940 $dt=40
C5860 TOP_PLATE 429 L=4e-06 W=4e-06 $[cap_mim_m3__base] $X=85225 $Y=93220 $dt=40
C5861 TOP_PLATE 430 L=4e-06 W=4e-06 $[cap_mim_m3__base] $X=85225 $Y=101500 $dt=40
C5862 TOP_PLATE 431 L=4e-06 W=4e-06 $[cap_mim_m3__base] $X=85225 $Y=109780 $dt=40
C5863 TOP_PLATE 432 L=4e-06 W=4e-06 $[cap_mim_m3__base] $X=85225 $Y=118060 $dt=40
C5864 TOP_PLATE 433 L=4e-06 W=4e-06 $[cap_mim_m3__base] $X=85225 $Y=126340 $dt=40
C5865 TOP_PLATE 434 L=4e-06 W=4e-06 $[cap_mim_m3__base] $X=85225 $Y=134620 $dt=40
C5866 TOP_PLATE 435 L=4e-06 W=4e-06 $[cap_mim_m3__base] $X=85225 $Y=142900 $dt=40
C5867 TOP_PLATE 436 L=4e-06 W=4e-06 $[cap_mim_m3__base] $X=85225 $Y=151180 $dt=40
C5868 TOP_PLATE 437 L=4e-06 W=4e-06 $[cap_mim_m3__base] $X=85225 $Y=159460 $dt=40
C5869 VREF_P VSS! L=4e-06 W=4e-06 $[cap_mim_m3__base] $X=85225 $Y=167740 $dt=40
C5870 VREF_P VSS! L=4e-06 W=4e-06 $[cap_mim_m3__base] $X=93505 $Y=2140 $dt=40
C5871 TOP_PLATE 401 L=4e-06 W=4e-06 $[cap_mim_m3__base] $X=93505 $Y=10420 $dt=40
C5872 TOP_PLATE 402 L=4e-06 W=4e-06 $[cap_mim_m3__base] $X=93505 $Y=18700 $dt=40
C5873 TOP_PLATE 403 L=4e-06 W=4e-06 $[cap_mim_m3__base] $X=93505 $Y=26980 $dt=40
C5874 TOP_PLATE 404 L=4e-06 W=4e-06 $[cap_mim_m3__base] $X=93505 $Y=35260 $dt=40
C5875 TOP_PLATE 405 L=4e-06 W=4e-06 $[cap_mim_m3__base] $X=93505 $Y=43540 $dt=40
C5876 TOP_PLATE 406 L=4e-06 W=4e-06 $[cap_mim_m3__base] $X=93505 $Y=51820 $dt=40
C5877 TOP_PLATE 407 L=4e-06 W=4e-06 $[cap_mim_m3__base] $X=93505 $Y=60100 $dt=40
C5878 TOP_PLATE 408 L=4e-06 W=4e-06 $[cap_mim_m3__base] $X=93505 $Y=68380 $dt=40
C5879 TOP_PLATE 409 L=4e-06 W=4e-06 $[cap_mim_m3__base] $X=93505 $Y=76660 $dt=40
C5880 VREF_N VREF_P L=4e-06 W=4e-06 $[cap_mim_m3__base] $X=93505 $Y=84940 $dt=40
C5881 TOP_PLATE 410 L=4e-06 W=4e-06 $[cap_mim_m3__base] $X=93505 $Y=93220 $dt=40
C5882 TOP_PLATE 411 L=4e-06 W=4e-06 $[cap_mim_m3__base] $X=93505 $Y=101500 $dt=40
C5883 TOP_PLATE 412 L=4e-06 W=4e-06 $[cap_mim_m3__base] $X=93505 $Y=109780 $dt=40
C5884 TOP_PLATE 413 L=4e-06 W=4e-06 $[cap_mim_m3__base] $X=93505 $Y=118060 $dt=40
C5885 TOP_PLATE 414 L=4e-06 W=4e-06 $[cap_mim_m3__base] $X=93505 $Y=126340 $dt=40
C5886 TOP_PLATE 415 L=4e-06 W=4e-06 $[cap_mim_m3__base] $X=93505 $Y=134620 $dt=40
C5887 TOP_PLATE 416 L=4e-06 W=4e-06 $[cap_mim_m3__base] $X=93505 $Y=142900 $dt=40
C5888 TOP_PLATE 417 L=4e-06 W=4e-06 $[cap_mim_m3__base] $X=93505 $Y=151180 $dt=40
C5889 TOP_PLATE 418 L=4e-06 W=4e-06 $[cap_mim_m3__base] $X=93505 $Y=159460 $dt=40
C5890 VREF_N VSS! L=4e-06 W=4e-06 $[cap_mim_m3__base] $X=93505 $Y=167740 $dt=40
C5891 VREF_N VSS! L=4e-06 W=4e-06 $[cap_mim_m3__base] $X=101785 $Y=2140 $dt=40
C5892 TOP_PLATE 384 L=4e-06 W=4e-06 $[cap_mim_m3__base] $X=101785 $Y=10420 $dt=40
C5893 TOP_PLATE 385 L=4e-06 W=4e-06 $[cap_mim_m3__base] $X=101785 $Y=18700 $dt=40
C5894 TOP_PLATE 386 L=4e-06 W=4e-06 $[cap_mim_m3__base] $X=101785 $Y=26980 $dt=40
C5895 TOP_PLATE 387 L=4e-06 W=4e-06 $[cap_mim_m3__base] $X=101785 $Y=35260 $dt=40
C5896 TOP_PLATE 388 L=4e-06 W=4e-06 $[cap_mim_m3__base] $X=101785 $Y=43540 $dt=40
C5897 TOP_PLATE 389 L=4e-06 W=4e-06 $[cap_mim_m3__base] $X=101785 $Y=51820 $dt=40
C5898 TOP_PLATE 390 L=4e-06 W=4e-06 $[cap_mim_m3__base] $X=101785 $Y=60100 $dt=40
C5899 TOP_PLATE 391 L=4e-06 W=4e-06 $[cap_mim_m3__base] $X=101785 $Y=68380 $dt=40
C5900 TOP_PLATE 392 L=4e-06 W=4e-06 $[cap_mim_m3__base] $X=101785 $Y=76660 $dt=40
C5901 VREF_N VREF_P L=4e-06 W=4e-06 $[cap_mim_m3__base] $X=101785 $Y=84940 $dt=40
C5902 VREF_P VREF_N L=4e-06 W=4e-06 $[cap_mim_m3__base] $X=101785 $Y=93220 $dt=40
C5903 TOP_PLATE 393 L=4e-06 W=4e-06 $[cap_mim_m3__base] $X=101785 $Y=101500 $dt=40
C5904 TOP_PLATE 394 L=4e-06 W=4e-06 $[cap_mim_m3__base] $X=101785 $Y=109780 $dt=40
C5905 TOP_PLATE 395 L=4e-06 W=4e-06 $[cap_mim_m3__base] $X=101785 $Y=118060 $dt=40
C5906 TOP_PLATE 396 L=4e-06 W=4e-06 $[cap_mim_m3__base] $X=101785 $Y=126340 $dt=40
C5907 TOP_PLATE 397 L=4e-06 W=4e-06 $[cap_mim_m3__base] $X=101785 $Y=134620 $dt=40
C5908 TOP_PLATE 398 L=4e-06 W=4e-06 $[cap_mim_m3__base] $X=101785 $Y=142900 $dt=40
C5909 TOP_PLATE 399 L=4e-06 W=4e-06 $[cap_mim_m3__base] $X=101785 $Y=151180 $dt=40
C5910 TOP_PLATE 400 L=4e-06 W=4e-06 $[cap_mim_m3__base] $X=101785 $Y=159460 $dt=40
C5911 VREF_P VSS! L=4e-06 W=4e-06 $[cap_mim_m3__base] $X=101785 $Y=167740 $dt=40
C5912 VREF_P VSS! L=4e-06 W=4e-06 $[cap_mim_m3__base] $X=110065 $Y=2140 $dt=40
C5913 TOP_PLATE 367 L=4e-06 W=4e-06 $[cap_mim_m3__base] $X=110065 $Y=10420 $dt=40
C5914 TOP_PLATE 368 L=4e-06 W=4e-06 $[cap_mim_m3__base] $X=110065 $Y=18700 $dt=40
C5915 TOP_PLATE 369 L=4e-06 W=4e-06 $[cap_mim_m3__base] $X=110065 $Y=26980 $dt=40
C5916 TOP_PLATE 370 L=4e-06 W=4e-06 $[cap_mim_m3__base] $X=110065 $Y=35260 $dt=40
C5917 TOP_PLATE 371 L=4e-06 W=4e-06 $[cap_mim_m3__base] $X=110065 $Y=43540 $dt=40
C5918 TOP_PLATE 372 L=4e-06 W=4e-06 $[cap_mim_m3__base] $X=110065 $Y=51820 $dt=40
C5919 TOP_PLATE 373 L=4e-06 W=4e-06 $[cap_mim_m3__base] $X=110065 $Y=60100 $dt=40
C5920 TOP_PLATE 374 L=4e-06 W=4e-06 $[cap_mim_m3__base] $X=110065 $Y=68380 $dt=40
C5921 TOP_PLATE 375 L=4e-06 W=4e-06 $[cap_mim_m3__base] $X=110065 $Y=76660 $dt=40
C5922 VREF_P VREF_N L=4e-06 W=4e-06 $[cap_mim_m3__base] $X=110065 $Y=84940 $dt=40
C5923 VREF_N VREF_P L=4e-06 W=4e-06 $[cap_mim_m3__base] $X=110065 $Y=93220 $dt=40
C5924 TOP_PLATE 376 L=4e-06 W=4e-06 $[cap_mim_m3__base] $X=110065 $Y=101500 $dt=40
C5925 TOP_PLATE 377 L=4e-06 W=4e-06 $[cap_mim_m3__base] $X=110065 $Y=109780 $dt=40
C5926 TOP_PLATE 378 L=4e-06 W=4e-06 $[cap_mim_m3__base] $X=110065 $Y=118060 $dt=40
C5927 TOP_PLATE 379 L=4e-06 W=4e-06 $[cap_mim_m3__base] $X=110065 $Y=126340 $dt=40
C5928 TOP_PLATE 380 L=4e-06 W=4e-06 $[cap_mim_m3__base] $X=110065 $Y=134620 $dt=40
C5929 TOP_PLATE 381 L=4e-06 W=4e-06 $[cap_mim_m3__base] $X=110065 $Y=142900 $dt=40
C5930 TOP_PLATE 382 L=4e-06 W=4e-06 $[cap_mim_m3__base] $X=110065 $Y=151180 $dt=40
C5931 TOP_PLATE 383 L=4e-06 W=4e-06 $[cap_mim_m3__base] $X=110065 $Y=159460 $dt=40
C5932 VREF_N VSS! L=4e-06 W=4e-06 $[cap_mim_m3__base] $X=110065 $Y=167740 $dt=40
C5933 VREF_N VSS! L=4e-06 W=4e-06 $[cap_mim_m3__base] $X=118345 $Y=2140 $dt=40
C5934 TOP_PLATE 353 L=4e-06 W=4e-06 $[cap_mim_m3__base] $X=118345 $Y=10420 $dt=40
C5935 TOP_PLATE 354 L=4e-06 W=4e-06 $[cap_mim_m3__base] $X=118345 $Y=18700 $dt=40
C5936 TOP_PLATE 355 L=4e-06 W=4e-06 $[cap_mim_m3__base] $X=118345 $Y=26980 $dt=40
C5937 TOP_PLATE 356 L=4e-06 W=4e-06 $[cap_mim_m3__base] $X=118345 $Y=35260 $dt=40
C5938 TOP_PLATE 357 L=4e-06 W=4e-06 $[cap_mim_m3__base] $X=118345 $Y=43540 $dt=40
C5939 TOP_PLATE 358 L=4e-06 W=4e-06 $[cap_mim_m3__base] $X=118345 $Y=51820 $dt=40
C5940 TOP_PLATE 359 L=4e-06 W=4e-06 $[cap_mim_m3__base] $X=118345 $Y=60100 $dt=40
C5941 VREF_N VREF_P L=4e-06 W=4e-06 $[cap_mim_m3__base] $X=118345 $Y=68380 $dt=40
C5942 VREF_P VREF_N L=4e-06 W=4e-06 $[cap_mim_m3__base] $X=118345 $Y=76660 $dt=40
C5943 VREF_N VREF_P L=4e-06 W=4e-06 $[cap_mim_m3__base] $X=118345 $Y=84940 $dt=40
C5944 VREF_P VREF_N L=4e-06 W=4e-06 $[cap_mim_m3__base] $X=118345 $Y=93220 $dt=40
C5945 VREF_N VREF_P L=4e-06 W=4e-06 $[cap_mim_m3__base] $X=118345 $Y=101500 $dt=40
C5946 TOP_PLATE 360 L=4e-06 W=4e-06 $[cap_mim_m3__base] $X=118345 $Y=109780 $dt=40
C5947 TOP_PLATE 361 L=4e-06 W=4e-06 $[cap_mim_m3__base] $X=118345 $Y=118060 $dt=40
C5948 TOP_PLATE 362 L=4e-06 W=4e-06 $[cap_mim_m3__base] $X=118345 $Y=126340 $dt=40
C5949 TOP_PLATE 363 L=4e-06 W=4e-06 $[cap_mim_m3__base] $X=118345 $Y=134620 $dt=40
C5950 TOP_PLATE 364 L=4e-06 W=4e-06 $[cap_mim_m3__base] $X=118345 $Y=142900 $dt=40
C5951 TOP_PLATE 365 L=4e-06 W=4e-06 $[cap_mim_m3__base] $X=118345 $Y=151180 $dt=40
C5952 TOP_PLATE 366 L=4e-06 W=4e-06 $[cap_mim_m3__base] $X=118345 $Y=159460 $dt=40
C5953 VREF_P VSS! L=4e-06 W=4e-06 $[cap_mim_m3__base] $X=118345 $Y=167740 $dt=40
C5954 VREF_P VSS! L=4e-06 W=4e-06 $[cap_mim_m3__base] $X=126625 $Y=2140 $dt=40
C5955 TOP_PLATE 339 L=4e-06 W=4e-06 $[cap_mim_m3__base] $X=126625 $Y=10420 $dt=40
C5956 TOP_PLATE 340 L=4e-06 W=4e-06 $[cap_mim_m3__base] $X=126625 $Y=18700 $dt=40
C5957 TOP_PLATE 341 L=4e-06 W=4e-06 $[cap_mim_m3__base] $X=126625 $Y=26980 $dt=40
C5958 TOP_PLATE 342 L=4e-06 W=4e-06 $[cap_mim_m3__base] $X=126625 $Y=35260 $dt=40
C5959 TOP_PLATE 343 L=4e-06 W=4e-06 $[cap_mim_m3__base] $X=126625 $Y=43540 $dt=40
C5960 TOP_PLATE 344 L=4e-06 W=4e-06 $[cap_mim_m3__base] $X=126625 $Y=51820 $dt=40
C5961 TOP_PLATE 345 L=4e-06 W=4e-06 $[cap_mim_m3__base] $X=126625 $Y=60100 $dt=40
C5962 VREF_P VREF_N L=4e-06 W=4e-06 $[cap_mim_m3__base] $X=126625 $Y=68380 $dt=40
C5963 VREF_N VREF_P L=4e-06 W=4e-06 $[cap_mim_m3__base] $X=126625 $Y=76660 $dt=40
C5964 VREF_P VREF_N L=4e-06 W=4e-06 $[cap_mim_m3__base] $X=126625 $Y=84940 $dt=40
C5965 VREF_N VREF_P L=4e-06 W=4e-06 $[cap_mim_m3__base] $X=126625 $Y=93220 $dt=40
C5966 VREF_P VREF_N L=4e-06 W=4e-06 $[cap_mim_m3__base] $X=126625 $Y=101500 $dt=40
C5967 TOP_PLATE 346 L=4e-06 W=4e-06 $[cap_mim_m3__base] $X=126625 $Y=109780 $dt=40
C5968 TOP_PLATE 347 L=4e-06 W=4e-06 $[cap_mim_m3__base] $X=126625 $Y=118060 $dt=40
C5969 TOP_PLATE 348 L=4e-06 W=4e-06 $[cap_mim_m3__base] $X=126625 $Y=126340 $dt=40
C5970 TOP_PLATE 349 L=4e-06 W=4e-06 $[cap_mim_m3__base] $X=126625 $Y=134620 $dt=40
C5971 TOP_PLATE 350 L=4e-06 W=4e-06 $[cap_mim_m3__base] $X=126625 $Y=142900 $dt=40
C5972 TOP_PLATE 351 L=4e-06 W=4e-06 $[cap_mim_m3__base] $X=126625 $Y=151180 $dt=40
C5973 TOP_PLATE 352 L=4e-06 W=4e-06 $[cap_mim_m3__base] $X=126625 $Y=159460 $dt=40
C5974 VREF_N VSS! L=4e-06 W=4e-06 $[cap_mim_m3__base] $X=126625 $Y=167740 $dt=40
C5975 VREF_N VSS! L=4e-06 W=4e-06 $[cap_mim_m3__base] $X=134905 $Y=2140 $dt=40
C5976 TOP_PLATE 325 L=4e-06 W=4e-06 $[cap_mim_m3__base] $X=134905 $Y=10420 $dt=40
C5977 TOP_PLATE 326 L=4e-06 W=4e-06 $[cap_mim_m3__base] $X=134905 $Y=18700 $dt=40
C5978 TOP_PLATE 327 L=4e-06 W=4e-06 $[cap_mim_m3__base] $X=134905 $Y=26980 $dt=40
C5979 TOP_PLATE 328 L=4e-06 W=4e-06 $[cap_mim_m3__base] $X=134905 $Y=35260 $dt=40
C5980 TOP_PLATE 329 L=4e-06 W=4e-06 $[cap_mim_m3__base] $X=134905 $Y=43540 $dt=40
C5981 TOP_PLATE 330 L=4e-06 W=4e-06 $[cap_mim_m3__base] $X=134905 $Y=51820 $dt=40
C5982 TOP_PLATE 331 L=4e-06 W=4e-06 $[cap_mim_m3__base] $X=134905 $Y=60100 $dt=40
C5983 VREF_N VREF_P L=4e-06 W=4e-06 $[cap_mim_m3__base] $X=134905 $Y=68380 $dt=40
C5984 VREF_P VREF_N L=4e-06 W=4e-06 $[cap_mim_m3__base] $X=134905 $Y=76660 $dt=40
C5985 VREF_N VREF_P L=4e-06 W=4e-06 $[cap_mim_m3__base] $X=134905 $Y=84940 $dt=40
C5986 VREF_P VREF_N L=4e-06 W=4e-06 $[cap_mim_m3__base] $X=134905 $Y=93220 $dt=40
C5987 VREF_N VREF_P L=4e-06 W=4e-06 $[cap_mim_m3__base] $X=134905 $Y=101500 $dt=40
C5988 TOP_PLATE 332 L=4e-06 W=4e-06 $[cap_mim_m3__base] $X=134905 $Y=109780 $dt=40
C5989 TOP_PLATE 333 L=4e-06 W=4e-06 $[cap_mim_m3__base] $X=134905 $Y=118060 $dt=40
C5990 TOP_PLATE 334 L=4e-06 W=4e-06 $[cap_mim_m3__base] $X=134905 $Y=126340 $dt=40
C5991 TOP_PLATE 335 L=4e-06 W=4e-06 $[cap_mim_m3__base] $X=134905 $Y=134620 $dt=40
C5992 TOP_PLATE 336 L=4e-06 W=4e-06 $[cap_mim_m3__base] $X=134905 $Y=142900 $dt=40
C5993 TOP_PLATE 337 L=4e-06 W=4e-06 $[cap_mim_m3__base] $X=134905 $Y=151180 $dt=40
C5994 TOP_PLATE 338 L=4e-06 W=4e-06 $[cap_mim_m3__base] $X=134905 $Y=159460 $dt=40
C5995 VREF_P VSS! L=4e-06 W=4e-06 $[cap_mim_m3__base] $X=134905 $Y=167740 $dt=40
C5996 VREF_P VSS! L=4e-06 W=4e-06 $[cap_mim_m3__base] $X=143185 $Y=2140 $dt=40
C5997 TOP_PLATE 310 L=4e-06 W=4e-06 $[cap_mim_m3__base] $X=143185 $Y=10420 $dt=40
C5998 TOP_PLATE 311 L=4e-06 W=4e-06 $[cap_mim_m3__base] $X=143185 $Y=18700 $dt=40
C5999 TOP_PLATE 312 L=4e-06 W=4e-06 $[cap_mim_m3__base] $X=143185 $Y=26980 $dt=40
C6000 TOP_PLATE 313 L=4e-06 W=4e-06 $[cap_mim_m3__base] $X=143185 $Y=35260 $dt=40
C6001 TOP_PLATE 314 L=4e-06 W=4e-06 $[cap_mim_m3__base] $X=143185 $Y=43540 $dt=40
C6002 TOP_PLATE 315 L=4e-06 W=4e-06 $[cap_mim_m3__base] $X=143185 $Y=51820 $dt=40
C6003 TOP_PLATE 316 L=4e-06 W=4e-06 $[cap_mim_m3__base] $X=143185 $Y=60100 $dt=40
C6004 VREF_P VREF_N L=4e-06 W=4e-06 $[cap_mim_m3__base] $X=143185 $Y=68380 $dt=40
C6005 VREF_N VREF_P L=4e-06 W=4e-06 $[cap_mim_m3__base] $X=143185 $Y=76660 $dt=40
C6006 VREF_P VREF_N L=4e-06 W=4e-06 $[cap_mim_m3__base] $X=143185 $Y=84940 $dt=40
C6007 VREF_N VREF_P L=4e-06 W=4e-06 $[cap_mim_m3__base] $X=143185 $Y=93220 $dt=40
C6008 VREF_P VREF_N L=4e-06 W=4e-06 $[cap_mim_m3__base] $X=143185 $Y=101500 $dt=40
C6009 TOP_PLATE 317 L=4e-06 W=4e-06 $[cap_mim_m3__base] $X=143185 $Y=109780 $dt=40
C6010 TOP_PLATE 318 L=4e-06 W=4e-06 $[cap_mim_m3__base] $X=143185 $Y=118060 $dt=40
C6011 TOP_PLATE 319 L=4e-06 W=4e-06 $[cap_mim_m3__base] $X=143185 $Y=126340 $dt=40
C6012 TOP_PLATE 320 L=4e-06 W=4e-06 $[cap_mim_m3__base] $X=143185 $Y=134620 $dt=40
C6013 TOP_PLATE 321 L=4e-06 W=4e-06 $[cap_mim_m3__base] $X=143185 $Y=142900 $dt=40
C6014 TOP_PLATE 322 L=4e-06 W=4e-06 $[cap_mim_m3__base] $X=143185 $Y=151180 $dt=40
C6015 TOP_PLATE 323 L=4e-06 W=4e-06 $[cap_mim_m3__base] $X=143185 $Y=159460 $dt=40
C6016 VREF_N VSS! L=4e-06 W=4e-06 $[cap_mim_m3__base] $X=143185 $Y=167740 $dt=40
C6017 VDD! VSS! L=4e-06 W=4e-06 $[cap_mim_m3__base] $X=151465 $Y=10420 $dt=40
C6018 VDD! VSS! L=4e-06 W=4e-06 $[cap_mim_m3__base] $X=151465 $Y=18700 $dt=40
C6019 VDD! VSS! L=4e-06 W=4e-06 $[cap_mim_m3__base] $X=151465 $Y=26980 $dt=40
C6020 VDD! VSS! L=4e-06 W=4e-06 $[cap_mim_m3__base] $X=151465 $Y=35260 $dt=40
C6021 VDD! VSS! L=4e-06 W=4e-06 $[cap_mim_m3__base] $X=151465 $Y=43540 $dt=40
C6022 VDD! VSS! L=4e-06 W=4e-06 $[cap_mim_m3__base] $X=151465 $Y=51820 $dt=40
C6023 VDD! VSS! L=4e-06 W=4e-06 $[cap_mim_m3__base] $X=151465 $Y=60100 $dt=40
C6024 VDD! VSS! L=4e-06 W=4e-06 $[cap_mim_m3__base] $X=151465 $Y=68380 $dt=40
C6025 VDD! VSS! L=4e-06 W=4e-06 $[cap_mim_m3__base] $X=151465 $Y=76660 $dt=40
C6026 VDD! VSS! L=4e-06 W=4e-06 $[cap_mim_m3__base] $X=151465 $Y=84940 $dt=40
C6027 VDD! VSS! L=4e-06 W=4e-06 $[cap_mim_m3__base] $X=151465 $Y=93220 $dt=40
C6028 VDD! VSS! L=4e-06 W=4e-06 $[cap_mim_m3__base] $X=151465 $Y=101500 $dt=40
C6029 VDD! VSS! L=4e-06 W=4e-06 $[cap_mim_m3__base] $X=151465 $Y=109780 $dt=40
C6030 VDD! VSS! L=4e-06 W=4e-06 $[cap_mim_m3__base] $X=151465 $Y=118060 $dt=40
C6031 VDD! VSS! L=4e-06 W=4e-06 $[cap_mim_m3__base] $X=151465 $Y=126340 $dt=40
C6032 VDD! VSS! L=4e-06 W=4e-06 $[cap_mim_m3__base] $X=151465 $Y=134620 $dt=40
C6033 VDD! VSS! L=4e-06 W=4e-06 $[cap_mim_m3__base] $X=151465 $Y=142900 $dt=40
C6034 VDD! VSS! L=4e-06 W=4e-06 $[cap_mim_m3__base] $X=151465 $Y=151180 $dt=40
C6035 VDD! VSS! L=4e-06 W=4e-06 $[cap_mim_m3__base] $X=151465 $Y=159460 $dt=40
.ends CDAC_DEM
