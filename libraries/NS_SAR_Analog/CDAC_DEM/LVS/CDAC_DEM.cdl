***********************************************************
* CDL produced by pvsBuildNetlist on Aug 28 13:56:15 2026 *
***********************************************************

*pvsViewList = auCdl schematic
*pvsStopList = ("auCdl")
*pvsSimName  = auCdl

*.EXPAND_ON_M_FACTOR
*.MEGA

*.GLOBAL
+  VDD!
+  VSS!

.subckt unit_capacitor SEL_VIN SEL_VIN_N SEL_VREF_N SEL_VREF_N_N SEL_VREF_P
+  SEL_VREF_P_N TOP_PLATE VDD VIN VREF_N VREF_P VSS
*PVSCELL netlisted from NS_SAR_Analog unit_capacitor schematic
  CC0 TOP_PLATE bottom_plate cap_mim_m3__base l=4u w=4u m=1
  MNM0 VIN SEL_VIN bottom_plate VSS nfet_01v8 M=1 L=150n W=1.5u
  MNM1 bottom_plate SEL_VIN_N bottom_plate VSS nfet_01v8 M=1 L=150n W=1.5u
  MNM2 bottom_plate SEL_VREF_P VREF_P VSS nfet_01v8 M=1 L=150n W=1.5u
  MNM3 bottom_plate SEL_VREF_N VREF_N VSS nfet_01v8 M=1 L=150n W=1.5u
  MPM0 bottom_plate SEL_VIN_N VIN VDD pfet_01v8 M=1 L=150n W=1.5u
  MPM1 bottom_plate SEL_VIN bottom_plate VDD pfet_01v8 M=1 L=150n W=1.5u
  MPM2 VREF_P SEL_VREF_P_N bottom_plate VDD pfet_01v8 M=1 L=150n W=1.5u
  MPM3 VREF_N SEL_VREF_N_N bottom_plate VDD pfet_01v8 M=1 L=150n W=1.5u
.ends unit_capacitor

.subckt unit_capacitor_dummy SEL_VIN SEL_VIN_N SEL_VREF_N SEL_VREF_N_N SEL_VREF_P
+  SEL_VREF_P_N VDD VIN VREF_N VREF_P VSS
*PVSCELL netlisted from NS_SAR_Analog unit_capacitor_dummy schematic
  MNM0 VSS VDD VSS VSS nfet_01v8 M=2 L=580n W=1.5u
  MPM0 VDD VSS VDD VDD pfet_01v8 M=2 L=580n W=1.5u
.ends unit_capacitor_dummy

.subckt NOR2X1 A B VDD VSS Y
*PVSCELL netlisted from sky130_scl_9T NOR2X1 schematic
*.INHEXPR VSS VSS VSS!
*.INHEXPR VDD VDD VDD!
*.connect VSS VSS!
*.connect VDD VDD!
  Mmn0 Y A VSS! VSS! nfet_01v8 M=1 L=150n W=760n
  Mmn1 Y B VSS! VSS! nfet_01v8 M=1 L=150n W=760n
  Mmp0 net41 A VDD! VDD! pfet_01v8 M=1 L=150n W=1.13u
  Mmp1 Y B net41 VDD! pfet_01v8 M=1 L=150n W=1.13u
.ends NOR2X1

.subckt INVX8 A VDD VSS Y
*PVSCELL netlisted from sky130_scl_9T INVX8 schematic
*.INHEXPR VSS VSS VSS!
*.INHEXPR VDD VDD VDD!
*.connect VSS VSS!
*.connect VDD VDD!
  Mmn0 Y A VSS! VSS! nfet_01v8 M=1 L=150n W=6.08u
  Mmp0 Y A VDD! VDD! pfet_01v8 M=1 L=150n W=9.04u
.ends INVX8

.subckt INVX4 A VDD VSS Y
*PVSCELL netlisted from sky130_scl_9T INVX4 schematic
*.INHEXPR VSS VSS VSS!
*.INHEXPR VDD VDD VDD!
*.connect VSS VSS!
*.connect VDD VDD!
  Mmn0 Y A VSS! VSS! nfet_01v8 M=1 L=150n W=3.04u
  Mmp0 Y A VDD! VDD! pfet_01v8 M=1 L=150n W=4.52u
.ends INVX4

.subckt AND2X1 A B VDD VSS Y
*PVSCELL netlisted from sky130_scl_9T AND2X1 schematic
*.INHEXPR VSS VSS VSS!
*.INHEXPR VDD VDD VDD!
*.connect VSS VSS!
*.connect VDD VDD!
  Mmn0 net127 B VSS! VSS! nfet_01v8 M=1 L=150n W=425n
  Mmn1 n0 A net127 VSS! nfet_01v8 M=1 L=150n W=425n
  Mmn2 Y n0 VSS! VSS! nfet_01v8 M=1 L=150n W=760n
  Mmp0 n0 A VDD! VDD! pfet_01v8 M=1 L=150n W=625n
  Mmp1 n0 B VDD! VDD! pfet_01v8 M=1 L=150n W=625n
  Mmp2 Y n0 VDD! VDD! pfet_01v8 M=1 L=150n W=1.13u
.ends AND2X1

.subckt BUFX4 A VDD VSS Y
*PVSCELL netlisted from sky130_scl_9T BUFX4 schematic
*.INHEXPR VSS VSS VSS!
*.INHEXPR VDD VDD VDD!
*.connect VSS VSS!
*.connect VDD VDD!
  Mmn0 VSS! A n0 VSS! nfet_01v8 M=1 L=150n W=760n
  Mmn1 VSS! n0 Y VSS! nfet_01v8 M=1 L=150n W=3.04u
  Mmp0 n0 A VDD! VDD! pfet_01v8 M=1 L=150n W=1.13u
  Mmp1 Y n0 VDD! VDD! pfet_01v8 M=1 L=150n W=4.52u
.ends BUFX4

.subckt INVX1 A VDD VSS Y
*PVSCELL netlisted from sky130_scl_9T INVX1 schematic
*.INHEXPR VSS VSS VSS!
*.INHEXPR VDD VDD VDD!
*.connect VSS VSS!
*.connect VDD VDD!
  Mmn0 Y A VSS! VSS! nfet_01v8 M=1 L=150n W=760n
  Mmp0 Y A VDD! VDD! pfet_01v8 M=1 L=150n W=1.13u
.ends INVX1

.subckt BUFX8 A VDD VSS Y
*PVSCELL netlisted from sky130_scl_9T BUFX8 schematic
*.INHEXPR VSS VSS VSS!
*.INHEXPR VDD VDD VDD!
*.connect VSS VSS!
*.connect VDD VDD!
  Mmn0 VSS! A n0 VSS! nfet_01v8 M=1 L=150n W=1.52u
  Mmn1 VSS! n0 Y VSS! nfet_01v8 M=1 L=150n W=6.08u
  Mmp0 n0 A VDD! VDD! pfet_01v8 M=1 L=150n W=2.26u
  Mmp1 Y n0 VDD! VDD! pfet_01v8 M=1 L=150n W=9.04u
.ends BUFX8

.subckt gate_driver SAMPLE SEL_VIN SEL_VIN_N SEL_VREF_N SEL_VREF_N_N SEL_VREF_P
+  SEL_VREF_P_N VREF
*PVSCELL netlisted from NS_SAR_Analog gate_driver schematic
  CC0 VDD! VSS! cap_mim_m3__base l=4u w=4u m=1
  XI24 AND2X1 $PINS A=SAMPLE B=VREF Y=I
  XI25 AND2X1 $PINS A=net24 B=VREF Y=P
  XI29 BUFX4 $PINS A=P Y=SEL_VREF_P
  XI30 BUFX4 $PINS A=N Y=SEL_VREF_N
  XI35 BUFX8 $PINS A=I Y=SEL_VIN
  XI26 INVX1 $PINS A=SAMPLE Y=net24
  XI32 INVX4 $PINS A=P Y=SEL_VREF_P_N
  XI33 INVX4 $PINS A=N Y=SEL_VREF_N_N
  XI34 INVX8 $PINS A=I Y=SEL_VIN_N
  XI27 NOR2X1 $PINS A=SAMPLE B=VREF Y=N
.ends gate_driver

.subckt unit_capacitor_1_in_8_L SAMPLE TOP_PLATE VIN VREF_N VREF_P VREF_SEL
*PVSCELL netlisted from NS_SAR_Analog unit_capacitor_1_in_8_L schematic
  XI1 gate_driver $PINS SAMPLE=SAMPLE SEL_VIN=SEL_VIN SEL_VIN_N=SEL_VIN_N
+  SEL_VREF_N=SEL_VREF_N SEL_VREF_N_N=SEL_VREF_N_N SEL_VREF_P=SEL_VREF_P SEL_VREF_P_N=SEL_VREF_P_N
+  VREF=VREF_SEL
  XI0 unit_capacitor $PINS SEL_VIN=SEL_VIN SEL_VIN_N=SEL_VIN_N SEL_VREF_N=SEL_VREF_N
+  SEL_VREF_N_N=SEL_VREF_N_N SEL_VREF_P=SEL_VREF_P SEL_VREF_P_N=SEL_VREF_P_N
+  TOP_PLATE=TOP_PLATE VDD=VDD! VIN=VIN VREF_N=VREF_N VREF_P=VREF_P VSS=VSS!
  XI2<0> unit_capacitor_dummy $PINS SEL_VIN=SEL_VIN SEL_VIN_N=SEL_VIN_N SEL_VREF_N=SEL_VREF_N
+  SEL_VREF_N_N=SEL_VREF_N_N SEL_VREF_P=SEL_VREF_P SEL_VREF_P_N=SEL_VREF_P_N
+  VDD=VDD! VIN=VIN VREF_N=VREF_N VREF_P=VREF_P VSS=VSS!
  XI2<1> unit_capacitor_dummy $PINS SEL_VIN=SEL_VIN SEL_VIN_N=SEL_VIN_N SEL_VREF_N=SEL_VREF_N
+  SEL_VREF_N_N=SEL_VREF_N_N SEL_VREF_P=SEL_VREF_P SEL_VREF_P_N=SEL_VREF_P_N
+  VDD=VDD! VIN=VIN VREF_N=VREF_N VREF_P=VREF_P VSS=VSS!
  XI2<2> unit_capacitor_dummy $PINS SEL_VIN=SEL_VIN SEL_VIN_N=SEL_VIN_N SEL_VREF_N=SEL_VREF_N
+  SEL_VREF_N_N=SEL_VREF_N_N SEL_VREF_P=SEL_VREF_P SEL_VREF_P_N=SEL_VREF_P_N
+  VDD=VDD! VIN=VIN VREF_N=VREF_N VREF_P=VREF_P VSS=VSS!
  XI2<3> unit_capacitor_dummy $PINS SEL_VIN=SEL_VIN SEL_VIN_N=SEL_VIN_N SEL_VREF_N=SEL_VREF_N
+  SEL_VREF_N_N=SEL_VREF_N_N SEL_VREF_P=SEL_VREF_P SEL_VREF_P_N=SEL_VREF_P_N
+  VDD=VDD! VIN=VIN VREF_N=VREF_N VREF_P=VREF_P VSS=VSS!
  XI2<4> unit_capacitor_dummy $PINS SEL_VIN=SEL_VIN SEL_VIN_N=SEL_VIN_N SEL_VREF_N=SEL_VREF_N
+  SEL_VREF_N_N=SEL_VREF_N_N SEL_VREF_P=SEL_VREF_P SEL_VREF_P_N=SEL_VREF_P_N
+  VDD=VDD! VIN=VIN VREF_N=VREF_N VREF_P=VREF_P VSS=VSS!
  XI2<5> unit_capacitor_dummy $PINS SEL_VIN=SEL_VIN SEL_VIN_N=SEL_VIN_N SEL_VREF_N=SEL_VREF_N
+  SEL_VREF_N_N=SEL_VREF_N_N SEL_VREF_P=SEL_VREF_P SEL_VREF_P_N=SEL_VREF_P_N
+  VDD=VDD! VIN=VIN VREF_N=VREF_N VREF_P=VREF_P VSS=VSS!
  XI2<6> unit_capacitor_dummy $PINS SEL_VIN=SEL_VIN SEL_VIN_N=SEL_VIN_N SEL_VREF_N=SEL_VREF_N
+  SEL_VREF_N_N=SEL_VREF_N_N SEL_VREF_P=SEL_VREF_P SEL_VREF_P_N=SEL_VREF_P_N
+  VDD=VDD! VIN=VIN VREF_N=VREF_N VREF_P=VREF_P VSS=VSS!
.ends unit_capacitor_1_in_8_L

.subckt unit_capacitor_1_in_8_R SAMPLE TOP_PLATE VIN VREF_N VREF_P VREF_SEL
*PVSCELL netlisted from NS_SAR_Analog unit_capacitor_1_in_8_R schematic
  XI1 gate_driver $PINS SAMPLE=SAMPLE SEL_VIN=SEL_VIN SEL_VIN_N=SEL_VIN_N
+  SEL_VREF_N=SEL_VREF_N SEL_VREF_N_N=SEL_VREF_N_N SEL_VREF_P=SEL_VREF_P SEL_VREF_P_N=SEL_VREF_P_N
+  VREF=VREF_SEL
  XI0 unit_capacitor $PINS SEL_VIN=SEL_VIN SEL_VIN_N=SEL_VIN_N SEL_VREF_N=SEL_VREF_N
+  SEL_VREF_N_N=SEL_VREF_N_N SEL_VREF_P=SEL_VREF_P SEL_VREF_P_N=SEL_VREF_P_N
+  TOP_PLATE=TOP_PLATE VDD=VDD! VIN=VIN VREF_N=VREF_N VREF_P=VREF_P VSS=VSS!
  XI2<0> unit_capacitor_dummy $PINS SEL_VIN=SEL_VIN SEL_VIN_N=SEL_VIN_N SEL_VREF_N=SEL_VREF_N
+  SEL_VREF_N_N=SEL_VREF_N_N SEL_VREF_P=SEL_VREF_P SEL_VREF_P_N=SEL_VREF_P_N
+  VDD=VDD! VIN=VIN VREF_N=VREF_N VREF_P=VREF_P VSS=VSS!
  XI2<1> unit_capacitor_dummy $PINS SEL_VIN=SEL_VIN SEL_VIN_N=SEL_VIN_N SEL_VREF_N=SEL_VREF_N
+  SEL_VREF_N_N=SEL_VREF_N_N SEL_VREF_P=SEL_VREF_P SEL_VREF_P_N=SEL_VREF_P_N
+  VDD=VDD! VIN=VIN VREF_N=VREF_N VREF_P=VREF_P VSS=VSS!
  XI2<2> unit_capacitor_dummy $PINS SEL_VIN=SEL_VIN SEL_VIN_N=SEL_VIN_N SEL_VREF_N=SEL_VREF_N
+  SEL_VREF_N_N=SEL_VREF_N_N SEL_VREF_P=SEL_VREF_P SEL_VREF_P_N=SEL_VREF_P_N
+  VDD=VDD! VIN=VIN VREF_N=VREF_N VREF_P=VREF_P VSS=VSS!
  XI2<3> unit_capacitor_dummy $PINS SEL_VIN=SEL_VIN SEL_VIN_N=SEL_VIN_N SEL_VREF_N=SEL_VREF_N
+  SEL_VREF_N_N=SEL_VREF_N_N SEL_VREF_P=SEL_VREF_P SEL_VREF_P_N=SEL_VREF_P_N
+  VDD=VDD! VIN=VIN VREF_N=VREF_N VREF_P=VREF_P VSS=VSS!
  XI2<4> unit_capacitor_dummy $PINS SEL_VIN=SEL_VIN SEL_VIN_N=SEL_VIN_N SEL_VREF_N=SEL_VREF_N
+  SEL_VREF_N_N=SEL_VREF_N_N SEL_VREF_P=SEL_VREF_P SEL_VREF_P_N=SEL_VREF_P_N
+  VDD=VDD! VIN=VIN VREF_N=VREF_N VREF_P=VREF_P VSS=VSS!
  XI2<5> unit_capacitor_dummy $PINS SEL_VIN=SEL_VIN SEL_VIN_N=SEL_VIN_N SEL_VREF_N=SEL_VREF_N
+  SEL_VREF_N_N=SEL_VREF_N_N SEL_VREF_P=SEL_VREF_P SEL_VREF_P_N=SEL_VREF_P_N
+  VDD=VDD! VIN=VIN VREF_N=VREF_N VREF_P=VREF_P VSS=VSS!
  XI2<6> unit_capacitor_dummy $PINS SEL_VIN=SEL_VIN SEL_VIN_N=SEL_VIN_N SEL_VREF_N=SEL_VREF_N
+  SEL_VREF_N_N=SEL_VREF_N_N SEL_VREF_P=SEL_VREF_P SEL_VREF_P_N=SEL_VREF_P_N
+  VDD=VDD! VIN=VIN VREF_N=VREF_N VREF_P=VREF_P VSS=VSS!
.ends unit_capacitor_1_in_8_R

.subckt unit_capacitor_2_in_8_R SAMPLE TOP_PLATE VIN VREF_N VREF_P VREF_SEL
*PVSCELL netlisted from NS_SAR_Analog unit_capacitor_2_in_8_R schematic
  XI1 gate_driver $PINS SAMPLE=SAMPLE SEL_VIN=SEL_VIN SEL_VIN_N=SEL_VIN_N
+  SEL_VREF_N=SEL_VREF_N SEL_VREF_N_N=SEL_VREF_N_N SEL_VREF_P=SEL_VREF_P SEL_VREF_P_N=SEL_VREF_P_N
+  VREF=VREF_SEL
  XI0<0> unit_capacitor $PINS SEL_VIN=SEL_VIN SEL_VIN_N=SEL_VIN_N SEL_VREF_N=SEL_VREF_N
+  SEL_VREF_N_N=SEL_VREF_N_N SEL_VREF_P=SEL_VREF_P SEL_VREF_P_N=SEL_VREF_P_N
+  TOP_PLATE=TOP_PLATE VDD=VDD! VIN=VIN VREF_N=VREF_N VREF_P=VREF_P VSS=VSS!
  XI0<1> unit_capacitor $PINS SEL_VIN=SEL_VIN SEL_VIN_N=SEL_VIN_N SEL_VREF_N=SEL_VREF_N
+  SEL_VREF_N_N=SEL_VREF_N_N SEL_VREF_P=SEL_VREF_P SEL_VREF_P_N=SEL_VREF_P_N
+  TOP_PLATE=TOP_PLATE VDD=VDD! VIN=VIN VREF_N=VREF_N VREF_P=VREF_P VSS=VSS!
  XI2<0> unit_capacitor_dummy $PINS SEL_VIN=SEL_VIN SEL_VIN_N=SEL_VIN_N SEL_VREF_N=SEL_VREF_N
+  SEL_VREF_N_N=SEL_VREF_N_N SEL_VREF_P=SEL_VREF_P SEL_VREF_P_N=SEL_VREF_P_N
+  VDD=VDD! VIN=VIN VREF_N=VREF_N VREF_P=VREF_P VSS=VSS!
  XI2<1> unit_capacitor_dummy $PINS SEL_VIN=SEL_VIN SEL_VIN_N=SEL_VIN_N SEL_VREF_N=SEL_VREF_N
+  SEL_VREF_N_N=SEL_VREF_N_N SEL_VREF_P=SEL_VREF_P SEL_VREF_P_N=SEL_VREF_P_N
+  VDD=VDD! VIN=VIN VREF_N=VREF_N VREF_P=VREF_P VSS=VSS!
  XI2<2> unit_capacitor_dummy $PINS SEL_VIN=SEL_VIN SEL_VIN_N=SEL_VIN_N SEL_VREF_N=SEL_VREF_N
+  SEL_VREF_N_N=SEL_VREF_N_N SEL_VREF_P=SEL_VREF_P SEL_VREF_P_N=SEL_VREF_P_N
+  VDD=VDD! VIN=VIN VREF_N=VREF_N VREF_P=VREF_P VSS=VSS!
  XI2<3> unit_capacitor_dummy $PINS SEL_VIN=SEL_VIN SEL_VIN_N=SEL_VIN_N SEL_VREF_N=SEL_VREF_N
+  SEL_VREF_N_N=SEL_VREF_N_N SEL_VREF_P=SEL_VREF_P SEL_VREF_P_N=SEL_VREF_P_N
+  VDD=VDD! VIN=VIN VREF_N=VREF_N VREF_P=VREF_P VSS=VSS!
  XI2<4> unit_capacitor_dummy $PINS SEL_VIN=SEL_VIN SEL_VIN_N=SEL_VIN_N SEL_VREF_N=SEL_VREF_N
+  SEL_VREF_N_N=SEL_VREF_N_N SEL_VREF_P=SEL_VREF_P SEL_VREF_P_N=SEL_VREF_P_N
+  VDD=VDD! VIN=VIN VREF_N=VREF_N VREF_P=VREF_P VSS=VSS!
  XI2<5> unit_capacitor_dummy $PINS SEL_VIN=SEL_VIN SEL_VIN_N=SEL_VIN_N SEL_VREF_N=SEL_VREF_N
+  SEL_VREF_N_N=SEL_VREF_N_N SEL_VREF_P=SEL_VREF_P SEL_VREF_P_N=SEL_VREF_P_N
+  VDD=VDD! VIN=VIN VREF_N=VREF_N VREF_P=VREF_P VSS=VSS!
.ends unit_capacitor_2_in_8_R

.subckt unit_capacitor_4_in_8_L SAMPLE TOP_PLATE VIN VREF_N VREF_P VREF_SEL
*PVSCELL netlisted from NS_SAR_Analog unit_capacitor_4_in_8_L schematic
  XI3 gate_driver $PINS SAMPLE=SAMPLE SEL_VIN=SEL_VIN SEL_VIN_N=SEL_VIN_N
+  SEL_VREF_N=SEL_VREF_N SEL_VREF_N_N=SEL_VREF_N_N SEL_VREF_P=SEL_VREF_P SEL_VREF_P_N=SEL_VREF_P_N
+  VREF=VREF_SEL
  XI0<0> unit_capacitor $PINS SEL_VIN=SEL_VIN SEL_VIN_N=SEL_VIN_N SEL_VREF_N=SEL_VREF_N
+  SEL_VREF_N_N=SEL_VREF_N_N SEL_VREF_P=SEL_VREF_P SEL_VREF_P_N=SEL_VREF_P_N
+  TOP_PLATE=TOP_PLATE VDD=VDD! VIN=VIN VREF_N=VREF_N VREF_P=VREF_P VSS=VSS!
  XI0<1> unit_capacitor $PINS SEL_VIN=SEL_VIN SEL_VIN_N=SEL_VIN_N SEL_VREF_N=SEL_VREF_N
+  SEL_VREF_N_N=SEL_VREF_N_N SEL_VREF_P=SEL_VREF_P SEL_VREF_P_N=SEL_VREF_P_N
+  TOP_PLATE=TOP_PLATE VDD=VDD! VIN=VIN VREF_N=VREF_N VREF_P=VREF_P VSS=VSS!
  XI0<2> unit_capacitor $PINS SEL_VIN=SEL_VIN SEL_VIN_N=SEL_VIN_N SEL_VREF_N=SEL_VREF_N
+  SEL_VREF_N_N=SEL_VREF_N_N SEL_VREF_P=SEL_VREF_P SEL_VREF_P_N=SEL_VREF_P_N
+  TOP_PLATE=TOP_PLATE VDD=VDD! VIN=VIN VREF_N=VREF_N VREF_P=VREF_P VSS=VSS!
  XI0<3> unit_capacitor $PINS SEL_VIN=SEL_VIN SEL_VIN_N=SEL_VIN_N SEL_VREF_N=SEL_VREF_N
+  SEL_VREF_N_N=SEL_VREF_N_N SEL_VREF_P=SEL_VREF_P SEL_VREF_P_N=SEL_VREF_P_N
+  TOP_PLATE=TOP_PLATE VDD=VDD! VIN=VIN VREF_N=VREF_N VREF_P=VREF_P VSS=VSS!
  XI2<0> unit_capacitor_dummy $PINS SEL_VIN=SEL_VIN SEL_VIN_N=SEL_VIN_N SEL_VREF_N=SEL_VREF_N
+  SEL_VREF_N_N=SEL_VREF_N_N SEL_VREF_P=SEL_VREF_P SEL_VREF_P_N=SEL_VREF_P_N
+  VDD=VDD! VIN=VIN VREF_N=VREF_N VREF_P=VREF_P VSS=VSS!
  XI2<1> unit_capacitor_dummy $PINS SEL_VIN=SEL_VIN SEL_VIN_N=SEL_VIN_N SEL_VREF_N=SEL_VREF_N
+  SEL_VREF_N_N=SEL_VREF_N_N SEL_VREF_P=SEL_VREF_P SEL_VREF_P_N=SEL_VREF_P_N
+  VDD=VDD! VIN=VIN VREF_N=VREF_N VREF_P=VREF_P VSS=VSS!
  XI2<2> unit_capacitor_dummy $PINS SEL_VIN=SEL_VIN SEL_VIN_N=SEL_VIN_N SEL_VREF_N=SEL_VREF_N
+  SEL_VREF_N_N=SEL_VREF_N_N SEL_VREF_P=SEL_VREF_P SEL_VREF_P_N=SEL_VREF_P_N
+  VDD=VDD! VIN=VIN VREF_N=VREF_N VREF_P=VREF_P VSS=VSS!
  XI2<3> unit_capacitor_dummy $PINS SEL_VIN=SEL_VIN SEL_VIN_N=SEL_VIN_N SEL_VREF_N=SEL_VREF_N
+  SEL_VREF_N_N=SEL_VREF_N_N SEL_VREF_P=SEL_VREF_P SEL_VREF_P_N=SEL_VREF_P_N
+  VDD=VDD! VIN=VIN VREF_N=VREF_N VREF_P=VREF_P VSS=VSS!
.ends unit_capacitor_4_in_8_L

.subckt unit_capacitor_4_in_8_R SAMPLE TOP_PLATE VIN VREF_N VREF_P VREF_SEL
*PVSCELL netlisted from NS_SAR_Analog unit_capacitor_4_in_8_R schematic
  XI3 gate_driver $PINS SAMPLE=SAMPLE SEL_VIN=SEL_VIN SEL_VIN_N=SEL_VIN_N
+  SEL_VREF_N=SEL_VREF_N SEL_VREF_N_N=SEL_VREF_N_N SEL_VREF_P=SEL_VREF_P SEL_VREF_P_N=SEL_VREF_P_N
+  VREF=VREF_SEL
  XI0<0> unit_capacitor $PINS SEL_VIN=SEL_VIN SEL_VIN_N=SEL_VIN_N SEL_VREF_N=SEL_VREF_N
+  SEL_VREF_N_N=SEL_VREF_N_N SEL_VREF_P=SEL_VREF_P SEL_VREF_P_N=SEL_VREF_P_N
+  TOP_PLATE=TOP_PLATE VDD=VDD! VIN=VIN VREF_N=VREF_N VREF_P=VREF_P VSS=VSS!
  XI0<1> unit_capacitor $PINS SEL_VIN=SEL_VIN SEL_VIN_N=SEL_VIN_N SEL_VREF_N=SEL_VREF_N
+  SEL_VREF_N_N=SEL_VREF_N_N SEL_VREF_P=SEL_VREF_P SEL_VREF_P_N=SEL_VREF_P_N
+  TOP_PLATE=TOP_PLATE VDD=VDD! VIN=VIN VREF_N=VREF_N VREF_P=VREF_P VSS=VSS!
  XI0<2> unit_capacitor $PINS SEL_VIN=SEL_VIN SEL_VIN_N=SEL_VIN_N SEL_VREF_N=SEL_VREF_N
+  SEL_VREF_N_N=SEL_VREF_N_N SEL_VREF_P=SEL_VREF_P SEL_VREF_P_N=SEL_VREF_P_N
+  TOP_PLATE=TOP_PLATE VDD=VDD! VIN=VIN VREF_N=VREF_N VREF_P=VREF_P VSS=VSS!
  XI0<3> unit_capacitor $PINS SEL_VIN=SEL_VIN SEL_VIN_N=SEL_VIN_N SEL_VREF_N=SEL_VREF_N
+  SEL_VREF_N_N=SEL_VREF_N_N SEL_VREF_P=SEL_VREF_P SEL_VREF_P_N=SEL_VREF_P_N
+  TOP_PLATE=TOP_PLATE VDD=VDD! VIN=VIN VREF_N=VREF_N VREF_P=VREF_P VSS=VSS!
  XI2<0> unit_capacitor_dummy $PINS SEL_VIN=SEL_VIN SEL_VIN_N=SEL_VIN_N SEL_VREF_N=SEL_VREF_N
+  SEL_VREF_N_N=SEL_VREF_N_N SEL_VREF_P=SEL_VREF_P SEL_VREF_P_N=SEL_VREF_P_N
+  VDD=VDD! VIN=VIN VREF_N=VREF_N VREF_P=VREF_P VSS=VSS!
  XI2<1> unit_capacitor_dummy $PINS SEL_VIN=SEL_VIN SEL_VIN_N=SEL_VIN_N SEL_VREF_N=SEL_VREF_N
+  SEL_VREF_N_N=SEL_VREF_N_N SEL_VREF_P=SEL_VREF_P SEL_VREF_P_N=SEL_VREF_P_N
+  VDD=VDD! VIN=VIN VREF_N=VREF_N VREF_P=VREF_P VSS=VSS!
  XI2<2> unit_capacitor_dummy $PINS SEL_VIN=SEL_VIN SEL_VIN_N=SEL_VIN_N SEL_VREF_N=SEL_VREF_N
+  SEL_VREF_N_N=SEL_VREF_N_N SEL_VREF_P=SEL_VREF_P SEL_VREF_P_N=SEL_VREF_P_N
+  VDD=VDD! VIN=VIN VREF_N=VREF_N VREF_P=VREF_P VSS=VSS!
  XI2<3> unit_capacitor_dummy $PINS SEL_VIN=SEL_VIN SEL_VIN_N=SEL_VIN_N SEL_VREF_N=SEL_VREF_N
+  SEL_VREF_N_N=SEL_VREF_N_N SEL_VREF_P=SEL_VREF_P SEL_VREF_P_N=SEL_VREF_P_N
+  VDD=VDD! VIN=VIN VREF_N=VREF_N VREF_P=VREF_P VSS=VSS!
.ends unit_capacitor_4_in_8_R

.subckt unit_capacitor_8_in_8_L SAMPLE TOP_PLATE VIN VREF_N VREF_P VREF_SEL
*PVSCELL netlisted from NS_SAR_Analog unit_capacitor_8_in_8_L schematic
  XI2 gate_driver $PINS SAMPLE=SAMPLE SEL_VIN=SEL_VIN SEL_VIN_N=SEL_VIN_N
+  SEL_VREF_N=SEL_VREF_N SEL_VREF_N_N=SEL_VREF_N_N SEL_VREF_P=SEL_VREF_P SEL_VREF_P_N=SEL_VREF_P_N
+  VREF=VREF_SEL
  XI0<0> unit_capacitor $PINS SEL_VIN=SEL_VIN SEL_VIN_N=SEL_VIN_N SEL_VREF_N=SEL_VREF_N
+  SEL_VREF_N_N=SEL_VREF_N_N SEL_VREF_P=SEL_VREF_P SEL_VREF_P_N=SEL_VREF_P_N
+  TOP_PLATE=TOP_PLATE VDD=VDD! VIN=VIN VREF_N=VREF_N VREF_P=VREF_P VSS=VSS!
  XI0<1> unit_capacitor $PINS SEL_VIN=SEL_VIN SEL_VIN_N=SEL_VIN_N SEL_VREF_N=SEL_VREF_N
+  SEL_VREF_N_N=SEL_VREF_N_N SEL_VREF_P=SEL_VREF_P SEL_VREF_P_N=SEL_VREF_P_N
+  TOP_PLATE=TOP_PLATE VDD=VDD! VIN=VIN VREF_N=VREF_N VREF_P=VREF_P VSS=VSS!
  XI0<2> unit_capacitor $PINS SEL_VIN=SEL_VIN SEL_VIN_N=SEL_VIN_N SEL_VREF_N=SEL_VREF_N
+  SEL_VREF_N_N=SEL_VREF_N_N SEL_VREF_P=SEL_VREF_P SEL_VREF_P_N=SEL_VREF_P_N
+  TOP_PLATE=TOP_PLATE VDD=VDD! VIN=VIN VREF_N=VREF_N VREF_P=VREF_P VSS=VSS!
  XI0<3> unit_capacitor $PINS SEL_VIN=SEL_VIN SEL_VIN_N=SEL_VIN_N SEL_VREF_N=SEL_VREF_N
+  SEL_VREF_N_N=SEL_VREF_N_N SEL_VREF_P=SEL_VREF_P SEL_VREF_P_N=SEL_VREF_P_N
+  TOP_PLATE=TOP_PLATE VDD=VDD! VIN=VIN VREF_N=VREF_N VREF_P=VREF_P VSS=VSS!
  XI0<4> unit_capacitor $PINS SEL_VIN=SEL_VIN SEL_VIN_N=SEL_VIN_N SEL_VREF_N=SEL_VREF_N
+  SEL_VREF_N_N=SEL_VREF_N_N SEL_VREF_P=SEL_VREF_P SEL_VREF_P_N=SEL_VREF_P_N
+  TOP_PLATE=TOP_PLATE VDD=VDD! VIN=VIN VREF_N=VREF_N VREF_P=VREF_P VSS=VSS!
  XI0<5> unit_capacitor $PINS SEL_VIN=SEL_VIN SEL_VIN_N=SEL_VIN_N SEL_VREF_N=SEL_VREF_N
+  SEL_VREF_N_N=SEL_VREF_N_N SEL_VREF_P=SEL_VREF_P SEL_VREF_P_N=SEL_VREF_P_N
+  TOP_PLATE=TOP_PLATE VDD=VDD! VIN=VIN VREF_N=VREF_N VREF_P=VREF_P VSS=VSS!
  XI0<6> unit_capacitor $PINS SEL_VIN=SEL_VIN SEL_VIN_N=SEL_VIN_N SEL_VREF_N=SEL_VREF_N
+  SEL_VREF_N_N=SEL_VREF_N_N SEL_VREF_P=SEL_VREF_P SEL_VREF_P_N=SEL_VREF_P_N
+  TOP_PLATE=TOP_PLATE VDD=VDD! VIN=VIN VREF_N=VREF_N VREF_P=VREF_P VSS=VSS!
  XI0<7> unit_capacitor $PINS SEL_VIN=SEL_VIN SEL_VIN_N=SEL_VIN_N SEL_VREF_N=SEL_VREF_N
+  SEL_VREF_N_N=SEL_VREF_N_N SEL_VREF_P=SEL_VREF_P SEL_VREF_P_N=SEL_VREF_P_N
+  TOP_PLATE=TOP_PLATE VDD=VDD! VIN=VIN VREF_N=VREF_N VREF_P=VREF_P VSS=VSS!
.ends unit_capacitor_8_in_8_L

.subckt unit_capacitor_8_in_8_R SAMPLE TOP_PLATE VIN VREF_N VREF_P VREF_SEL
*PVSCELL netlisted from NS_SAR_Analog unit_capacitor_8_in_8_R schematic
  XI2 gate_driver $PINS SAMPLE=SAMPLE SEL_VIN=SEL_VIN SEL_VIN_N=SEL_VIN_N
+  SEL_VREF_N=SEL_VREF_N SEL_VREF_N_N=SEL_VREF_N_N SEL_VREF_P=SEL_VREF_P SEL_VREF_P_N=SEL_VREF_P_N
+  VREF=VREF_SEL
  XI0<0> unit_capacitor $PINS SEL_VIN=SEL_VIN SEL_VIN_N=SEL_VIN_N SEL_VREF_N=SEL_VREF_N
+  SEL_VREF_N_N=SEL_VREF_N_N SEL_VREF_P=SEL_VREF_P SEL_VREF_P_N=SEL_VREF_P_N
+  TOP_PLATE=TOP_PLATE VDD=VDD! VIN=VIN VREF_N=VREF_N VREF_P=VREF_P VSS=VSS!
  XI0<1> unit_capacitor $PINS SEL_VIN=SEL_VIN SEL_VIN_N=SEL_VIN_N SEL_VREF_N=SEL_VREF_N
+  SEL_VREF_N_N=SEL_VREF_N_N SEL_VREF_P=SEL_VREF_P SEL_VREF_P_N=SEL_VREF_P_N
+  TOP_PLATE=TOP_PLATE VDD=VDD! VIN=VIN VREF_N=VREF_N VREF_P=VREF_P VSS=VSS!
  XI0<2> unit_capacitor $PINS SEL_VIN=SEL_VIN SEL_VIN_N=SEL_VIN_N SEL_VREF_N=SEL_VREF_N
+  SEL_VREF_N_N=SEL_VREF_N_N SEL_VREF_P=SEL_VREF_P SEL_VREF_P_N=SEL_VREF_P_N
+  TOP_PLATE=TOP_PLATE VDD=VDD! VIN=VIN VREF_N=VREF_N VREF_P=VREF_P VSS=VSS!
  XI0<3> unit_capacitor $PINS SEL_VIN=SEL_VIN SEL_VIN_N=SEL_VIN_N SEL_VREF_N=SEL_VREF_N
+  SEL_VREF_N_N=SEL_VREF_N_N SEL_VREF_P=SEL_VREF_P SEL_VREF_P_N=SEL_VREF_P_N
+  TOP_PLATE=TOP_PLATE VDD=VDD! VIN=VIN VREF_N=VREF_N VREF_P=VREF_P VSS=VSS!
  XI0<4> unit_capacitor $PINS SEL_VIN=SEL_VIN SEL_VIN_N=SEL_VIN_N SEL_VREF_N=SEL_VREF_N
+  SEL_VREF_N_N=SEL_VREF_N_N SEL_VREF_P=SEL_VREF_P SEL_VREF_P_N=SEL_VREF_P_N
+  TOP_PLATE=TOP_PLATE VDD=VDD! VIN=VIN VREF_N=VREF_N VREF_P=VREF_P VSS=VSS!
  XI0<5> unit_capacitor $PINS SEL_VIN=SEL_VIN SEL_VIN_N=SEL_VIN_N SEL_VREF_N=SEL_VREF_N
+  SEL_VREF_N_N=SEL_VREF_N_N SEL_VREF_P=SEL_VREF_P SEL_VREF_P_N=SEL_VREF_P_N
+  TOP_PLATE=TOP_PLATE VDD=VDD! VIN=VIN VREF_N=VREF_N VREF_P=VREF_P VSS=VSS!
  XI0<6> unit_capacitor $PINS SEL_VIN=SEL_VIN SEL_VIN_N=SEL_VIN_N SEL_VREF_N=SEL_VREF_N
+  SEL_VREF_N_N=SEL_VREF_N_N SEL_VREF_P=SEL_VREF_P SEL_VREF_P_N=SEL_VREF_P_N
+  TOP_PLATE=TOP_PLATE VDD=VDD! VIN=VIN VREF_N=VREF_N VREF_P=VREF_P VSS=VSS!
  XI0<7> unit_capacitor $PINS SEL_VIN=SEL_VIN SEL_VIN_N=SEL_VIN_N SEL_VREF_N=SEL_VREF_N
+  SEL_VREF_N_N=SEL_VREF_N_N SEL_VREF_P=SEL_VREF_P SEL_VREF_P_N=SEL_VREF_P_N
+  TOP_PLATE=TOP_PLATE VDD=VDD! VIN=VIN VREF_N=VREF_N VREF_P=VREF_P VSS=VSS!
.ends unit_capacitor_8_in_8_R

.subckt CDAC_DEM SAMPLE TOP_PLATE VIN VREF_N VREF_P VREF_SEL_1<1> VREF_SEL_1<0>
+  VREF_SEL_2 VREF_SEL_4<6> VREF_SEL_4<5> VREF_SEL_4<4> VREF_SEL_4<3> VREF_SEL_4<2>
+  VREF_SEL_4<1> VREF_SEL_4<0> VREF_SEL_8<27> VREF_SEL_8<26> VREF_SEL_8<25>
+  VREF_SEL_8<24> VREF_SEL_8<23> VREF_SEL_8<22> VREF_SEL_8<21> VREF_SEL_8<20>
+  VREF_SEL_8<19> VREF_SEL_8<18> VREF_SEL_8<17> VREF_SEL_8<16> VREF_SEL_8<15>
+  VREF_SEL_8<14> VREF_SEL_8<13> VREF_SEL_8<12> VREF_SEL_8<11> VREF_SEL_8<10>
+  VREF_SEL_8<9> VREF_SEL_8<8> VREF_SEL_8<7> VREF_SEL_8<6> VREF_SEL_8<5> VREF_SEL_8<4>
+  VREF_SEL_8<3> VREF_SEL_8<2> VREF_SEL_8<1> VREF_SEL_8<0>
*PVSCELL netlisted from NS_SAR_Analog CDAC_DEM schematic
  XI1L unit_capacitor_1_in_8_L $PINS SAMPLE=SAMPLE TOP_PLATE=TOP_PLATE VIN=VIN
+  VREF_N=VREF_N VREF_P=VREF_P VREF_SEL=VREF_SEL_1<0>
  XI1R unit_capacitor_1_in_8_R $PINS SAMPLE=SAMPLE TOP_PLATE=TOP_PLATE VIN=VIN
+  VREF_N=VREF_N VREF_P=VREF_P VREF_SEL=VREF_SEL_1<1>
  XI2R unit_capacitor_2_in_8_R $PINS SAMPLE=SAMPLE TOP_PLATE=TOP_PLATE VIN=VIN
+  VREF_N=VREF_N VREF_P=VREF_P VREF_SEL=VREF_SEL_2
  XI4L<0> unit_capacitor_4_in_8_L $PINS SAMPLE=SAMPLE TOP_PLATE=TOP_PLATE
+  VIN=VIN VREF_N=VREF_N VREF_P=VREF_P VREF_SEL=VREF_SEL_4<0>
  XI4L<1> unit_capacitor_4_in_8_L $PINS SAMPLE=SAMPLE TOP_PLATE=TOP_PLATE
+  VIN=VIN VREF_N=VREF_N VREF_P=VREF_P VREF_SEL=VREF_SEL_4<1>
  XI4L<2> unit_capacitor_4_in_8_L $PINS SAMPLE=SAMPLE TOP_PLATE=TOP_PLATE
+  VIN=VIN VREF_N=VREF_N VREF_P=VREF_P VREF_SEL=VREF_SEL_4<2>
  XI4L<3> unit_capacitor_4_in_8_L $PINS SAMPLE=SAMPLE TOP_PLATE=TOP_PLATE
+  VIN=VIN VREF_N=VREF_N VREF_P=VREF_P VREF_SEL=VREF_SEL_4<3>
  XI4R<0> unit_capacitor_4_in_8_R $PINS SAMPLE=SAMPLE TOP_PLATE=TOP_PLATE
+  VIN=VIN VREF_N=VREF_N VREF_P=VREF_P VREF_SEL=VREF_SEL_4<4>
  XI4R<1> unit_capacitor_4_in_8_R $PINS SAMPLE=SAMPLE TOP_PLATE=TOP_PLATE
+  VIN=VIN VREF_N=VREF_N VREF_P=VREF_P VREF_SEL=VREF_SEL_4<5>
  XI4R<2> unit_capacitor_4_in_8_R $PINS SAMPLE=SAMPLE TOP_PLATE=TOP_PLATE
+  VIN=VIN VREF_N=VREF_N VREF_P=VREF_P VREF_SEL=VREF_SEL_4<6>
  XI8L<0> unit_capacitor_8_in_8_L $PINS SAMPLE=SAMPLE TOP_PLATE=TOP_PLATE
+  VIN=VIN VREF_N=VREF_N VREF_P=VREF_P VREF_SEL=VREF_SEL_8<0>
  XI8L<1> unit_capacitor_8_in_8_L $PINS SAMPLE=SAMPLE TOP_PLATE=TOP_PLATE
+  VIN=VIN VREF_N=VREF_N VREF_P=VREF_P VREF_SEL=VREF_SEL_8<1>
  XI8L<2> unit_capacitor_8_in_8_L $PINS SAMPLE=SAMPLE TOP_PLATE=TOP_PLATE
+  VIN=VIN VREF_N=VREF_N VREF_P=VREF_P VREF_SEL=VREF_SEL_8<2>
  XI8L<3> unit_capacitor_8_in_8_L $PINS SAMPLE=SAMPLE TOP_PLATE=TOP_PLATE
+  VIN=VIN VREF_N=VREF_N VREF_P=VREF_P VREF_SEL=VREF_SEL_8<3>
  XI8L<4> unit_capacitor_8_in_8_L $PINS SAMPLE=SAMPLE TOP_PLATE=TOP_PLATE
+  VIN=VIN VREF_N=VREF_N VREF_P=VREF_P VREF_SEL=VREF_SEL_8<4>
  XI8L<5> unit_capacitor_8_in_8_L $PINS SAMPLE=SAMPLE TOP_PLATE=TOP_PLATE
+  VIN=VIN VREF_N=VREF_N VREF_P=VREF_P VREF_SEL=VREF_SEL_8<5>
  XI8L<6> unit_capacitor_8_in_8_L $PINS SAMPLE=SAMPLE TOP_PLATE=TOP_PLATE
+  VIN=VIN VREF_N=VREF_N VREF_P=VREF_P VREF_SEL=VREF_SEL_8<6>
  XI8L<7> unit_capacitor_8_in_8_L $PINS SAMPLE=SAMPLE TOP_PLATE=TOP_PLATE
+  VIN=VIN VREF_N=VREF_N VREF_P=VREF_P VREF_SEL=VREF_SEL_8<7>
  XI8L<8> unit_capacitor_8_in_8_L $PINS SAMPLE=SAMPLE TOP_PLATE=TOP_PLATE
+  VIN=VIN VREF_N=VREF_N VREF_P=VREF_P VREF_SEL=VREF_SEL_8<8>
  XI8L<9> unit_capacitor_8_in_8_L $PINS SAMPLE=SAMPLE TOP_PLATE=TOP_PLATE
+  VIN=VIN VREF_N=VREF_N VREF_P=VREF_P VREF_SEL=VREF_SEL_8<9>
  XI8L<10> unit_capacitor_8_in_8_L $PINS SAMPLE=SAMPLE TOP_PLATE=TOP_PLATE
+  VIN=VIN VREF_N=VREF_N VREF_P=VREF_P VREF_SEL=VREF_SEL_8<10>
  XI8L<11> unit_capacitor_8_in_8_L $PINS SAMPLE=SAMPLE TOP_PLATE=TOP_PLATE
+  VIN=VIN VREF_N=VREF_N VREF_P=VREF_P VREF_SEL=VREF_SEL_8<11>
  XI8L<12> unit_capacitor_8_in_8_L $PINS SAMPLE=SAMPLE TOP_PLATE=TOP_PLATE
+  VIN=VIN VREF_N=VREF_N VREF_P=VREF_P VREF_SEL=VREF_SEL_8<12>
  XI8L<13> unit_capacitor_8_in_8_L $PINS SAMPLE=SAMPLE TOP_PLATE=TOP_PLATE
+  VIN=VIN VREF_N=VREF_N VREF_P=VREF_P VREF_SEL=VREF_SEL_8<13>
  XI8R<0> unit_capacitor_8_in_8_R $PINS SAMPLE=SAMPLE TOP_PLATE=TOP_PLATE
+  VIN=VIN VREF_N=VREF_N VREF_P=VREF_P VREF_SEL=VREF_SEL_8<14>
  XI8R<1> unit_capacitor_8_in_8_R $PINS SAMPLE=SAMPLE TOP_PLATE=TOP_PLATE
+  VIN=VIN VREF_N=VREF_N VREF_P=VREF_P VREF_SEL=VREF_SEL_8<15>
  XI8R<2> unit_capacitor_8_in_8_R $PINS SAMPLE=SAMPLE TOP_PLATE=TOP_PLATE
+  VIN=VIN VREF_N=VREF_N VREF_P=VREF_P VREF_SEL=VREF_SEL_8<16>
  XI8R<3> unit_capacitor_8_in_8_R $PINS SAMPLE=SAMPLE TOP_PLATE=TOP_PLATE
+  VIN=VIN VREF_N=VREF_N VREF_P=VREF_P VREF_SEL=VREF_SEL_8<17>
  XI8R<4> unit_capacitor_8_in_8_R $PINS SAMPLE=SAMPLE TOP_PLATE=TOP_PLATE
+  VIN=VIN VREF_N=VREF_N VREF_P=VREF_P VREF_SEL=VREF_SEL_8<18>
  XI8R<5> unit_capacitor_8_in_8_R $PINS SAMPLE=SAMPLE TOP_PLATE=TOP_PLATE
+  VIN=VIN VREF_N=VREF_N VREF_P=VREF_P VREF_SEL=VREF_SEL_8<19>
  XI8R<6> unit_capacitor_8_in_8_R $PINS SAMPLE=SAMPLE TOP_PLATE=TOP_PLATE
+  VIN=VIN VREF_N=VREF_N VREF_P=VREF_P VREF_SEL=VREF_SEL_8<20>
  XI8R<7> unit_capacitor_8_in_8_R $PINS SAMPLE=SAMPLE TOP_PLATE=TOP_PLATE
+  VIN=VIN VREF_N=VREF_N VREF_P=VREF_P VREF_SEL=VREF_SEL_8<21>
  XI8R<8> unit_capacitor_8_in_8_R $PINS SAMPLE=SAMPLE TOP_PLATE=TOP_PLATE
+  VIN=VIN VREF_N=VREF_N VREF_P=VREF_P VREF_SEL=VREF_SEL_8<22>
  XI8R<9> unit_capacitor_8_in_8_R $PINS SAMPLE=SAMPLE TOP_PLATE=TOP_PLATE
+  VIN=VIN VREF_N=VREF_N VREF_P=VREF_P VREF_SEL=VREF_SEL_8<23>
  XI8R<10> unit_capacitor_8_in_8_R $PINS SAMPLE=SAMPLE TOP_PLATE=TOP_PLATE
+  VIN=VIN VREF_N=VREF_N VREF_P=VREF_P VREF_SEL=VREF_SEL_8<24>
  XI8R<11> unit_capacitor_8_in_8_R $PINS SAMPLE=SAMPLE TOP_PLATE=TOP_PLATE
+  VIN=VIN VREF_N=VREF_N VREF_P=VREF_P VREF_SEL=VREF_SEL_8<25>
  XI8R<12> unit_capacitor_8_in_8_R $PINS SAMPLE=SAMPLE TOP_PLATE=TOP_PLATE
+  VIN=VIN VREF_N=VREF_N VREF_P=VREF_P VREF_SEL=VREF_SEL_8<26>
  XI8R<13> unit_capacitor_8_in_8_R $PINS SAMPLE=SAMPLE TOP_PLATE=TOP_PLATE
+  VIN=VIN VREF_N=VREF_N VREF_P=VREF_P VREF_SEL=VREF_SEL_8<27>
  CC0 VREF_P VSS! cap_mim_m3__base l=4u w=4u m=16
  CC1 VREF_N VSS! cap_mim_m3__base l=4u w=4u m=16
  CC2 VREF_P VREF_N cap_mim_m3__base l=4u w=4u m=24
  CC3 VREF_N VREF_P cap_mim_m3__base l=4u w=4u m=24
  CC4 VDD! VSS! cap_mim_m3__base l=4u w=4u m=2
.ends CDAC_DEM

***********************************************************
*             Completed at Aug 28 13:56:15 2026           *
***********************************************************
