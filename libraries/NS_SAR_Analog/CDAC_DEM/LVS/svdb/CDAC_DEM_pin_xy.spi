* +++++++++++++++++++++++++++++++++++++++++++++++++++++ *
* CDL Netlist:                                          *
*                                                       *
* Cell Name  : CDAC_DEM                                 *
* Netlisted  : Fri Aug 28 13:52:56 2026                 *
* PVS Version: 16.10-p006 Thu Jul 27 18:05:02 PDT 2017 *
* +++++++++++++++++++++++++++++++++++++++++++++++++++++ *
*.LDD
*.DEVTMPLT 0 R(res_generic_m1) met1_res met1(P) met1(N)
*.DEVTMPLT 1 R(res_generic_m2) met2_res met2(P) met2(N)
*.DEVTMPLT 2 R(res_generic_m3) met3_res met3(P) met3(N)
*.DEVTMPLT 3 R(res_generic_m4) met4_res met4(P) met4(N)
*.DEVTMPLT 4 R(res_generic_m5) met5_res met5(P) met5(N)
*.DEVTMPLT 5 D(diode_pd2nw_05v5) diode_pd2nw_05v5_rec psd(PLUS) nwell(MINUS)
*.DEVTMPLT 6 D(diode_pd2nw_05v5_hvt) diode_pd2nw_05v5_hvt_rec psd(PLUS) nwell(MINUS)
*.DEVTMPLT 7 D(diode_pd2nw_05v5_lvt) diode_pd2nw_05v5_lvt_rec psd(PLUS) nwell(MINUS)
*.DEVTMPLT 8 D(diode_pd2nw_11v0) diode_pd2nw_11v0_rec psd(PLUS) nwell(MINUS)
*.DEVTMPLT 9 D(diode_pw2nd_05v5) diode_pw2nd_05v5_rec pwell_all(PLUS) nsd(MINUS)
*.DEVTMPLT 10 D(diode_pw2nd_05v5_lvt) diode_pw2nd_05v5_lvt_rec pwell_all(PLUS) nsd(MINUS)
*.DEVTMPLT 11 D(diode_pw2nd_05v5_nvt) diode_pw2nd_05v5_nvt_rec pwell_all(PLUS) nsd(MINUS)
*.DEVTMPLT 12 D(diode_pw2nd_11v0) diode_pw2nd_11v0_rec pwell_all(PLUS) nsd(MINUS)
*.DEVTMPLT 13 R(RES_GENERIC_ND) diff_res np_term(P) np_term(N)
*.DEVTMPLT 14 R(RES_GENERIC_PD) diff_res pp_term(P) pp_term(N)
*.DEVTMPLT 15 MN(nfet_01v8) nfet_01v8_rec nSourceDrain(D) nfet(G) nSourceDrain(S) pwell_all(B)
*.DEVTMPLT 16 MP(pfet_01v8) pfet_01v8_rec pSourceDrain(D) pfet(G) pSourceDrain(S) nwell(B)
*.DEVTMPLT 17 MP(pfet_01v8_lvt) lvtpfet_01v8_rec pSourceDrain(D) lvtpfet(G) pSourceDrain(S) nwell(B)
*.DEVTMPLT 18 MN(nfet_01v8_lvt) lvtnfet_01v8_rec nSourceDrain(D) lvtnfet(G) nSourceDrain(S) pwell_all(B)
*.DEVTMPLT 19 MP(pfet_01v8_hvt) hvtpfet_01v8_rec pSourceDrain(D) hvtpfet(G) pSourceDrain(S) nwell(B)
*.DEVTMPLT 20 MN(nfet_03v3_nvt) HV_ngate_3v3 HV_source_drain(D) HV_FET_gate(G) HV_source_drain(S) pwell_all(B)
*.DEVTMPLT 21 MN(nfet_05v0_nvt) HV_ngate_5v0 HV_source_drain(D) HV_FET_gate(G) HV_source_drain(S) pwell_all(B)
*.DEVTMPLT 22 MN(nfet_g5v0d10v5) HV_ngate_5v10v HV_source_drain(D) HV_FET_gate(G) HV_source_drain(S) pwell_all(B)
*.DEVTMPLT 23 MP(pfet_g5v0d10v5) HV_pgate_5v10v HV_source_drain(D) HV_FET_gate(G) HV_source_drain(S) nwell(B)
*.DEVTMPLT 24 MN(nfet_20v0) nfet_v20_rec nfet_v20_drain(D) nfet_v20_gate(G) nfet_v20_source(S) pwell_all(B)
*.DEVTMPLT 25 MN(nfet_20v0_zvt) nfet_v20_zvt_rec nfet_v20_drain(D) nfet_v20_gate(G) nfet_v20_source(S) pwell_all(B)
*.DEVTMPLT 26 MP(pfet_20v0) pfet_v20_rec pfet_v20_drain(D) pfet_v20_gate(G) pfet_v20_source(S) nwell(B)
*.DEVTMPLT 27 Q(npn_05v5) npn_rec npnC(C) npnB(B) npnE(E) pwell_all(BN)
*.DEVTMPLT 28 Q(npn_11v0) hvnpn_rec npnC(C) npnB(B) hvnpnE(E) pwell_all(BN)
*.DEVTMPLT 29 Q(pnp_05v5) pnp_rec pnpC(C) pnpB(B) pnpE(E) pwell_all(BN)
*.DEVTMPLT 30 R(res_high_po_0p35) res_high_po_0p35_rec prec_resistor_term(PLUS) prec_resistor_term(MINUS) pwell_all(B)
*.DEVTMPLT 31 R(res_high_po_0p69) res_high_po_0p69_rec prec_resistor_term(PLUS) prec_resistor_term(MINUS) pwell_all(B)
*.DEVTMPLT 32 R(res_high_po_1p41) res_high_po_1p41_rec prec_resistor_term(PLUS) prec_resistor_term(MINUS) pwell_all(B)
*.DEVTMPLT 33 R(res_high_po_2p85) res_high_po_2p85_rec prec_resistor_term(PLUS) prec_resistor_term(MINUS) pwell_all(B)
*.DEVTMPLT 34 R(res_high_po_5p73) res_high_po_5p73_rec prec_resistor_term(PLUS) prec_resistor_term(MINUS) pwell_all(B)
*.DEVTMPLT 35 R(res_xhigh_po_0p35) res_xhigh_po_0p35_rec prec_resistor_term(PLUS) prec_resistor_term(MINUS) pwell_all(B)
*.DEVTMPLT 36 R(res_xhigh_po_0p69) res_xhigh_po_0p69_rec prec_resistor_term(PLUS) prec_resistor_term(MINUS) pwell_all(B)
*.DEVTMPLT 37 R(res_xhigh_po_1p41) res_xhigh_po_1p41_rec prec_resistor_term(PLUS) prec_resistor_term(MINUS) pwell_all(B)
*.DEVTMPLT 38 R(res_xhigh_po_2p85) res_xhigh_po_2p85_rec prec_resistor_term(PLUS) prec_resistor_term(MINUS) pwell_all(B)
*.DEVTMPLT 39 R(res_xhigh_po_5p73) res_xhigh_po_5p73_rec prec_resistor_term(PLUS) prec_resistor_term(MINUS) pwell_all(B)
*.DEVTMPLT 40 C(cap_mim_m3__base) capacitor top_plate(PLUS) bottom_plate(MINUS)

* +++++++++++++++++++++++++++++++++++++++++++++++++++++ *
* Sub cell: CDAC_DEM                                    *
* +++++++++++++++++++++++++++++++++++++++++++++++++++++ *
.subckt CDAC_DEM 871 52 806 807 1 53 795 54 808 2
+ 55 809 42 796 3 797 56 43 810 811
+ 44 798 57 812 799 58 45 59 800 813
+ 46 801 60 47 802 308 48 803 49 309
+ 804 50 805 324 51
** N=32847 EP=45 FDC=6036
M0 852 2 3 3 nfet_01v8 L=1.5e-07 W=7.6e-07 $X=2360 $Y=13010 $dt=15
M1 853 2 3 3 nfet_01v8 L=1.5e-07 W=7.6e-07 $X=2360 $Y=21290 $dt=15
M2 854 2 3 3 nfet_01v8 L=1.5e-07 W=7.6e-07 $X=2360 $Y=29570 $dt=15
M3 855 2 3 3 nfet_01v8 L=1.5e-07 W=7.6e-07 $X=2360 $Y=37850 $dt=15
M4 856 2 3 3 nfet_01v8 L=1.5e-07 W=7.6e-07 $X=2360 $Y=46130 $dt=15
M5 857 2 3 3 nfet_01v8 L=1.5e-07 W=7.6e-07 $X=2360 $Y=54410 $dt=15
M6 858 2 3 3 nfet_01v8 L=1.5e-07 W=7.6e-07 $X=2360 $Y=62690 $dt=15
M7 859 2 3 3 nfet_01v8 L=1.5e-07 W=7.6e-07 $X=2360 $Y=70970 $dt=15
M8 860 2 3 3 nfet_01v8 L=1.5e-07 W=7.6e-07 $X=2360 $Y=79250 $dt=15
M9 861 2 3 3 nfet_01v8 L=1.5e-07 W=7.6e-07 $X=2360 $Y=87530 $dt=15
M10 862 2 3 3 nfet_01v8 L=1.5e-07 W=7.6e-07 $X=2360 $Y=95810 $dt=15
M11 863 2 3 3 nfet_01v8 L=1.5e-07 W=7.6e-07 $X=2360 $Y=104090 $dt=15
M12 864 2 3 3 nfet_01v8 L=1.5e-07 W=7.6e-07 $X=2360 $Y=112370 $dt=15
M13 865 2 3 3 nfet_01v8 L=1.5e-07 W=7.6e-07 $X=2360 $Y=120650 $dt=15
M14 866 2 3 3 nfet_01v8 L=1.5e-07 W=7.6e-07 $X=2360 $Y=128930 $dt=15
M15 867 2 3 3 nfet_01v8 L=1.5e-07 W=7.6e-07 $X=2360 $Y=137210 $dt=15
M16 868 2 3 3 nfet_01v8 L=1.5e-07 W=7.6e-07 $X=2360 $Y=145490 $dt=15
M17 869 2 3 3 nfet_01v8 L=1.5e-07 W=7.6e-07 $X=2360 $Y=153770 $dt=15
M18 870 2 3 3 nfet_01v8 L=1.5e-07 W=7.6e-07 $X=2360 $Y=162050 $dt=15
M19 720 2 3 3 nfet_01v8 L=1.5e-07 W=7.6e-07 $X=2400 $Y=11070 $dt=15
M20 722 2 3 3 nfet_01v8 L=1.5e-07 W=7.6e-07 $X=2400 $Y=19350 $dt=15
M21 724 2 3 3 nfet_01v8 L=1.5e-07 W=7.6e-07 $X=2400 $Y=27630 $dt=15
M22 726 2 3 3 nfet_01v8 L=1.5e-07 W=7.6e-07 $X=2400 $Y=35910 $dt=15
M23 728 2 3 3 nfet_01v8 L=1.5e-07 W=7.6e-07 $X=2400 $Y=44190 $dt=15
M24 730 2 3 3 nfet_01v8 L=1.5e-07 W=7.6e-07 $X=2400 $Y=52470 $dt=15
M25 732 2 3 3 nfet_01v8 L=1.5e-07 W=7.6e-07 $X=2400 $Y=60750 $dt=15
M26 734 2 3 3 nfet_01v8 L=1.5e-07 W=7.6e-07 $X=2400 $Y=69030 $dt=15
M27 736 2 3 3 nfet_01v8 L=1.5e-07 W=7.6e-07 $X=2400 $Y=77310 $dt=15
M28 738 2 3 3 nfet_01v8 L=1.5e-07 W=7.6e-07 $X=2400 $Y=85590 $dt=15
M29 740 2 3 3 nfet_01v8 L=1.5e-07 W=7.6e-07 $X=2400 $Y=93870 $dt=15
M30 742 2 3 3 nfet_01v8 L=1.5e-07 W=7.6e-07 $X=2400 $Y=102150 $dt=15
M31 744 2 3 3 nfet_01v8 L=1.5e-07 W=7.6e-07 $X=2400 $Y=110430 $dt=15
M32 746 2 3 3 nfet_01v8 L=1.5e-07 W=7.6e-07 $X=2400 $Y=118710 $dt=15
M33 748 2 3 3 nfet_01v8 L=1.5e-07 W=7.6e-07 $X=2400 $Y=126990 $dt=15
M34 750 2 3 3 nfet_01v8 L=1.5e-07 W=7.6e-07 $X=2400 $Y=135270 $dt=15
M35 752 2 3 3 nfet_01v8 L=1.5e-07 W=7.6e-07 $X=2400 $Y=143550 $dt=15
M36 754 2 3 3 nfet_01v8 L=1.5e-07 W=7.6e-07 $X=2400 $Y=151830 $dt=15
M37 756 2 3 3 nfet_01v8 L=1.5e-07 W=7.6e-07 $X=2400 $Y=160110 $dt=15
M38 3 795 720 3 nfet_01v8 L=1.5e-07 W=7.6e-07 $X=2870 $Y=11070 $dt=15
M39 3 796 722 3 nfet_01v8 L=1.5e-07 W=7.6e-07 $X=2870 $Y=19350 $dt=15
M40 3 797 724 3 nfet_01v8 L=1.5e-07 W=7.6e-07 $X=2870 $Y=27630 $dt=15
M41 3 798 726 3 nfet_01v8 L=1.5e-07 W=7.6e-07 $X=2870 $Y=35910 $dt=15
M42 3 799 728 3 nfet_01v8 L=1.5e-07 W=7.6e-07 $X=2870 $Y=44190 $dt=15
M43 3 800 730 3 nfet_01v8 L=1.5e-07 W=7.6e-07 $X=2870 $Y=52470 $dt=15
M44 3 801 732 3 nfet_01v8 L=1.5e-07 W=7.6e-07 $X=2870 $Y=60750 $dt=15
M45 3 802 734 3 nfet_01v8 L=1.5e-07 W=7.6e-07 $X=2870 $Y=69030 $dt=15
M46 3 803 736 3 nfet_01v8 L=1.5e-07 W=7.6e-07 $X=2870 $Y=77310 $dt=15
M47 3 804 738 3 nfet_01v8 L=1.5e-07 W=7.6e-07 $X=2870 $Y=85590 $dt=15
M48 3 805 740 3 nfet_01v8 L=1.5e-07 W=7.6e-07 $X=2870 $Y=93870 $dt=15
M49 3 806 742 3 nfet_01v8 L=1.5e-07 W=7.6e-07 $X=2870 $Y=102150 $dt=15
M50 3 807 744 3 nfet_01v8 L=1.5e-07 W=7.6e-07 $X=2870 $Y=110430 $dt=15
M51 3 808 746 3 nfet_01v8 L=1.5e-07 W=7.6e-07 $X=2870 $Y=118710 $dt=15
M52 3 809 748 3 nfet_01v8 L=1.5e-07 W=7.6e-07 $X=2870 $Y=126990 $dt=15
M53 3 810 750 3 nfet_01v8 L=1.5e-07 W=7.6e-07 $X=2870 $Y=135270 $dt=15
M54 3 811 752 3 nfet_01v8 L=1.5e-07 W=7.6e-07 $X=2870 $Y=143550 $dt=15
M55 3 812 754 3 nfet_01v8 L=1.5e-07 W=7.6e-07 $X=2870 $Y=151830 $dt=15
M56 3 813 756 3 nfet_01v8 L=1.5e-07 W=7.6e-07 $X=2870 $Y=160110 $dt=15
M57 948 852 833 3 nfet_01v8 L=1.5e-07 W=4.25e-07 $X=3740 $Y=13010 $dt=15
M58 949 853 834 3 nfet_01v8 L=1.5e-07 W=4.25e-07 $X=3740 $Y=21290 $dt=15
M59 950 854 835 3 nfet_01v8 L=1.5e-07 W=4.25e-07 $X=3740 $Y=29570 $dt=15
M60 951 855 836 3 nfet_01v8 L=1.5e-07 W=4.25e-07 $X=3740 $Y=37850 $dt=15
M61 952 856 837 3 nfet_01v8 L=1.5e-07 W=4.25e-07 $X=3740 $Y=46130 $dt=15
M62 953 857 838 3 nfet_01v8 L=1.5e-07 W=4.25e-07 $X=3740 $Y=54410 $dt=15
M63 954 858 839 3 nfet_01v8 L=1.5e-07 W=4.25e-07 $X=3740 $Y=62690 $dt=15
M64 955 859 840 3 nfet_01v8 L=1.5e-07 W=4.25e-07 $X=3740 $Y=70970 $dt=15
M65 956 860 841 3 nfet_01v8 L=1.5e-07 W=4.25e-07 $X=3740 $Y=79250 $dt=15
M66 957 861 842 3 nfet_01v8 L=1.5e-07 W=4.25e-07 $X=3740 $Y=87530 $dt=15
M67 958 862 843 3 nfet_01v8 L=1.5e-07 W=4.25e-07 $X=3740 $Y=95810 $dt=15
M68 959 863 844 3 nfet_01v8 L=1.5e-07 W=4.25e-07 $X=3740 $Y=104090 $dt=15
M69 960 864 845 3 nfet_01v8 L=1.5e-07 W=4.25e-07 $X=3740 $Y=112370 $dt=15
M70 961 865 846 3 nfet_01v8 L=1.5e-07 W=4.25e-07 $X=3740 $Y=120650 $dt=15
M71 962 866 847 3 nfet_01v8 L=1.5e-07 W=4.25e-07 $X=3740 $Y=128930 $dt=15
M72 963 867 848 3 nfet_01v8 L=1.5e-07 W=4.25e-07 $X=3740 $Y=137210 $dt=15
M73 964 868 849 3 nfet_01v8 L=1.5e-07 W=4.25e-07 $X=3740 $Y=145490 $dt=15
M74 965 869 850 3 nfet_01v8 L=1.5e-07 W=4.25e-07 $X=3740 $Y=153770 $dt=15
M75 966 870 851 3 nfet_01v8 L=1.5e-07 W=4.25e-07 $X=3740 $Y=162050 $dt=15
M76 3 795 948 3 nfet_01v8 L=1.5e-07 W=4.25e-07 $X=4170 $Y=13010 $dt=15
M77 3 796 949 3 nfet_01v8 L=1.5e-07 W=4.25e-07 $X=4170 $Y=21290 $dt=15
M78 3 797 950 3 nfet_01v8 L=1.5e-07 W=4.25e-07 $X=4170 $Y=29570 $dt=15
M79 3 798 951 3 nfet_01v8 L=1.5e-07 W=4.25e-07 $X=4170 $Y=37850 $dt=15
M80 3 799 952 3 nfet_01v8 L=1.5e-07 W=4.25e-07 $X=4170 $Y=46130 $dt=15
M81 3 800 953 3 nfet_01v8 L=1.5e-07 W=4.25e-07 $X=4170 $Y=54410 $dt=15
M82 3 801 954 3 nfet_01v8 L=1.5e-07 W=4.25e-07 $X=4170 $Y=62690 $dt=15
M83 3 802 955 3 nfet_01v8 L=1.5e-07 W=4.25e-07 $X=4170 $Y=70970 $dt=15
M84 3 803 956 3 nfet_01v8 L=1.5e-07 W=4.25e-07 $X=4170 $Y=79250 $dt=15
M85 3 804 957 3 nfet_01v8 L=1.5e-07 W=4.25e-07 $X=4170 $Y=87530 $dt=15
M86 3 805 958 3 nfet_01v8 L=1.5e-07 W=4.25e-07 $X=4170 $Y=95810 $dt=15
M87 3 806 959 3 nfet_01v8 L=1.5e-07 W=4.25e-07 $X=4170 $Y=104090 $dt=15
M88 3 807 960 3 nfet_01v8 L=1.5e-07 W=4.25e-07 $X=4170 $Y=112370 $dt=15
M89 3 808 961 3 nfet_01v8 L=1.5e-07 W=4.25e-07 $X=4170 $Y=120650 $dt=15
M90 3 809 962 3 nfet_01v8 L=1.5e-07 W=4.25e-07 $X=4170 $Y=128930 $dt=15
M91 3 810 963 3 nfet_01v8 L=1.5e-07 W=4.25e-07 $X=4170 $Y=137210 $dt=15
M92 3 811 964 3 nfet_01v8 L=1.5e-07 W=4.25e-07 $X=4170 $Y=145490 $dt=15
M93 3 812 965 3 nfet_01v8 L=1.5e-07 W=4.25e-07 $X=4170 $Y=153770 $dt=15
M94 3 813 966 3 nfet_01v8 L=1.5e-07 W=4.25e-07 $X=4170 $Y=162050 $dt=15
M95 929 2 814 3 nfet_01v8 L=1.5e-07 W=4.25e-07 $X=4200 $Y=11405 $dt=15
M96 930 2 815 3 nfet_01v8 L=1.5e-07 W=4.25e-07 $X=4200 $Y=19685 $dt=15
M97 931 2 816 3 nfet_01v8 L=1.5e-07 W=4.25e-07 $X=4200 $Y=27965 $dt=15
M98 932 2 817 3 nfet_01v8 L=1.5e-07 W=4.25e-07 $X=4200 $Y=36245 $dt=15
M99 933 2 818 3 nfet_01v8 L=1.5e-07 W=4.25e-07 $X=4200 $Y=44525 $dt=15
M100 934 2 819 3 nfet_01v8 L=1.5e-07 W=4.25e-07 $X=4200 $Y=52805 $dt=15
M101 935 2 820 3 nfet_01v8 L=1.5e-07 W=4.25e-07 $X=4200 $Y=61085 $dt=15
M102 936 2 821 3 nfet_01v8 L=1.5e-07 W=4.25e-07 $X=4200 $Y=69365 $dt=15
M103 937 2 822 3 nfet_01v8 L=1.5e-07 W=4.25e-07 $X=4200 $Y=77645 $dt=15
M104 938 2 823 3 nfet_01v8 L=1.5e-07 W=4.25e-07 $X=4200 $Y=85925 $dt=15
M105 939 2 824 3 nfet_01v8 L=1.5e-07 W=4.25e-07 $X=4200 $Y=94205 $dt=15
M106 940 2 825 3 nfet_01v8 L=1.5e-07 W=4.25e-07 $X=4200 $Y=102485 $dt=15
M107 941 2 826 3 nfet_01v8 L=1.5e-07 W=4.25e-07 $X=4200 $Y=110765 $dt=15
M108 942 2 827 3 nfet_01v8 L=1.5e-07 W=4.25e-07 $X=4200 $Y=119045 $dt=15
M109 943 2 828 3 nfet_01v8 L=1.5e-07 W=4.25e-07 $X=4200 $Y=127325 $dt=15
M110 944 2 829 3 nfet_01v8 L=1.5e-07 W=4.25e-07 $X=4200 $Y=135605 $dt=15
M111 945 2 830 3 nfet_01v8 L=1.5e-07 W=4.25e-07 $X=4200 $Y=143885 $dt=15
M112 946 2 831 3 nfet_01v8 L=1.5e-07 W=4.25e-07 $X=4200 $Y=152165 $dt=15
M113 947 2 832 3 nfet_01v8 L=1.5e-07 W=4.25e-07 $X=4200 $Y=160445 $dt=15
M114 3 795 929 3 nfet_01v8 L=1.5e-07 W=4.25e-07 $X=4630 $Y=11405 $dt=15
M115 3 796 930 3 nfet_01v8 L=1.5e-07 W=4.25e-07 $X=4630 $Y=19685 $dt=15
M116 3 797 931 3 nfet_01v8 L=1.5e-07 W=4.25e-07 $X=4630 $Y=27965 $dt=15
M117 3 798 932 3 nfet_01v8 L=1.5e-07 W=4.25e-07 $X=4630 $Y=36245 $dt=15
M118 3 799 933 3 nfet_01v8 L=1.5e-07 W=4.25e-07 $X=4630 $Y=44525 $dt=15
M119 3 800 934 3 nfet_01v8 L=1.5e-07 W=4.25e-07 $X=4630 $Y=52805 $dt=15
M120 3 801 935 3 nfet_01v8 L=1.5e-07 W=4.25e-07 $X=4630 $Y=61085 $dt=15
M121 3 802 936 3 nfet_01v8 L=1.5e-07 W=4.25e-07 $X=4630 $Y=69365 $dt=15
M122 3 803 937 3 nfet_01v8 L=1.5e-07 W=4.25e-07 $X=4630 $Y=77645 $dt=15
M123 3 804 938 3 nfet_01v8 L=1.5e-07 W=4.25e-07 $X=4630 $Y=85925 $dt=15
M124 3 805 939 3 nfet_01v8 L=1.5e-07 W=4.25e-07 $X=4630 $Y=94205 $dt=15
M125 3 806 940 3 nfet_01v8 L=1.5e-07 W=4.25e-07 $X=4630 $Y=102485 $dt=15
M126 3 807 941 3 nfet_01v8 L=1.5e-07 W=4.25e-07 $X=4630 $Y=110765 $dt=15
M127 3 808 942 3 nfet_01v8 L=1.5e-07 W=4.25e-07 $X=4630 $Y=119045 $dt=15
M128 3 809 943 3 nfet_01v8 L=1.5e-07 W=4.25e-07 $X=4630 $Y=127325 $dt=15
M129 3 810 944 3 nfet_01v8 L=1.5e-07 W=4.25e-07 $X=4630 $Y=135605 $dt=15
M130 3 811 945 3 nfet_01v8 L=1.5e-07 W=4.25e-07 $X=4630 $Y=143885 $dt=15
M131 3 812 946 3 nfet_01v8 L=1.5e-07 W=4.25e-07 $X=4630 $Y=152165 $dt=15
M132 3 813 947 3 nfet_01v8 L=1.5e-07 W=4.25e-07 $X=4630 $Y=160445 $dt=15
M133 719 833 3 3 nfet_01v8 L=1.5e-07 W=7.6e-07 $X=4660 $Y=13010 $dt=15
M134 721 834 3 3 nfet_01v8 L=1.5e-07 W=7.6e-07 $X=4660 $Y=21290 $dt=15
M135 723 835 3 3 nfet_01v8 L=1.5e-07 W=7.6e-07 $X=4660 $Y=29570 $dt=15
M136 725 836 3 3 nfet_01v8 L=1.5e-07 W=7.6e-07 $X=4660 $Y=37850 $dt=15
M137 727 837 3 3 nfet_01v8 L=1.5e-07 W=7.6e-07 $X=4660 $Y=46130 $dt=15
M138 729 838 3 3 nfet_01v8 L=1.5e-07 W=7.6e-07 $X=4660 $Y=54410 $dt=15
M139 731 839 3 3 nfet_01v8 L=1.5e-07 W=7.6e-07 $X=4660 $Y=62690 $dt=15
M140 733 840 3 3 nfet_01v8 L=1.5e-07 W=7.6e-07 $X=4660 $Y=70970 $dt=15
M141 735 841 3 3 nfet_01v8 L=1.5e-07 W=7.6e-07 $X=4660 $Y=79250 $dt=15
M142 737 842 3 3 nfet_01v8 L=1.5e-07 W=7.6e-07 $X=4660 $Y=87530 $dt=15
M143 739 843 3 3 nfet_01v8 L=1.5e-07 W=7.6e-07 $X=4660 $Y=95810 $dt=15
M144 741 844 3 3 nfet_01v8 L=1.5e-07 W=7.6e-07 $X=4660 $Y=104090 $dt=15
M145 743 845 3 3 nfet_01v8 L=1.5e-07 W=7.6e-07 $X=4660 $Y=112370 $dt=15
M146 745 846 3 3 nfet_01v8 L=1.5e-07 W=7.6e-07 $X=4660 $Y=120650 $dt=15
M147 747 847 3 3 nfet_01v8 L=1.5e-07 W=7.6e-07 $X=4660 $Y=128930 $dt=15
M148 749 848 3 3 nfet_01v8 L=1.5e-07 W=7.6e-07 $X=4660 $Y=137210 $dt=15
M149 751 849 3 3 nfet_01v8 L=1.5e-07 W=7.6e-07 $X=4660 $Y=145490 $dt=15
M150 753 850 3 3 nfet_01v8 L=1.5e-07 W=7.6e-07 $X=4660 $Y=153770 $dt=15
M151 755 851 3 3 nfet_01v8 L=1.5e-07 W=7.6e-07 $X=4660 $Y=162050 $dt=15
M152 681 814 3 3 nfet_01v8 L=1.5e-07 W=7.6e-07 $X=5120 $Y=11070 $dt=15
M153 682 815 3 3 nfet_01v8 L=1.5e-07 W=7.6e-07 $X=5120 $Y=19350 $dt=15
M154 683 816 3 3 nfet_01v8 L=1.5e-07 W=7.6e-07 $X=5120 $Y=27630 $dt=15
M155 684 817 3 3 nfet_01v8 L=1.5e-07 W=7.6e-07 $X=5120 $Y=35910 $dt=15
M156 685 818 3 3 nfet_01v8 L=1.5e-07 W=7.6e-07 $X=5120 $Y=44190 $dt=15
M157 686 819 3 3 nfet_01v8 L=1.5e-07 W=7.6e-07 $X=5120 $Y=52470 $dt=15
M158 687 820 3 3 nfet_01v8 L=1.5e-07 W=7.6e-07 $X=5120 $Y=60750 $dt=15
M159 688 821 3 3 nfet_01v8 L=1.5e-07 W=7.6e-07 $X=5120 $Y=69030 $dt=15
M160 689 822 3 3 nfet_01v8 L=1.5e-07 W=7.6e-07 $X=5120 $Y=77310 $dt=15
M161 690 823 3 3 nfet_01v8 L=1.5e-07 W=7.6e-07 $X=5120 $Y=85590 $dt=15
M162 691 824 3 3 nfet_01v8 L=1.5e-07 W=7.6e-07 $X=5120 $Y=93870 $dt=15
M163 692 825 3 3 nfet_01v8 L=1.5e-07 W=7.6e-07 $X=5120 $Y=102150 $dt=15
M164 693 826 3 3 nfet_01v8 L=1.5e-07 W=7.6e-07 $X=5120 $Y=110430 $dt=15
M165 694 827 3 3 nfet_01v8 L=1.5e-07 W=7.6e-07 $X=5120 $Y=118710 $dt=15
M166 695 828 3 3 nfet_01v8 L=1.5e-07 W=7.6e-07 $X=5120 $Y=126990 $dt=15
M167 696 829 3 3 nfet_01v8 L=1.5e-07 W=7.6e-07 $X=5120 $Y=135270 $dt=15
M168 697 830 3 3 nfet_01v8 L=1.5e-07 W=7.6e-07 $X=5120 $Y=143550 $dt=15
M169 698 831 3 3 nfet_01v8 L=1.5e-07 W=7.6e-07 $X=5120 $Y=151830 $dt=15
M170 699 832 3 3 nfet_01v8 L=1.5e-07 W=7.6e-07 $X=5120 $Y=160110 $dt=15
M171 3 719 776 3 nfet_01v8 L=1.5e-07 W=7.6e-07 $X=6040 $Y=13010 $dt=15
M172 3 721 777 3 nfet_01v8 L=1.5e-07 W=7.6e-07 $X=6040 $Y=21290 $dt=15
M173 3 723 778 3 nfet_01v8 L=1.5e-07 W=7.6e-07 $X=6040 $Y=29570 $dt=15
M174 3 725 779 3 nfet_01v8 L=1.5e-07 W=7.6e-07 $X=6040 $Y=37850 $dt=15
M175 3 727 780 3 nfet_01v8 L=1.5e-07 W=7.6e-07 $X=6040 $Y=46130 $dt=15
M176 3 729 781 3 nfet_01v8 L=1.5e-07 W=7.6e-07 $X=6040 $Y=54410 $dt=15
M177 3 731 782 3 nfet_01v8 L=1.5e-07 W=7.6e-07 $X=6040 $Y=62690 $dt=15
M178 3 733 783 3 nfet_01v8 L=1.5e-07 W=7.6e-07 $X=6040 $Y=70970 $dt=15
M179 3 735 784 3 nfet_01v8 L=1.5e-07 W=7.6e-07 $X=6040 $Y=79250 $dt=15
M180 3 737 785 3 nfet_01v8 L=1.5e-07 W=7.6e-07 $X=6040 $Y=87530 $dt=15
M181 3 739 786 3 nfet_01v8 L=1.5e-07 W=7.6e-07 $X=6040 $Y=95810 $dt=15
M182 3 741 787 3 nfet_01v8 L=1.5e-07 W=7.6e-07 $X=6040 $Y=104090 $dt=15
M183 3 743 788 3 nfet_01v8 L=1.5e-07 W=7.6e-07 $X=6040 $Y=112370 $dt=15
M184 3 745 789 3 nfet_01v8 L=1.5e-07 W=7.6e-07 $X=6040 $Y=120650 $dt=15
M185 3 747 790 3 nfet_01v8 L=1.5e-07 W=7.6e-07 $X=6040 $Y=128930 $dt=15
M186 3 749 791 3 nfet_01v8 L=1.5e-07 W=7.6e-07 $X=6040 $Y=137210 $dt=15
M187 3 751 792 3 nfet_01v8 L=1.5e-07 W=7.6e-07 $X=6040 $Y=145490 $dt=15
M188 3 753 793 3 nfet_01v8 L=1.5e-07 W=7.6e-07 $X=6040 $Y=153770 $dt=15
M189 3 755 794 3 nfet_01v8 L=1.5e-07 W=7.6e-07 $X=6040 $Y=162050 $dt=15
M190 534 776 3 3 nfet_01v8 L=1.5e-07 W=7.6e-07 $X=6470 $Y=13010 $dt=15
M191 536 777 3 3 nfet_01v8 L=1.5e-07 W=7.6e-07 $X=6470 $Y=21290 $dt=15
M192 538 778 3 3 nfet_01v8 L=1.5e-07 W=7.6e-07 $X=6470 $Y=29570 $dt=15
M193 540 779 3 3 nfet_01v8 L=1.5e-07 W=7.6e-07 $X=6470 $Y=37850 $dt=15
M194 542 780 3 3 nfet_01v8 L=1.5e-07 W=7.6e-07 $X=6470 $Y=46130 $dt=15
M195 544 781 3 3 nfet_01v8 L=1.5e-07 W=7.6e-07 $X=6470 $Y=54410 $dt=15
M196 546 782 3 3 nfet_01v8 L=1.5e-07 W=7.6e-07 $X=6470 $Y=62690 $dt=15
M197 548 783 3 3 nfet_01v8 L=1.5e-07 W=7.6e-07 $X=6470 $Y=70970 $dt=15
M198 550 784 3 3 nfet_01v8 L=1.5e-07 W=7.6e-07 $X=6470 $Y=79250 $dt=15
M199 552 785 3 3 nfet_01v8 L=1.5e-07 W=7.6e-07 $X=6470 $Y=87530 $dt=15
M200 554 786 3 3 nfet_01v8 L=1.5e-07 W=7.6e-07 $X=6470 $Y=95810 $dt=15
M201 556 787 3 3 nfet_01v8 L=1.5e-07 W=7.6e-07 $X=6470 $Y=104090 $dt=15
M202 558 788 3 3 nfet_01v8 L=1.5e-07 W=7.6e-07 $X=6470 $Y=112370 $dt=15
M203 560 789 3 3 nfet_01v8 L=1.5e-07 W=7.6e-07 $X=6470 $Y=120650 $dt=15
M204 562 790 3 3 nfet_01v8 L=1.5e-07 W=7.6e-07 $X=6470 $Y=128930 $dt=15
M205 564 791 3 3 nfet_01v8 L=1.5e-07 W=7.6e-07 $X=6470 $Y=137210 $dt=15
M206 566 792 3 3 nfet_01v8 L=1.5e-07 W=7.6e-07 $X=6470 $Y=145490 $dt=15
M207 568 793 3 3 nfet_01v8 L=1.5e-07 W=7.6e-07 $X=6470 $Y=153770 $dt=15
M208 570 794 3 3 nfet_01v8 L=1.5e-07 W=7.6e-07 $X=6470 $Y=162050 $dt=15
M209 457 720 3 3 nfet_01v8 L=1.5e-07 W=7.6e-07 $X=6500 $Y=11070 $dt=15
M210 459 722 3 3 nfet_01v8 L=1.5e-07 W=7.6e-07 $X=6500 $Y=19350 $dt=15
M211 461 724 3 3 nfet_01v8 L=1.5e-07 W=7.6e-07 $X=6500 $Y=27630 $dt=15
M212 463 726 3 3 nfet_01v8 L=1.5e-07 W=7.6e-07 $X=6500 $Y=35910 $dt=15
M213 465 728 3 3 nfet_01v8 L=1.5e-07 W=7.6e-07 $X=6500 $Y=44190 $dt=15
M214 467 730 3 3 nfet_01v8 L=1.5e-07 W=7.6e-07 $X=6500 $Y=52470 $dt=15
M215 469 732 3 3 nfet_01v8 L=1.5e-07 W=7.6e-07 $X=6500 $Y=60750 $dt=15
M216 471 734 3 3 nfet_01v8 L=1.5e-07 W=7.6e-07 $X=6500 $Y=69030 $dt=15
M217 473 736 3 3 nfet_01v8 L=1.5e-07 W=7.6e-07 $X=6500 $Y=77310 $dt=15
M218 475 738 3 3 nfet_01v8 L=1.5e-07 W=7.6e-07 $X=6500 $Y=85590 $dt=15
M219 477 740 3 3 nfet_01v8 L=1.5e-07 W=7.6e-07 $X=6500 $Y=93870 $dt=15
M220 479 742 3 3 nfet_01v8 L=1.5e-07 W=7.6e-07 $X=6500 $Y=102150 $dt=15
M221 481 744 3 3 nfet_01v8 L=1.5e-07 W=7.6e-07 $X=6500 $Y=110430 $dt=15
M222 483 746 3 3 nfet_01v8 L=1.5e-07 W=7.6e-07 $X=6500 $Y=118710 $dt=15
M223 485 748 3 3 nfet_01v8 L=1.5e-07 W=7.6e-07 $X=6500 $Y=126990 $dt=15
M224 487 750 3 3 nfet_01v8 L=1.5e-07 W=7.6e-07 $X=6500 $Y=135270 $dt=15
M225 489 752 3 3 nfet_01v8 L=1.5e-07 W=7.6e-07 $X=6500 $Y=143550 $dt=15
M226 491 754 3 3 nfet_01v8 L=1.5e-07 W=7.6e-07 $X=6500 $Y=151830 $dt=15
M227 493 756 3 3 nfet_01v8 L=1.5e-07 W=7.6e-07 $X=6500 $Y=160110 $dt=15
M228 3 776 534 3 nfet_01v8 L=1.5e-07 W=7.6e-07 $X=6900 $Y=13010 $dt=15
M229 3 777 536 3 nfet_01v8 L=1.5e-07 W=7.6e-07 $X=6900 $Y=21290 $dt=15
M230 3 778 538 3 nfet_01v8 L=1.5e-07 W=7.6e-07 $X=6900 $Y=29570 $dt=15
M231 3 779 540 3 nfet_01v8 L=1.5e-07 W=7.6e-07 $X=6900 $Y=37850 $dt=15
M232 3 780 542 3 nfet_01v8 L=1.5e-07 W=7.6e-07 $X=6900 $Y=46130 $dt=15
M233 3 781 544 3 nfet_01v8 L=1.5e-07 W=7.6e-07 $X=6900 $Y=54410 $dt=15
M234 3 782 546 3 nfet_01v8 L=1.5e-07 W=7.6e-07 $X=6900 $Y=62690 $dt=15
M235 3 783 548 3 nfet_01v8 L=1.5e-07 W=7.6e-07 $X=6900 $Y=70970 $dt=15
M236 3 784 550 3 nfet_01v8 L=1.5e-07 W=7.6e-07 $X=6900 $Y=79250 $dt=15
M237 3 785 552 3 nfet_01v8 L=1.5e-07 W=7.6e-07 $X=6900 $Y=87530 $dt=15
M238 3 786 554 3 nfet_01v8 L=1.5e-07 W=7.6e-07 $X=6900 $Y=95810 $dt=15
M239 3 787 556 3 nfet_01v8 L=1.5e-07 W=7.6e-07 $X=6900 $Y=104090 $dt=15
M240 3 788 558 3 nfet_01v8 L=1.5e-07 W=7.6e-07 $X=6900 $Y=112370 $dt=15
M241 3 789 560 3 nfet_01v8 L=1.5e-07 W=7.6e-07 $X=6900 $Y=120650 $dt=15
M242 3 790 562 3 nfet_01v8 L=1.5e-07 W=7.6e-07 $X=6900 $Y=128930 $dt=15
M243 3 791 564 3 nfet_01v8 L=1.5e-07 W=7.6e-07 $X=6900 $Y=137210 $dt=15
M244 3 792 566 3 nfet_01v8 L=1.5e-07 W=7.6e-07 $X=6900 $Y=145490 $dt=15
M245 3 793 568 3 nfet_01v8 L=1.5e-07 W=7.6e-07 $X=6900 $Y=153770 $dt=15
M246 3 794 570 3 nfet_01v8 L=1.5e-07 W=7.6e-07 $X=6900 $Y=162050 $dt=15
M247 3 720 457 3 nfet_01v8 L=1.5e-07 W=7.6e-07 $X=6930 $Y=11070 $dt=15
M248 3 722 459 3 nfet_01v8 L=1.5e-07 W=7.6e-07 $X=6930 $Y=19350 $dt=15
M249 3 724 461 3 nfet_01v8 L=1.5e-07 W=7.6e-07 $X=6930 $Y=27630 $dt=15
M250 3 726 463 3 nfet_01v8 L=1.5e-07 W=7.6e-07 $X=6930 $Y=35910 $dt=15
M251 3 728 465 3 nfet_01v8 L=1.5e-07 W=7.6e-07 $X=6930 $Y=44190 $dt=15
M252 3 730 467 3 nfet_01v8 L=1.5e-07 W=7.6e-07 $X=6930 $Y=52470 $dt=15
M253 3 732 469 3 nfet_01v8 L=1.5e-07 W=7.6e-07 $X=6930 $Y=60750 $dt=15
M254 3 734 471 3 nfet_01v8 L=1.5e-07 W=7.6e-07 $X=6930 $Y=69030 $dt=15
M255 3 736 473 3 nfet_01v8 L=1.5e-07 W=7.6e-07 $X=6930 $Y=77310 $dt=15
M256 3 738 475 3 nfet_01v8 L=1.5e-07 W=7.6e-07 $X=6930 $Y=85590 $dt=15
M257 3 740 477 3 nfet_01v8 L=1.5e-07 W=7.6e-07 $X=6930 $Y=93870 $dt=15
M258 3 742 479 3 nfet_01v8 L=1.5e-07 W=7.6e-07 $X=6930 $Y=102150 $dt=15
M259 3 744 481 3 nfet_01v8 L=1.5e-07 W=7.6e-07 $X=6930 $Y=110430 $dt=15
M260 3 746 483 3 nfet_01v8 L=1.5e-07 W=7.6e-07 $X=6930 $Y=118710 $dt=15
M261 3 748 485 3 nfet_01v8 L=1.5e-07 W=7.6e-07 $X=6930 $Y=126990 $dt=15
M262 3 750 487 3 nfet_01v8 L=1.5e-07 W=7.6e-07 $X=6930 $Y=135270 $dt=15
M263 3 752 489 3 nfet_01v8 L=1.5e-07 W=7.6e-07 $X=6930 $Y=143550 $dt=15
M264 3 754 491 3 nfet_01v8 L=1.5e-07 W=7.6e-07 $X=6930 $Y=151830 $dt=15
M265 3 756 493 3 nfet_01v8 L=1.5e-07 W=7.6e-07 $X=6930 $Y=160110 $dt=15
M266 534 776 3 3 nfet_01v8 L=1.5e-07 W=7.6e-07 $X=7330 $Y=13010 $dt=15
M267 536 777 3 3 nfet_01v8 L=1.5e-07 W=7.6e-07 $X=7330 $Y=21290 $dt=15
M268 538 778 3 3 nfet_01v8 L=1.5e-07 W=7.6e-07 $X=7330 $Y=29570 $dt=15
M269 540 779 3 3 nfet_01v8 L=1.5e-07 W=7.6e-07 $X=7330 $Y=37850 $dt=15
M270 542 780 3 3 nfet_01v8 L=1.5e-07 W=7.6e-07 $X=7330 $Y=46130 $dt=15
M271 544 781 3 3 nfet_01v8 L=1.5e-07 W=7.6e-07 $X=7330 $Y=54410 $dt=15
M272 546 782 3 3 nfet_01v8 L=1.5e-07 W=7.6e-07 $X=7330 $Y=62690 $dt=15
M273 548 783 3 3 nfet_01v8 L=1.5e-07 W=7.6e-07 $X=7330 $Y=70970 $dt=15
M274 550 784 3 3 nfet_01v8 L=1.5e-07 W=7.6e-07 $X=7330 $Y=79250 $dt=15
M275 552 785 3 3 nfet_01v8 L=1.5e-07 W=7.6e-07 $X=7330 $Y=87530 $dt=15
M276 554 786 3 3 nfet_01v8 L=1.5e-07 W=7.6e-07 $X=7330 $Y=95810 $dt=15
M277 556 787 3 3 nfet_01v8 L=1.5e-07 W=7.6e-07 $X=7330 $Y=104090 $dt=15
M278 558 788 3 3 nfet_01v8 L=1.5e-07 W=7.6e-07 $X=7330 $Y=112370 $dt=15
M279 560 789 3 3 nfet_01v8 L=1.5e-07 W=7.6e-07 $X=7330 $Y=120650 $dt=15
M280 562 790 3 3 nfet_01v8 L=1.5e-07 W=7.6e-07 $X=7330 $Y=128930 $dt=15
M281 564 791 3 3 nfet_01v8 L=1.5e-07 W=7.6e-07 $X=7330 $Y=137210 $dt=15
M282 566 792 3 3 nfet_01v8 L=1.5e-07 W=7.6e-07 $X=7330 $Y=145490 $dt=15
M283 568 793 3 3 nfet_01v8 L=1.5e-07 W=7.6e-07 $X=7330 $Y=153770 $dt=15
M284 570 794 3 3 nfet_01v8 L=1.5e-07 W=7.6e-07 $X=7330 $Y=162050 $dt=15
M285 457 720 3 3 nfet_01v8 L=1.5e-07 W=7.6e-07 $X=7360 $Y=11070 $dt=15
M286 459 722 3 3 nfet_01v8 L=1.5e-07 W=7.6e-07 $X=7360 $Y=19350 $dt=15
M287 461 724 3 3 nfet_01v8 L=1.5e-07 W=7.6e-07 $X=7360 $Y=27630 $dt=15
M288 463 726 3 3 nfet_01v8 L=1.5e-07 W=7.6e-07 $X=7360 $Y=35910 $dt=15
M289 465 728 3 3 nfet_01v8 L=1.5e-07 W=7.6e-07 $X=7360 $Y=44190 $dt=15
M290 467 730 3 3 nfet_01v8 L=1.5e-07 W=7.6e-07 $X=7360 $Y=52470 $dt=15
M291 469 732 3 3 nfet_01v8 L=1.5e-07 W=7.6e-07 $X=7360 $Y=60750 $dt=15
M292 471 734 3 3 nfet_01v8 L=1.5e-07 W=7.6e-07 $X=7360 $Y=69030 $dt=15
M293 473 736 3 3 nfet_01v8 L=1.5e-07 W=7.6e-07 $X=7360 $Y=77310 $dt=15
M294 475 738 3 3 nfet_01v8 L=1.5e-07 W=7.6e-07 $X=7360 $Y=85590 $dt=15
M295 477 740 3 3 nfet_01v8 L=1.5e-07 W=7.6e-07 $X=7360 $Y=93870 $dt=15
M296 479 742 3 3 nfet_01v8 L=1.5e-07 W=7.6e-07 $X=7360 $Y=102150 $dt=15
M297 481 744 3 3 nfet_01v8 L=1.5e-07 W=7.6e-07 $X=7360 $Y=110430 $dt=15
M298 483 746 3 3 nfet_01v8 L=1.5e-07 W=7.6e-07 $X=7360 $Y=118710 $dt=15
M299 485 748 3 3 nfet_01v8 L=1.5e-07 W=7.6e-07 $X=7360 $Y=126990 $dt=15
M300 487 750 3 3 nfet_01v8 L=1.5e-07 W=7.6e-07 $X=7360 $Y=135270 $dt=15
M301 489 752 3 3 nfet_01v8 L=1.5e-07 W=7.6e-07 $X=7360 $Y=143550 $dt=15
M302 491 754 3 3 nfet_01v8 L=1.5e-07 W=7.6e-07 $X=7360 $Y=151830 $dt=15
M303 493 756 3 3 nfet_01v8 L=1.5e-07 W=7.6e-07 $X=7360 $Y=160110 $dt=15
M304 3 776 534 3 nfet_01v8 L=1.5e-07 W=7.6e-07 $X=7760 $Y=13010 $dt=15
M305 3 777 536 3 nfet_01v8 L=1.5e-07 W=7.6e-07 $X=7760 $Y=21290 $dt=15
M306 3 778 538 3 nfet_01v8 L=1.5e-07 W=7.6e-07 $X=7760 $Y=29570 $dt=15
M307 3 779 540 3 nfet_01v8 L=1.5e-07 W=7.6e-07 $X=7760 $Y=37850 $dt=15
M308 3 780 542 3 nfet_01v8 L=1.5e-07 W=7.6e-07 $X=7760 $Y=46130 $dt=15
M309 3 781 544 3 nfet_01v8 L=1.5e-07 W=7.6e-07 $X=7760 $Y=54410 $dt=15
M310 3 782 546 3 nfet_01v8 L=1.5e-07 W=7.6e-07 $X=7760 $Y=62690 $dt=15
M311 3 783 548 3 nfet_01v8 L=1.5e-07 W=7.6e-07 $X=7760 $Y=70970 $dt=15
M312 3 784 550 3 nfet_01v8 L=1.5e-07 W=7.6e-07 $X=7760 $Y=79250 $dt=15
M313 3 785 552 3 nfet_01v8 L=1.5e-07 W=7.6e-07 $X=7760 $Y=87530 $dt=15
M314 3 786 554 3 nfet_01v8 L=1.5e-07 W=7.6e-07 $X=7760 $Y=95810 $dt=15
M315 3 787 556 3 nfet_01v8 L=1.5e-07 W=7.6e-07 $X=7760 $Y=104090 $dt=15
M316 3 788 558 3 nfet_01v8 L=1.5e-07 W=7.6e-07 $X=7760 $Y=112370 $dt=15
M317 3 789 560 3 nfet_01v8 L=1.5e-07 W=7.6e-07 $X=7760 $Y=120650 $dt=15
M318 3 790 562 3 nfet_01v8 L=1.5e-07 W=7.6e-07 $X=7760 $Y=128930 $dt=15
M319 3 791 564 3 nfet_01v8 L=1.5e-07 W=7.6e-07 $X=7760 $Y=137210 $dt=15
M320 3 792 566 3 nfet_01v8 L=1.5e-07 W=7.6e-07 $X=7760 $Y=145490 $dt=15
M321 3 793 568 3 nfet_01v8 L=1.5e-07 W=7.6e-07 $X=7760 $Y=153770 $dt=15
M322 3 794 570 3 nfet_01v8 L=1.5e-07 W=7.6e-07 $X=7760 $Y=162050 $dt=15
M323 3 720 457 3 nfet_01v8 L=1.5e-07 W=7.6e-07 $X=7790 $Y=11070 $dt=15
M324 3 722 459 3 nfet_01v8 L=1.5e-07 W=7.6e-07 $X=7790 $Y=19350 $dt=15
M325 3 724 461 3 nfet_01v8 L=1.5e-07 W=7.6e-07 $X=7790 $Y=27630 $dt=15
M326 3 726 463 3 nfet_01v8 L=1.5e-07 W=7.6e-07 $X=7790 $Y=35910 $dt=15
M327 3 728 465 3 nfet_01v8 L=1.5e-07 W=7.6e-07 $X=7790 $Y=44190 $dt=15
M328 3 730 467 3 nfet_01v8 L=1.5e-07 W=7.6e-07 $X=7790 $Y=52470 $dt=15
M329 3 732 469 3 nfet_01v8 L=1.5e-07 W=7.6e-07 $X=7790 $Y=60750 $dt=15
M330 3 734 471 3 nfet_01v8 L=1.5e-07 W=7.6e-07 $X=7790 $Y=69030 $dt=15
M331 3 736 473 3 nfet_01v8 L=1.5e-07 W=7.6e-07 $X=7790 $Y=77310 $dt=15
M332 3 738 475 3 nfet_01v8 L=1.5e-07 W=7.6e-07 $X=7790 $Y=85590 $dt=15
M333 3 740 477 3 nfet_01v8 L=1.5e-07 W=7.6e-07 $X=7790 $Y=93870 $dt=15
M334 3 742 479 3 nfet_01v8 L=1.5e-07 W=7.6e-07 $X=7790 $Y=102150 $dt=15
M335 3 744 481 3 nfet_01v8 L=1.5e-07 W=7.6e-07 $X=7790 $Y=110430 $dt=15
M336 3 746 483 3 nfet_01v8 L=1.5e-07 W=7.6e-07 $X=7790 $Y=118710 $dt=15
M337 3 748 485 3 nfet_01v8 L=1.5e-07 W=7.6e-07 $X=7790 $Y=126990 $dt=15
M338 3 750 487 3 nfet_01v8 L=1.5e-07 W=7.6e-07 $X=7790 $Y=135270 $dt=15
M339 3 752 489 3 nfet_01v8 L=1.5e-07 W=7.6e-07 $X=7790 $Y=143550 $dt=15
M340 3 754 491 3 nfet_01v8 L=1.5e-07 W=7.6e-07 $X=7790 $Y=151830 $dt=15
M341 3 756 493 3 nfet_01v8 L=1.5e-07 W=7.6e-07 $X=7790 $Y=160110 $dt=15
M342 533 719 3 3 nfet_01v8 L=1.5e-07 W=7.6e-07 $X=8800 $Y=11070 $dt=15
M343 3 720 757 3 nfet_01v8 L=1.5e-07 W=7.6e-07 $X=8800 $Y=13010 $dt=15
M344 535 721 3 3 nfet_01v8 L=1.5e-07 W=7.6e-07 $X=8800 $Y=19350 $dt=15
M345 3 722 758 3 nfet_01v8 L=1.5e-07 W=7.6e-07 $X=8800 $Y=21290 $dt=15
M346 537 723 3 3 nfet_01v8 L=1.5e-07 W=7.6e-07 $X=8800 $Y=27630 $dt=15
M347 3 724 759 3 nfet_01v8 L=1.5e-07 W=7.6e-07 $X=8800 $Y=29570 $dt=15
M348 539 725 3 3 nfet_01v8 L=1.5e-07 W=7.6e-07 $X=8800 $Y=35910 $dt=15
M349 3 726 760 3 nfet_01v8 L=1.5e-07 W=7.6e-07 $X=8800 $Y=37850 $dt=15
M350 541 727 3 3 nfet_01v8 L=1.5e-07 W=7.6e-07 $X=8800 $Y=44190 $dt=15
M351 3 728 761 3 nfet_01v8 L=1.5e-07 W=7.6e-07 $X=8800 $Y=46130 $dt=15
M352 543 729 3 3 nfet_01v8 L=1.5e-07 W=7.6e-07 $X=8800 $Y=52470 $dt=15
M353 3 730 762 3 nfet_01v8 L=1.5e-07 W=7.6e-07 $X=8800 $Y=54410 $dt=15
M354 545 731 3 3 nfet_01v8 L=1.5e-07 W=7.6e-07 $X=8800 $Y=60750 $dt=15
M355 3 732 763 3 nfet_01v8 L=1.5e-07 W=7.6e-07 $X=8800 $Y=62690 $dt=15
M356 547 733 3 3 nfet_01v8 L=1.5e-07 W=7.6e-07 $X=8800 $Y=69030 $dt=15
M357 3 734 764 3 nfet_01v8 L=1.5e-07 W=7.6e-07 $X=8800 $Y=70970 $dt=15
M358 549 735 3 3 nfet_01v8 L=1.5e-07 W=7.6e-07 $X=8800 $Y=77310 $dt=15
M359 3 736 765 3 nfet_01v8 L=1.5e-07 W=7.6e-07 $X=8800 $Y=79250 $dt=15
M360 551 737 3 3 nfet_01v8 L=1.5e-07 W=7.6e-07 $X=8800 $Y=85590 $dt=15
M361 3 738 766 3 nfet_01v8 L=1.5e-07 W=7.6e-07 $X=8800 $Y=87530 $dt=15
M362 553 739 3 3 nfet_01v8 L=1.5e-07 W=7.6e-07 $X=8800 $Y=93870 $dt=15
M363 3 740 767 3 nfet_01v8 L=1.5e-07 W=7.6e-07 $X=8800 $Y=95810 $dt=15
M364 555 741 3 3 nfet_01v8 L=1.5e-07 W=7.6e-07 $X=8800 $Y=102150 $dt=15
M365 3 742 768 3 nfet_01v8 L=1.5e-07 W=7.6e-07 $X=8800 $Y=104090 $dt=15
M366 557 743 3 3 nfet_01v8 L=1.5e-07 W=7.6e-07 $X=8800 $Y=110430 $dt=15
M367 3 744 769 3 nfet_01v8 L=1.5e-07 W=7.6e-07 $X=8800 $Y=112370 $dt=15
M368 559 745 3 3 nfet_01v8 L=1.5e-07 W=7.6e-07 $X=8800 $Y=118710 $dt=15
M369 3 746 770 3 nfet_01v8 L=1.5e-07 W=7.6e-07 $X=8800 $Y=120650 $dt=15
M370 561 747 3 3 nfet_01v8 L=1.5e-07 W=7.6e-07 $X=8800 $Y=126990 $dt=15
M371 3 748 771 3 nfet_01v8 L=1.5e-07 W=7.6e-07 $X=8800 $Y=128930 $dt=15
M372 563 749 3 3 nfet_01v8 L=1.5e-07 W=7.6e-07 $X=8800 $Y=135270 $dt=15
M373 3 750 772 3 nfet_01v8 L=1.5e-07 W=7.6e-07 $X=8800 $Y=137210 $dt=15
M374 565 751 3 3 nfet_01v8 L=1.5e-07 W=7.6e-07 $X=8800 $Y=143550 $dt=15
M375 3 752 773 3 nfet_01v8 L=1.5e-07 W=7.6e-07 $X=8800 $Y=145490 $dt=15
M376 567 753 3 3 nfet_01v8 L=1.5e-07 W=7.6e-07 $X=8800 $Y=151830 $dt=15
M377 3 754 774 3 nfet_01v8 L=1.5e-07 W=7.6e-07 $X=8800 $Y=153770 $dt=15
M378 569 755 3 3 nfet_01v8 L=1.5e-07 W=7.6e-07 $X=8800 $Y=160110 $dt=15
M379 3 756 775 3 nfet_01v8 L=1.5e-07 W=7.6e-07 $X=8800 $Y=162050 $dt=15
M380 3 719 533 3 nfet_01v8 L=1.5e-07 W=7.6e-07 $X=9230 $Y=11070 $dt=15
M381 458 757 3 3 nfet_01v8 L=1.5e-07 W=7.6e-07 $X=9230 $Y=13010 $dt=15
M382 3 721 535 3 nfet_01v8 L=1.5e-07 W=7.6e-07 $X=9230 $Y=19350 $dt=15
M383 460 758 3 3 nfet_01v8 L=1.5e-07 W=7.6e-07 $X=9230 $Y=21290 $dt=15
M384 3 723 537 3 nfet_01v8 L=1.5e-07 W=7.6e-07 $X=9230 $Y=27630 $dt=15
M385 462 759 3 3 nfet_01v8 L=1.5e-07 W=7.6e-07 $X=9230 $Y=29570 $dt=15
M386 3 725 539 3 nfet_01v8 L=1.5e-07 W=7.6e-07 $X=9230 $Y=35910 $dt=15
M387 464 760 3 3 nfet_01v8 L=1.5e-07 W=7.6e-07 $X=9230 $Y=37850 $dt=15
M388 3 727 541 3 nfet_01v8 L=1.5e-07 W=7.6e-07 $X=9230 $Y=44190 $dt=15
M389 466 761 3 3 nfet_01v8 L=1.5e-07 W=7.6e-07 $X=9230 $Y=46130 $dt=15
M390 3 729 543 3 nfet_01v8 L=1.5e-07 W=7.6e-07 $X=9230 $Y=52470 $dt=15
M391 468 762 3 3 nfet_01v8 L=1.5e-07 W=7.6e-07 $X=9230 $Y=54410 $dt=15
M392 3 731 545 3 nfet_01v8 L=1.5e-07 W=7.6e-07 $X=9230 $Y=60750 $dt=15
M393 470 763 3 3 nfet_01v8 L=1.5e-07 W=7.6e-07 $X=9230 $Y=62690 $dt=15
M394 3 733 547 3 nfet_01v8 L=1.5e-07 W=7.6e-07 $X=9230 $Y=69030 $dt=15
M395 472 764 3 3 nfet_01v8 L=1.5e-07 W=7.6e-07 $X=9230 $Y=70970 $dt=15
M396 3 735 549 3 nfet_01v8 L=1.5e-07 W=7.6e-07 $X=9230 $Y=77310 $dt=15
M397 474 765 3 3 nfet_01v8 L=1.5e-07 W=7.6e-07 $X=9230 $Y=79250 $dt=15
M398 3 737 551 3 nfet_01v8 L=1.5e-07 W=7.6e-07 $X=9230 $Y=85590 $dt=15
M399 476 766 3 3 nfet_01v8 L=1.5e-07 W=7.6e-07 $X=9230 $Y=87530 $dt=15
M400 3 739 553 3 nfet_01v8 L=1.5e-07 W=7.6e-07 $X=9230 $Y=93870 $dt=15
M401 478 767 3 3 nfet_01v8 L=1.5e-07 W=7.6e-07 $X=9230 $Y=95810 $dt=15
M402 3 741 555 3 nfet_01v8 L=1.5e-07 W=7.6e-07 $X=9230 $Y=102150 $dt=15
M403 480 768 3 3 nfet_01v8 L=1.5e-07 W=7.6e-07 $X=9230 $Y=104090 $dt=15
M404 3 743 557 3 nfet_01v8 L=1.5e-07 W=7.6e-07 $X=9230 $Y=110430 $dt=15
M405 482 769 3 3 nfet_01v8 L=1.5e-07 W=7.6e-07 $X=9230 $Y=112370 $dt=15
M406 3 745 559 3 nfet_01v8 L=1.5e-07 W=7.6e-07 $X=9230 $Y=118710 $dt=15
M407 484 770 3 3 nfet_01v8 L=1.5e-07 W=7.6e-07 $X=9230 $Y=120650 $dt=15
M408 3 747 561 3 nfet_01v8 L=1.5e-07 W=7.6e-07 $X=9230 $Y=126990 $dt=15
M409 486 771 3 3 nfet_01v8 L=1.5e-07 W=7.6e-07 $X=9230 $Y=128930 $dt=15
M410 3 749 563 3 nfet_01v8 L=1.5e-07 W=7.6e-07 $X=9230 $Y=135270 $dt=15
M411 488 772 3 3 nfet_01v8 L=1.5e-07 W=7.6e-07 $X=9230 $Y=137210 $dt=15
M412 3 751 565 3 nfet_01v8 L=1.5e-07 W=7.6e-07 $X=9230 $Y=143550 $dt=15
M413 490 773 3 3 nfet_01v8 L=1.5e-07 W=7.6e-07 $X=9230 $Y=145490 $dt=15
M414 3 753 567 3 nfet_01v8 L=1.5e-07 W=7.6e-07 $X=9230 $Y=151830 $dt=15
M415 492 774 3 3 nfet_01v8 L=1.5e-07 W=7.6e-07 $X=9230 $Y=153770 $dt=15
M416 3 755 569 3 nfet_01v8 L=1.5e-07 W=7.6e-07 $X=9230 $Y=160110 $dt=15
M417 494 775 3 3 nfet_01v8 L=1.5e-07 W=7.6e-07 $X=9230 $Y=162050 $dt=15
M418 533 719 3 3 nfet_01v8 L=1.5e-07 W=7.6e-07 $X=9660 $Y=11070 $dt=15
M419 3 757 458 3 nfet_01v8 L=1.5e-07 W=7.6e-07 $X=9660 $Y=13010 $dt=15
M420 535 721 3 3 nfet_01v8 L=1.5e-07 W=7.6e-07 $X=9660 $Y=19350 $dt=15
M421 3 758 460 3 nfet_01v8 L=1.5e-07 W=7.6e-07 $X=9660 $Y=21290 $dt=15
M422 537 723 3 3 nfet_01v8 L=1.5e-07 W=7.6e-07 $X=9660 $Y=27630 $dt=15
M423 3 759 462 3 nfet_01v8 L=1.5e-07 W=7.6e-07 $X=9660 $Y=29570 $dt=15
M424 539 725 3 3 nfet_01v8 L=1.5e-07 W=7.6e-07 $X=9660 $Y=35910 $dt=15
M425 3 760 464 3 nfet_01v8 L=1.5e-07 W=7.6e-07 $X=9660 $Y=37850 $dt=15
M426 541 727 3 3 nfet_01v8 L=1.5e-07 W=7.6e-07 $X=9660 $Y=44190 $dt=15
M427 3 761 466 3 nfet_01v8 L=1.5e-07 W=7.6e-07 $X=9660 $Y=46130 $dt=15
M428 543 729 3 3 nfet_01v8 L=1.5e-07 W=7.6e-07 $X=9660 $Y=52470 $dt=15
M429 3 762 468 3 nfet_01v8 L=1.5e-07 W=7.6e-07 $X=9660 $Y=54410 $dt=15
M430 545 731 3 3 nfet_01v8 L=1.5e-07 W=7.6e-07 $X=9660 $Y=60750 $dt=15
M431 3 763 470 3 nfet_01v8 L=1.5e-07 W=7.6e-07 $X=9660 $Y=62690 $dt=15
M432 547 733 3 3 nfet_01v8 L=1.5e-07 W=7.6e-07 $X=9660 $Y=69030 $dt=15
M433 3 764 472 3 nfet_01v8 L=1.5e-07 W=7.6e-07 $X=9660 $Y=70970 $dt=15
M434 549 735 3 3 nfet_01v8 L=1.5e-07 W=7.6e-07 $X=9660 $Y=77310 $dt=15
M435 3 765 474 3 nfet_01v8 L=1.5e-07 W=7.6e-07 $X=9660 $Y=79250 $dt=15
M436 551 737 3 3 nfet_01v8 L=1.5e-07 W=7.6e-07 $X=9660 $Y=85590 $dt=15
M437 3 766 476 3 nfet_01v8 L=1.5e-07 W=7.6e-07 $X=9660 $Y=87530 $dt=15
M438 553 739 3 3 nfet_01v8 L=1.5e-07 W=7.6e-07 $X=9660 $Y=93870 $dt=15
M439 3 767 478 3 nfet_01v8 L=1.5e-07 W=7.6e-07 $X=9660 $Y=95810 $dt=15
M440 555 741 3 3 nfet_01v8 L=1.5e-07 W=7.6e-07 $X=9660 $Y=102150 $dt=15
M441 3 768 480 3 nfet_01v8 L=1.5e-07 W=7.6e-07 $X=9660 $Y=104090 $dt=15
M442 557 743 3 3 nfet_01v8 L=1.5e-07 W=7.6e-07 $X=9660 $Y=110430 $dt=15
M443 3 769 482 3 nfet_01v8 L=1.5e-07 W=7.6e-07 $X=9660 $Y=112370 $dt=15
M444 559 745 3 3 nfet_01v8 L=1.5e-07 W=7.6e-07 $X=9660 $Y=118710 $dt=15
M445 3 770 484 3 nfet_01v8 L=1.5e-07 W=7.6e-07 $X=9660 $Y=120650 $dt=15
M446 561 747 3 3 nfet_01v8 L=1.5e-07 W=7.6e-07 $X=9660 $Y=126990 $dt=15
M447 3 771 486 3 nfet_01v8 L=1.5e-07 W=7.6e-07 $X=9660 $Y=128930 $dt=15
M448 563 749 3 3 nfet_01v8 L=1.5e-07 W=7.6e-07 $X=9660 $Y=135270 $dt=15
M449 3 772 488 3 nfet_01v8 L=1.5e-07 W=7.6e-07 $X=9660 $Y=137210 $dt=15
M450 565 751 3 3 nfet_01v8 L=1.5e-07 W=7.6e-07 $X=9660 $Y=143550 $dt=15
M451 3 773 490 3 nfet_01v8 L=1.5e-07 W=7.6e-07 $X=9660 $Y=145490 $dt=15
M452 567 753 3 3 nfet_01v8 L=1.5e-07 W=7.6e-07 $X=9660 $Y=151830 $dt=15
M453 3 774 492 3 nfet_01v8 L=1.5e-07 W=7.6e-07 $X=9660 $Y=153770 $dt=15
M454 569 755 3 3 nfet_01v8 L=1.5e-07 W=7.6e-07 $X=9660 $Y=160110 $dt=15
M455 3 775 494 3 nfet_01v8 L=1.5e-07 W=7.6e-07 $X=9660 $Y=162050 $dt=15
M456 3 719 533 3 nfet_01v8 L=1.5e-07 W=7.6e-07 $X=10090 $Y=11070 $dt=15
M457 458 757 3 3 nfet_01v8 L=1.5e-07 W=7.6e-07 $X=10090 $Y=13010 $dt=15
M458 3 721 535 3 nfet_01v8 L=1.5e-07 W=7.6e-07 $X=10090 $Y=19350 $dt=15
M459 460 758 3 3 nfet_01v8 L=1.5e-07 W=7.6e-07 $X=10090 $Y=21290 $dt=15
M460 3 723 537 3 nfet_01v8 L=1.5e-07 W=7.6e-07 $X=10090 $Y=27630 $dt=15
M461 462 759 3 3 nfet_01v8 L=1.5e-07 W=7.6e-07 $X=10090 $Y=29570 $dt=15
M462 3 725 539 3 nfet_01v8 L=1.5e-07 W=7.6e-07 $X=10090 $Y=35910 $dt=15
M463 464 760 3 3 nfet_01v8 L=1.5e-07 W=7.6e-07 $X=10090 $Y=37850 $dt=15
M464 3 727 541 3 nfet_01v8 L=1.5e-07 W=7.6e-07 $X=10090 $Y=44190 $dt=15
M465 466 761 3 3 nfet_01v8 L=1.5e-07 W=7.6e-07 $X=10090 $Y=46130 $dt=15
M466 3 729 543 3 nfet_01v8 L=1.5e-07 W=7.6e-07 $X=10090 $Y=52470 $dt=15
M467 468 762 3 3 nfet_01v8 L=1.5e-07 W=7.6e-07 $X=10090 $Y=54410 $dt=15
M468 3 731 545 3 nfet_01v8 L=1.5e-07 W=7.6e-07 $X=10090 $Y=60750 $dt=15
M469 470 763 3 3 nfet_01v8 L=1.5e-07 W=7.6e-07 $X=10090 $Y=62690 $dt=15
M470 3 733 547 3 nfet_01v8 L=1.5e-07 W=7.6e-07 $X=10090 $Y=69030 $dt=15
M471 472 764 3 3 nfet_01v8 L=1.5e-07 W=7.6e-07 $X=10090 $Y=70970 $dt=15
M472 3 735 549 3 nfet_01v8 L=1.5e-07 W=7.6e-07 $X=10090 $Y=77310 $dt=15
M473 474 765 3 3 nfet_01v8 L=1.5e-07 W=7.6e-07 $X=10090 $Y=79250 $dt=15
M474 3 737 551 3 nfet_01v8 L=1.5e-07 W=7.6e-07 $X=10090 $Y=85590 $dt=15
M475 476 766 3 3 nfet_01v8 L=1.5e-07 W=7.6e-07 $X=10090 $Y=87530 $dt=15
M476 3 739 553 3 nfet_01v8 L=1.5e-07 W=7.6e-07 $X=10090 $Y=93870 $dt=15
M477 478 767 3 3 nfet_01v8 L=1.5e-07 W=7.6e-07 $X=10090 $Y=95810 $dt=15
M478 3 741 555 3 nfet_01v8 L=1.5e-07 W=7.6e-07 $X=10090 $Y=102150 $dt=15
M479 480 768 3 3 nfet_01v8 L=1.5e-07 W=7.6e-07 $X=10090 $Y=104090 $dt=15
M480 3 743 557 3 nfet_01v8 L=1.5e-07 W=7.6e-07 $X=10090 $Y=110430 $dt=15
M481 482 769 3 3 nfet_01v8 L=1.5e-07 W=7.6e-07 $X=10090 $Y=112370 $dt=15
M482 3 745 559 3 nfet_01v8 L=1.5e-07 W=7.6e-07 $X=10090 $Y=118710 $dt=15
M483 484 770 3 3 nfet_01v8 L=1.5e-07 W=7.6e-07 $X=10090 $Y=120650 $dt=15
M484 3 747 561 3 nfet_01v8 L=1.5e-07 W=7.6e-07 $X=10090 $Y=126990 $dt=15
M485 486 771 3 3 nfet_01v8 L=1.5e-07 W=7.6e-07 $X=10090 $Y=128930 $dt=15
M486 3 749 563 3 nfet_01v8 L=1.5e-07 W=7.6e-07 $X=10090 $Y=135270 $dt=15
M487 488 772 3 3 nfet_01v8 L=1.5e-07 W=7.6e-07 $X=10090 $Y=137210 $dt=15
M488 3 751 565 3 nfet_01v8 L=1.5e-07 W=7.6e-07 $X=10090 $Y=143550 $dt=15
M489 490 773 3 3 nfet_01v8 L=1.5e-07 W=7.6e-07 $X=10090 $Y=145490 $dt=15
M490 3 753 567 3 nfet_01v8 L=1.5e-07 W=7.6e-07 $X=10090 $Y=151830 $dt=15
M491 492 774 3 3 nfet_01v8 L=1.5e-07 W=7.6e-07 $X=10090 $Y=153770 $dt=15
M492 3 755 569 3 nfet_01v8 L=1.5e-07 W=7.6e-07 $X=10090 $Y=160110 $dt=15
M493 494 775 3 3 nfet_01v8 L=1.5e-07 W=7.6e-07 $X=10090 $Y=162050 $dt=15
M494 3 757 458 3 nfet_01v8 L=1.5e-07 W=7.6e-07 $X=10520 $Y=13010 $dt=15
M495 3 758 460 3 nfet_01v8 L=1.5e-07 W=7.6e-07 $X=10520 $Y=21290 $dt=15
M496 3 759 462 3 nfet_01v8 L=1.5e-07 W=7.6e-07 $X=10520 $Y=29570 $dt=15
M497 3 760 464 3 nfet_01v8 L=1.5e-07 W=7.6e-07 $X=10520 $Y=37850 $dt=15
M498 3 761 466 3 nfet_01v8 L=1.5e-07 W=7.6e-07 $X=10520 $Y=46130 $dt=15
M499 3 762 468 3 nfet_01v8 L=1.5e-07 W=7.6e-07 $X=10520 $Y=54410 $dt=15
M500 3 763 470 3 nfet_01v8 L=1.5e-07 W=7.6e-07 $X=10520 $Y=62690 $dt=15
M501 3 764 472 3 nfet_01v8 L=1.5e-07 W=7.6e-07 $X=10520 $Y=70970 $dt=15
M502 3 765 474 3 nfet_01v8 L=1.5e-07 W=7.6e-07 $X=10520 $Y=79250 $dt=15
M503 3 766 476 3 nfet_01v8 L=1.5e-07 W=7.6e-07 $X=10520 $Y=87530 $dt=15
M504 3 767 478 3 nfet_01v8 L=1.5e-07 W=7.6e-07 $X=10520 $Y=95810 $dt=15
M505 3 768 480 3 nfet_01v8 L=1.5e-07 W=7.6e-07 $X=10520 $Y=104090 $dt=15
M506 3 769 482 3 nfet_01v8 L=1.5e-07 W=7.6e-07 $X=10520 $Y=112370 $dt=15
M507 3 770 484 3 nfet_01v8 L=1.5e-07 W=7.6e-07 $X=10520 $Y=120650 $dt=15
M508 3 771 486 3 nfet_01v8 L=1.5e-07 W=7.6e-07 $X=10520 $Y=128930 $dt=15
M509 3 772 488 3 nfet_01v8 L=1.5e-07 W=7.6e-07 $X=10520 $Y=137210 $dt=15
M510 3 773 490 3 nfet_01v8 L=1.5e-07 W=7.6e-07 $X=10520 $Y=145490 $dt=15
M511 3 774 492 3 nfet_01v8 L=1.5e-07 W=7.6e-07 $X=10520 $Y=153770 $dt=15
M512 3 775 494 3 nfet_01v8 L=1.5e-07 W=7.6e-07 $X=10520 $Y=162050 $dt=15
M513 700 681 3 3 nfet_01v8 L=1.5e-07 W=7.6e-07 $X=11560 $Y=13010 $dt=15
M514 701 682 3 3 nfet_01v8 L=1.5e-07 W=7.6e-07 $X=11560 $Y=21290 $dt=15
M515 702 683 3 3 nfet_01v8 L=1.5e-07 W=7.6e-07 $X=11560 $Y=29570 $dt=15
M516 703 684 3 3 nfet_01v8 L=1.5e-07 W=7.6e-07 $X=11560 $Y=37850 $dt=15
M517 704 685 3 3 nfet_01v8 L=1.5e-07 W=7.6e-07 $X=11560 $Y=46130 $dt=15
M518 705 686 3 3 nfet_01v8 L=1.5e-07 W=7.6e-07 $X=11560 $Y=54410 $dt=15
M519 706 687 3 3 nfet_01v8 L=1.5e-07 W=7.6e-07 $X=11560 $Y=62690 $dt=15
M520 707 688 3 3 nfet_01v8 L=1.5e-07 W=7.6e-07 $X=11560 $Y=70970 $dt=15
M521 708 689 3 3 nfet_01v8 L=1.5e-07 W=7.6e-07 $X=11560 $Y=79250 $dt=15
M522 709 690 3 3 nfet_01v8 L=1.5e-07 W=7.6e-07 $X=11560 $Y=87530 $dt=15
M523 710 691 3 3 nfet_01v8 L=1.5e-07 W=7.6e-07 $X=11560 $Y=95810 $dt=15
M524 711 692 3 3 nfet_01v8 L=1.5e-07 W=7.6e-07 $X=11560 $Y=104090 $dt=15
M525 712 693 3 3 nfet_01v8 L=1.5e-07 W=7.6e-07 $X=11560 $Y=112370 $dt=15
M526 713 694 3 3 nfet_01v8 L=1.5e-07 W=7.6e-07 $X=11560 $Y=120650 $dt=15
M527 714 695 3 3 nfet_01v8 L=1.5e-07 W=7.6e-07 $X=11560 $Y=128930 $dt=15
M528 715 696 3 3 nfet_01v8 L=1.5e-07 W=7.6e-07 $X=11560 $Y=137210 $dt=15
M529 716 697 3 3 nfet_01v8 L=1.5e-07 W=7.6e-07 $X=11560 $Y=145490 $dt=15
M530 717 698 3 3 nfet_01v8 L=1.5e-07 W=7.6e-07 $X=11560 $Y=153770 $dt=15
M531 718 699 3 3 nfet_01v8 L=1.5e-07 W=7.6e-07 $X=11560 $Y=162050 $dt=15
M532 3 681 700 3 nfet_01v8 L=1.5e-07 W=7.6e-07 $X=11990 $Y=13010 $dt=15
M533 3 682 701 3 nfet_01v8 L=1.5e-07 W=7.6e-07 $X=11990 $Y=21290 $dt=15
M534 3 683 702 3 nfet_01v8 L=1.5e-07 W=7.6e-07 $X=11990 $Y=29570 $dt=15
M535 3 684 703 3 nfet_01v8 L=1.5e-07 W=7.6e-07 $X=11990 $Y=37850 $dt=15
M536 3 685 704 3 nfet_01v8 L=1.5e-07 W=7.6e-07 $X=11990 $Y=46130 $dt=15
M537 3 686 705 3 nfet_01v8 L=1.5e-07 W=7.6e-07 $X=11990 $Y=54410 $dt=15
M538 3 687 706 3 nfet_01v8 L=1.5e-07 W=7.6e-07 $X=11990 $Y=62690 $dt=15
M539 3 688 707 3 nfet_01v8 L=1.5e-07 W=7.6e-07 $X=11990 $Y=70970 $dt=15
M540 3 689 708 3 nfet_01v8 L=1.5e-07 W=7.6e-07 $X=11990 $Y=79250 $dt=15
M541 3 690 709 3 nfet_01v8 L=1.5e-07 W=7.6e-07 $X=11990 $Y=87530 $dt=15
M542 3 691 710 3 nfet_01v8 L=1.5e-07 W=7.6e-07 $X=11990 $Y=95810 $dt=15
M543 3 692 711 3 nfet_01v8 L=1.5e-07 W=7.6e-07 $X=11990 $Y=104090 $dt=15
M544 3 693 712 3 nfet_01v8 L=1.5e-07 W=7.6e-07 $X=11990 $Y=112370 $dt=15
M545 3 694 713 3 nfet_01v8 L=1.5e-07 W=7.6e-07 $X=11990 $Y=120650 $dt=15
M546 3 695 714 3 nfet_01v8 L=1.5e-07 W=7.6e-07 $X=11990 $Y=128930 $dt=15
M547 3 696 715 3 nfet_01v8 L=1.5e-07 W=7.6e-07 $X=11990 $Y=137210 $dt=15
M548 3 697 716 3 nfet_01v8 L=1.5e-07 W=7.6e-07 $X=11990 $Y=145490 $dt=15
M549 3 698 717 3 nfet_01v8 L=1.5e-07 W=7.6e-07 $X=11990 $Y=153770 $dt=15
M550 3 699 718 3 nfet_01v8 L=1.5e-07 W=7.6e-07 $X=11990 $Y=162050 $dt=15
M551 495 700 3 3 nfet_01v8 L=1.5e-07 W=7.6e-07 $X=12420 $Y=13010 $dt=15
M552 496 701 3 3 nfet_01v8 L=1.5e-07 W=7.6e-07 $X=12420 $Y=21290 $dt=15
M553 497 702 3 3 nfet_01v8 L=1.5e-07 W=7.6e-07 $X=12420 $Y=29570 $dt=15
M554 498 703 3 3 nfet_01v8 L=1.5e-07 W=7.6e-07 $X=12420 $Y=37850 $dt=15
M555 499 704 3 3 nfet_01v8 L=1.5e-07 W=7.6e-07 $X=12420 $Y=46130 $dt=15
M556 500 705 3 3 nfet_01v8 L=1.5e-07 W=7.6e-07 $X=12420 $Y=54410 $dt=15
M557 501 706 3 3 nfet_01v8 L=1.5e-07 W=7.6e-07 $X=12420 $Y=62690 $dt=15
M558 502 707 3 3 nfet_01v8 L=1.5e-07 W=7.6e-07 $X=12420 $Y=70970 $dt=15
M559 503 708 3 3 nfet_01v8 L=1.5e-07 W=7.6e-07 $X=12420 $Y=79250 $dt=15
M560 504 709 3 3 nfet_01v8 L=1.5e-07 W=7.6e-07 $X=12420 $Y=87530 $dt=15
M561 505 710 3 3 nfet_01v8 L=1.5e-07 W=7.6e-07 $X=12420 $Y=95810 $dt=15
M562 506 711 3 3 nfet_01v8 L=1.5e-07 W=7.6e-07 $X=12420 $Y=104090 $dt=15
M563 507 712 3 3 nfet_01v8 L=1.5e-07 W=7.6e-07 $X=12420 $Y=112370 $dt=15
M564 508 713 3 3 nfet_01v8 L=1.5e-07 W=7.6e-07 $X=12420 $Y=120650 $dt=15
M565 509 714 3 3 nfet_01v8 L=1.5e-07 W=7.6e-07 $X=12420 $Y=128930 $dt=15
M566 510 715 3 3 nfet_01v8 L=1.5e-07 W=7.6e-07 $X=12420 $Y=137210 $dt=15
M567 511 716 3 3 nfet_01v8 L=1.5e-07 W=7.6e-07 $X=12420 $Y=145490 $dt=15
M568 512 717 3 3 nfet_01v8 L=1.5e-07 W=7.6e-07 $X=12420 $Y=153770 $dt=15
M569 513 718 3 3 nfet_01v8 L=1.5e-07 W=7.6e-07 $X=12420 $Y=162050 $dt=15
M570 514 681 3 3 nfet_01v8 L=1.5e-07 W=7.6e-07 $X=12480 $Y=11070 $dt=15
M571 515 682 3 3 nfet_01v8 L=1.5e-07 W=7.6e-07 $X=12480 $Y=19350 $dt=15
M572 516 683 3 3 nfet_01v8 L=1.5e-07 W=7.6e-07 $X=12480 $Y=27630 $dt=15
M573 517 684 3 3 nfet_01v8 L=1.5e-07 W=7.6e-07 $X=12480 $Y=35910 $dt=15
M574 518 685 3 3 nfet_01v8 L=1.5e-07 W=7.6e-07 $X=12480 $Y=44190 $dt=15
M575 519 686 3 3 nfet_01v8 L=1.5e-07 W=7.6e-07 $X=12480 $Y=52470 $dt=15
M576 520 687 3 3 nfet_01v8 L=1.5e-07 W=7.6e-07 $X=12480 $Y=60750 $dt=15
M577 521 688 3 3 nfet_01v8 L=1.5e-07 W=7.6e-07 $X=12480 $Y=69030 $dt=15
M578 522 689 3 3 nfet_01v8 L=1.5e-07 W=7.6e-07 $X=12480 $Y=77310 $dt=15
M579 523 690 3 3 nfet_01v8 L=1.5e-07 W=7.6e-07 $X=12480 $Y=85590 $dt=15
M580 524 691 3 3 nfet_01v8 L=1.5e-07 W=7.6e-07 $X=12480 $Y=93870 $dt=15
M581 525 692 3 3 nfet_01v8 L=1.5e-07 W=7.6e-07 $X=12480 $Y=102150 $dt=15
M582 526 693 3 3 nfet_01v8 L=1.5e-07 W=7.6e-07 $X=12480 $Y=110430 $dt=15
M583 527 694 3 3 nfet_01v8 L=1.5e-07 W=7.6e-07 $X=12480 $Y=118710 $dt=15
M584 528 695 3 3 nfet_01v8 L=1.5e-07 W=7.6e-07 $X=12480 $Y=126990 $dt=15
M585 529 696 3 3 nfet_01v8 L=1.5e-07 W=7.6e-07 $X=12480 $Y=135270 $dt=15
M586 530 697 3 3 nfet_01v8 L=1.5e-07 W=7.6e-07 $X=12480 $Y=143550 $dt=15
M587 531 698 3 3 nfet_01v8 L=1.5e-07 W=7.6e-07 $X=12480 $Y=151830 $dt=15
M588 532 699 3 3 nfet_01v8 L=1.5e-07 W=7.6e-07 $X=12480 $Y=160110 $dt=15
M589 3 700 495 3 nfet_01v8 L=1.5e-07 W=7.6e-07 $X=12850 $Y=13010 $dt=15
M590 3 701 496 3 nfet_01v8 L=1.5e-07 W=7.6e-07 $X=12850 $Y=21290 $dt=15
M591 3 702 497 3 nfet_01v8 L=1.5e-07 W=7.6e-07 $X=12850 $Y=29570 $dt=15
M592 3 703 498 3 nfet_01v8 L=1.5e-07 W=7.6e-07 $X=12850 $Y=37850 $dt=15
M593 3 704 499 3 nfet_01v8 L=1.5e-07 W=7.6e-07 $X=12850 $Y=46130 $dt=15
M594 3 705 500 3 nfet_01v8 L=1.5e-07 W=7.6e-07 $X=12850 $Y=54410 $dt=15
M595 3 706 501 3 nfet_01v8 L=1.5e-07 W=7.6e-07 $X=12850 $Y=62690 $dt=15
M596 3 707 502 3 nfet_01v8 L=1.5e-07 W=7.6e-07 $X=12850 $Y=70970 $dt=15
M597 3 708 503 3 nfet_01v8 L=1.5e-07 W=7.6e-07 $X=12850 $Y=79250 $dt=15
M598 3 709 504 3 nfet_01v8 L=1.5e-07 W=7.6e-07 $X=12850 $Y=87530 $dt=15
M599 3 710 505 3 nfet_01v8 L=1.5e-07 W=7.6e-07 $X=12850 $Y=95810 $dt=15
M600 3 711 506 3 nfet_01v8 L=1.5e-07 W=7.6e-07 $X=12850 $Y=104090 $dt=15
M601 3 712 507 3 nfet_01v8 L=1.5e-07 W=7.6e-07 $X=12850 $Y=112370 $dt=15
M602 3 713 508 3 nfet_01v8 L=1.5e-07 W=7.6e-07 $X=12850 $Y=120650 $dt=15
M603 3 714 509 3 nfet_01v8 L=1.5e-07 W=7.6e-07 $X=12850 $Y=128930 $dt=15
M604 3 715 510 3 nfet_01v8 L=1.5e-07 W=7.6e-07 $X=12850 $Y=137210 $dt=15
M605 3 716 511 3 nfet_01v8 L=1.5e-07 W=7.6e-07 $X=12850 $Y=145490 $dt=15
M606 3 717 512 3 nfet_01v8 L=1.5e-07 W=7.6e-07 $X=12850 $Y=153770 $dt=15
M607 3 718 513 3 nfet_01v8 L=1.5e-07 W=7.6e-07 $X=12850 $Y=162050 $dt=15
M608 3 681 514 3 nfet_01v8 L=1.5e-07 W=7.6e-07 $X=12910 $Y=11070 $dt=15
M609 3 682 515 3 nfet_01v8 L=1.5e-07 W=7.6e-07 $X=12910 $Y=19350 $dt=15
M610 3 683 516 3 nfet_01v8 L=1.5e-07 W=7.6e-07 $X=12910 $Y=27630 $dt=15
M611 3 684 517 3 nfet_01v8 L=1.5e-07 W=7.6e-07 $X=12910 $Y=35910 $dt=15
M612 3 685 518 3 nfet_01v8 L=1.5e-07 W=7.6e-07 $X=12910 $Y=44190 $dt=15
M613 3 686 519 3 nfet_01v8 L=1.5e-07 W=7.6e-07 $X=12910 $Y=52470 $dt=15
M614 3 687 520 3 nfet_01v8 L=1.5e-07 W=7.6e-07 $X=12910 $Y=60750 $dt=15
M615 3 688 521 3 nfet_01v8 L=1.5e-07 W=7.6e-07 $X=12910 $Y=69030 $dt=15
M616 3 689 522 3 nfet_01v8 L=1.5e-07 W=7.6e-07 $X=12910 $Y=77310 $dt=15
M617 3 690 523 3 nfet_01v8 L=1.5e-07 W=7.6e-07 $X=12910 $Y=85590 $dt=15
M618 3 691 524 3 nfet_01v8 L=1.5e-07 W=7.6e-07 $X=12910 $Y=93870 $dt=15
M619 3 692 525 3 nfet_01v8 L=1.5e-07 W=7.6e-07 $X=12910 $Y=102150 $dt=15
M620 3 693 526 3 nfet_01v8 L=1.5e-07 W=7.6e-07 $X=12910 $Y=110430 $dt=15
M621 3 694 527 3 nfet_01v8 L=1.5e-07 W=7.6e-07 $X=12910 $Y=118710 $dt=15
M622 3 695 528 3 nfet_01v8 L=1.5e-07 W=7.6e-07 $X=12910 $Y=126990 $dt=15
M623 3 696 529 3 nfet_01v8 L=1.5e-07 W=7.6e-07 $X=12910 $Y=135270 $dt=15
M624 3 697 530 3 nfet_01v8 L=1.5e-07 W=7.6e-07 $X=12910 $Y=143550 $dt=15
M625 3 698 531 3 nfet_01v8 L=1.5e-07 W=7.6e-07 $X=12910 $Y=151830 $dt=15
M626 3 699 532 3 nfet_01v8 L=1.5e-07 W=7.6e-07 $X=12910 $Y=160110 $dt=15
M627 495 700 3 3 nfet_01v8 L=1.5e-07 W=7.6e-07 $X=13280 $Y=13010 $dt=15
M628 496 701 3 3 nfet_01v8 L=1.5e-07 W=7.6e-07 $X=13280 $Y=21290 $dt=15
M629 497 702 3 3 nfet_01v8 L=1.5e-07 W=7.6e-07 $X=13280 $Y=29570 $dt=15
M630 498 703 3 3 nfet_01v8 L=1.5e-07 W=7.6e-07 $X=13280 $Y=37850 $dt=15
M631 499 704 3 3 nfet_01v8 L=1.5e-07 W=7.6e-07 $X=13280 $Y=46130 $dt=15
M632 500 705 3 3 nfet_01v8 L=1.5e-07 W=7.6e-07 $X=13280 $Y=54410 $dt=15
M633 501 706 3 3 nfet_01v8 L=1.5e-07 W=7.6e-07 $X=13280 $Y=62690 $dt=15
M634 502 707 3 3 nfet_01v8 L=1.5e-07 W=7.6e-07 $X=13280 $Y=70970 $dt=15
M635 503 708 3 3 nfet_01v8 L=1.5e-07 W=7.6e-07 $X=13280 $Y=79250 $dt=15
M636 504 709 3 3 nfet_01v8 L=1.5e-07 W=7.6e-07 $X=13280 $Y=87530 $dt=15
M637 505 710 3 3 nfet_01v8 L=1.5e-07 W=7.6e-07 $X=13280 $Y=95810 $dt=15
M638 506 711 3 3 nfet_01v8 L=1.5e-07 W=7.6e-07 $X=13280 $Y=104090 $dt=15
M639 507 712 3 3 nfet_01v8 L=1.5e-07 W=7.6e-07 $X=13280 $Y=112370 $dt=15
M640 508 713 3 3 nfet_01v8 L=1.5e-07 W=7.6e-07 $X=13280 $Y=120650 $dt=15
M641 509 714 3 3 nfet_01v8 L=1.5e-07 W=7.6e-07 $X=13280 $Y=128930 $dt=15
M642 510 715 3 3 nfet_01v8 L=1.5e-07 W=7.6e-07 $X=13280 $Y=137210 $dt=15
M643 511 716 3 3 nfet_01v8 L=1.5e-07 W=7.6e-07 $X=13280 $Y=145490 $dt=15
M644 512 717 3 3 nfet_01v8 L=1.5e-07 W=7.6e-07 $X=13280 $Y=153770 $dt=15
M645 513 718 3 3 nfet_01v8 L=1.5e-07 W=7.6e-07 $X=13280 $Y=162050 $dt=15
M646 514 681 3 3 nfet_01v8 L=1.5e-07 W=7.6e-07 $X=13340 $Y=11070 $dt=15
M647 515 682 3 3 nfet_01v8 L=1.5e-07 W=7.6e-07 $X=13340 $Y=19350 $dt=15
M648 516 683 3 3 nfet_01v8 L=1.5e-07 W=7.6e-07 $X=13340 $Y=27630 $dt=15
M649 517 684 3 3 nfet_01v8 L=1.5e-07 W=7.6e-07 $X=13340 $Y=35910 $dt=15
M650 518 685 3 3 nfet_01v8 L=1.5e-07 W=7.6e-07 $X=13340 $Y=44190 $dt=15
M651 519 686 3 3 nfet_01v8 L=1.5e-07 W=7.6e-07 $X=13340 $Y=52470 $dt=15
M652 520 687 3 3 nfet_01v8 L=1.5e-07 W=7.6e-07 $X=13340 $Y=60750 $dt=15
M653 521 688 3 3 nfet_01v8 L=1.5e-07 W=7.6e-07 $X=13340 $Y=69030 $dt=15
M654 522 689 3 3 nfet_01v8 L=1.5e-07 W=7.6e-07 $X=13340 $Y=77310 $dt=15
M655 523 690 3 3 nfet_01v8 L=1.5e-07 W=7.6e-07 $X=13340 $Y=85590 $dt=15
M656 524 691 3 3 nfet_01v8 L=1.5e-07 W=7.6e-07 $X=13340 $Y=93870 $dt=15
M657 525 692 3 3 nfet_01v8 L=1.5e-07 W=7.6e-07 $X=13340 $Y=102150 $dt=15
M658 526 693 3 3 nfet_01v8 L=1.5e-07 W=7.6e-07 $X=13340 $Y=110430 $dt=15
M659 527 694 3 3 nfet_01v8 L=1.5e-07 W=7.6e-07 $X=13340 $Y=118710 $dt=15
M660 528 695 3 3 nfet_01v8 L=1.5e-07 W=7.6e-07 $X=13340 $Y=126990 $dt=15
M661 529 696 3 3 nfet_01v8 L=1.5e-07 W=7.6e-07 $X=13340 $Y=135270 $dt=15
M662 530 697 3 3 nfet_01v8 L=1.5e-07 W=7.6e-07 $X=13340 $Y=143550 $dt=15
M663 531 698 3 3 nfet_01v8 L=1.5e-07 W=7.6e-07 $X=13340 $Y=151830 $dt=15
M664 532 699 3 3 nfet_01v8 L=1.5e-07 W=7.6e-07 $X=13340 $Y=160110 $dt=15
M665 3 700 495 3 nfet_01v8 L=1.5e-07 W=7.6e-07 $X=13710 $Y=13010 $dt=15
M666 3 701 496 3 nfet_01v8 L=1.5e-07 W=7.6e-07 $X=13710 $Y=21290 $dt=15
M667 3 702 497 3 nfet_01v8 L=1.5e-07 W=7.6e-07 $X=13710 $Y=29570 $dt=15
M668 3 703 498 3 nfet_01v8 L=1.5e-07 W=7.6e-07 $X=13710 $Y=37850 $dt=15
M669 3 704 499 3 nfet_01v8 L=1.5e-07 W=7.6e-07 $X=13710 $Y=46130 $dt=15
M670 3 705 500 3 nfet_01v8 L=1.5e-07 W=7.6e-07 $X=13710 $Y=54410 $dt=15
M671 3 706 501 3 nfet_01v8 L=1.5e-07 W=7.6e-07 $X=13710 $Y=62690 $dt=15
M672 3 707 502 3 nfet_01v8 L=1.5e-07 W=7.6e-07 $X=13710 $Y=70970 $dt=15
M673 3 708 503 3 nfet_01v8 L=1.5e-07 W=7.6e-07 $X=13710 $Y=79250 $dt=15
M674 3 709 504 3 nfet_01v8 L=1.5e-07 W=7.6e-07 $X=13710 $Y=87530 $dt=15
M675 3 710 505 3 nfet_01v8 L=1.5e-07 W=7.6e-07 $X=13710 $Y=95810 $dt=15
M676 3 711 506 3 nfet_01v8 L=1.5e-07 W=7.6e-07 $X=13710 $Y=104090 $dt=15
M677 3 712 507 3 nfet_01v8 L=1.5e-07 W=7.6e-07 $X=13710 $Y=112370 $dt=15
M678 3 713 508 3 nfet_01v8 L=1.5e-07 W=7.6e-07 $X=13710 $Y=120650 $dt=15
M679 3 714 509 3 nfet_01v8 L=1.5e-07 W=7.6e-07 $X=13710 $Y=128930 $dt=15
M680 3 715 510 3 nfet_01v8 L=1.5e-07 W=7.6e-07 $X=13710 $Y=137210 $dt=15
M681 3 716 511 3 nfet_01v8 L=1.5e-07 W=7.6e-07 $X=13710 $Y=145490 $dt=15
M682 3 717 512 3 nfet_01v8 L=1.5e-07 W=7.6e-07 $X=13710 $Y=153770 $dt=15
M683 3 718 513 3 nfet_01v8 L=1.5e-07 W=7.6e-07 $X=13710 $Y=162050 $dt=15
M684 3 681 514 3 nfet_01v8 L=1.5e-07 W=7.6e-07 $X=13770 $Y=11070 $dt=15
M685 3 682 515 3 nfet_01v8 L=1.5e-07 W=7.6e-07 $X=13770 $Y=19350 $dt=15
M686 3 683 516 3 nfet_01v8 L=1.5e-07 W=7.6e-07 $X=13770 $Y=27630 $dt=15
M687 3 684 517 3 nfet_01v8 L=1.5e-07 W=7.6e-07 $X=13770 $Y=35910 $dt=15
M688 3 685 518 3 nfet_01v8 L=1.5e-07 W=7.6e-07 $X=13770 $Y=44190 $dt=15
M689 3 686 519 3 nfet_01v8 L=1.5e-07 W=7.6e-07 $X=13770 $Y=52470 $dt=15
M690 3 687 520 3 nfet_01v8 L=1.5e-07 W=7.6e-07 $X=13770 $Y=60750 $dt=15
M691 3 688 521 3 nfet_01v8 L=1.5e-07 W=7.6e-07 $X=13770 $Y=69030 $dt=15
M692 3 689 522 3 nfet_01v8 L=1.5e-07 W=7.6e-07 $X=13770 $Y=77310 $dt=15
M693 3 690 523 3 nfet_01v8 L=1.5e-07 W=7.6e-07 $X=13770 $Y=85590 $dt=15
M694 3 691 524 3 nfet_01v8 L=1.5e-07 W=7.6e-07 $X=13770 $Y=93870 $dt=15
M695 3 692 525 3 nfet_01v8 L=1.5e-07 W=7.6e-07 $X=13770 $Y=102150 $dt=15
M696 3 693 526 3 nfet_01v8 L=1.5e-07 W=7.6e-07 $X=13770 $Y=110430 $dt=15
M697 3 694 527 3 nfet_01v8 L=1.5e-07 W=7.6e-07 $X=13770 $Y=118710 $dt=15
M698 3 695 528 3 nfet_01v8 L=1.5e-07 W=7.6e-07 $X=13770 $Y=126990 $dt=15
M699 3 696 529 3 nfet_01v8 L=1.5e-07 W=7.6e-07 $X=13770 $Y=135270 $dt=15
M700 3 697 530 3 nfet_01v8 L=1.5e-07 W=7.6e-07 $X=13770 $Y=143550 $dt=15
M701 3 698 531 3 nfet_01v8 L=1.5e-07 W=7.6e-07 $X=13770 $Y=151830 $dt=15
M702 3 699 532 3 nfet_01v8 L=1.5e-07 W=7.6e-07 $X=13770 $Y=160110 $dt=15
M703 495 700 3 3 nfet_01v8 L=1.5e-07 W=7.6e-07 $X=14140 $Y=13010 $dt=15
M704 496 701 3 3 nfet_01v8 L=1.5e-07 W=7.6e-07 $X=14140 $Y=21290 $dt=15
M705 497 702 3 3 nfet_01v8 L=1.5e-07 W=7.6e-07 $X=14140 $Y=29570 $dt=15
M706 498 703 3 3 nfet_01v8 L=1.5e-07 W=7.6e-07 $X=14140 $Y=37850 $dt=15
M707 499 704 3 3 nfet_01v8 L=1.5e-07 W=7.6e-07 $X=14140 $Y=46130 $dt=15
M708 500 705 3 3 nfet_01v8 L=1.5e-07 W=7.6e-07 $X=14140 $Y=54410 $dt=15
M709 501 706 3 3 nfet_01v8 L=1.5e-07 W=7.6e-07 $X=14140 $Y=62690 $dt=15
M710 502 707 3 3 nfet_01v8 L=1.5e-07 W=7.6e-07 $X=14140 $Y=70970 $dt=15
M711 503 708 3 3 nfet_01v8 L=1.5e-07 W=7.6e-07 $X=14140 $Y=79250 $dt=15
M712 504 709 3 3 nfet_01v8 L=1.5e-07 W=7.6e-07 $X=14140 $Y=87530 $dt=15
M713 505 710 3 3 nfet_01v8 L=1.5e-07 W=7.6e-07 $X=14140 $Y=95810 $dt=15
M714 506 711 3 3 nfet_01v8 L=1.5e-07 W=7.6e-07 $X=14140 $Y=104090 $dt=15
M715 507 712 3 3 nfet_01v8 L=1.5e-07 W=7.6e-07 $X=14140 $Y=112370 $dt=15
M716 508 713 3 3 nfet_01v8 L=1.5e-07 W=7.6e-07 $X=14140 $Y=120650 $dt=15
M717 509 714 3 3 nfet_01v8 L=1.5e-07 W=7.6e-07 $X=14140 $Y=128930 $dt=15
M718 510 715 3 3 nfet_01v8 L=1.5e-07 W=7.6e-07 $X=14140 $Y=137210 $dt=15
M719 511 716 3 3 nfet_01v8 L=1.5e-07 W=7.6e-07 $X=14140 $Y=145490 $dt=15
M720 512 717 3 3 nfet_01v8 L=1.5e-07 W=7.6e-07 $X=14140 $Y=153770 $dt=15
M721 513 718 3 3 nfet_01v8 L=1.5e-07 W=7.6e-07 $X=14140 $Y=162050 $dt=15
M722 514 681 3 3 nfet_01v8 L=1.5e-07 W=7.6e-07 $X=14200 $Y=11070 $dt=15
M723 515 682 3 3 nfet_01v8 L=1.5e-07 W=7.6e-07 $X=14200 $Y=19350 $dt=15
M724 516 683 3 3 nfet_01v8 L=1.5e-07 W=7.6e-07 $X=14200 $Y=27630 $dt=15
M725 517 684 3 3 nfet_01v8 L=1.5e-07 W=7.6e-07 $X=14200 $Y=35910 $dt=15
M726 518 685 3 3 nfet_01v8 L=1.5e-07 W=7.6e-07 $X=14200 $Y=44190 $dt=15
M727 519 686 3 3 nfet_01v8 L=1.5e-07 W=7.6e-07 $X=14200 $Y=52470 $dt=15
M728 520 687 3 3 nfet_01v8 L=1.5e-07 W=7.6e-07 $X=14200 $Y=60750 $dt=15
M729 521 688 3 3 nfet_01v8 L=1.5e-07 W=7.6e-07 $X=14200 $Y=69030 $dt=15
M730 522 689 3 3 nfet_01v8 L=1.5e-07 W=7.6e-07 $X=14200 $Y=77310 $dt=15
M731 523 690 3 3 nfet_01v8 L=1.5e-07 W=7.6e-07 $X=14200 $Y=85590 $dt=15
M732 524 691 3 3 nfet_01v8 L=1.5e-07 W=7.6e-07 $X=14200 $Y=93870 $dt=15
M733 525 692 3 3 nfet_01v8 L=1.5e-07 W=7.6e-07 $X=14200 $Y=102150 $dt=15
M734 526 693 3 3 nfet_01v8 L=1.5e-07 W=7.6e-07 $X=14200 $Y=110430 $dt=15
M735 527 694 3 3 nfet_01v8 L=1.5e-07 W=7.6e-07 $X=14200 $Y=118710 $dt=15
M736 528 695 3 3 nfet_01v8 L=1.5e-07 W=7.6e-07 $X=14200 $Y=126990 $dt=15
M737 529 696 3 3 nfet_01v8 L=1.5e-07 W=7.6e-07 $X=14200 $Y=135270 $dt=15
M738 530 697 3 3 nfet_01v8 L=1.5e-07 W=7.6e-07 $X=14200 $Y=143550 $dt=15
M739 531 698 3 3 nfet_01v8 L=1.5e-07 W=7.6e-07 $X=14200 $Y=151830 $dt=15
M740 532 699 3 3 nfet_01v8 L=1.5e-07 W=7.6e-07 $X=14200 $Y=160110 $dt=15
M741 3 700 495 3 nfet_01v8 L=1.5e-07 W=7.6e-07 $X=14570 $Y=13010 $dt=15
M742 3 701 496 3 nfet_01v8 L=1.5e-07 W=7.6e-07 $X=14570 $Y=21290 $dt=15
M743 3 702 497 3 nfet_01v8 L=1.5e-07 W=7.6e-07 $X=14570 $Y=29570 $dt=15
M744 3 703 498 3 nfet_01v8 L=1.5e-07 W=7.6e-07 $X=14570 $Y=37850 $dt=15
M745 3 704 499 3 nfet_01v8 L=1.5e-07 W=7.6e-07 $X=14570 $Y=46130 $dt=15
M746 3 705 500 3 nfet_01v8 L=1.5e-07 W=7.6e-07 $X=14570 $Y=54410 $dt=15
M747 3 706 501 3 nfet_01v8 L=1.5e-07 W=7.6e-07 $X=14570 $Y=62690 $dt=15
M748 3 707 502 3 nfet_01v8 L=1.5e-07 W=7.6e-07 $X=14570 $Y=70970 $dt=15
M749 3 708 503 3 nfet_01v8 L=1.5e-07 W=7.6e-07 $X=14570 $Y=79250 $dt=15
M750 3 709 504 3 nfet_01v8 L=1.5e-07 W=7.6e-07 $X=14570 $Y=87530 $dt=15
M751 3 710 505 3 nfet_01v8 L=1.5e-07 W=7.6e-07 $X=14570 $Y=95810 $dt=15
M752 3 711 506 3 nfet_01v8 L=1.5e-07 W=7.6e-07 $X=14570 $Y=104090 $dt=15
M753 3 712 507 3 nfet_01v8 L=1.5e-07 W=7.6e-07 $X=14570 $Y=112370 $dt=15
M754 3 713 508 3 nfet_01v8 L=1.5e-07 W=7.6e-07 $X=14570 $Y=120650 $dt=15
M755 3 714 509 3 nfet_01v8 L=1.5e-07 W=7.6e-07 $X=14570 $Y=128930 $dt=15
M756 3 715 510 3 nfet_01v8 L=1.5e-07 W=7.6e-07 $X=14570 $Y=137210 $dt=15
M757 3 716 511 3 nfet_01v8 L=1.5e-07 W=7.6e-07 $X=14570 $Y=145490 $dt=15
M758 3 717 512 3 nfet_01v8 L=1.5e-07 W=7.6e-07 $X=14570 $Y=153770 $dt=15
M759 3 718 513 3 nfet_01v8 L=1.5e-07 W=7.6e-07 $X=14570 $Y=162050 $dt=15
M760 3 681 514 3 nfet_01v8 L=1.5e-07 W=7.6e-07 $X=14630 $Y=11070 $dt=15
M761 3 682 515 3 nfet_01v8 L=1.5e-07 W=7.6e-07 $X=14630 $Y=19350 $dt=15
M762 3 683 516 3 nfet_01v8 L=1.5e-07 W=7.6e-07 $X=14630 $Y=27630 $dt=15
M763 3 684 517 3 nfet_01v8 L=1.5e-07 W=7.6e-07 $X=14630 $Y=35910 $dt=15
M764 3 685 518 3 nfet_01v8 L=1.5e-07 W=7.6e-07 $X=14630 $Y=44190 $dt=15
M765 3 686 519 3 nfet_01v8 L=1.5e-07 W=7.6e-07 $X=14630 $Y=52470 $dt=15
M766 3 687 520 3 nfet_01v8 L=1.5e-07 W=7.6e-07 $X=14630 $Y=60750 $dt=15
M767 3 688 521 3 nfet_01v8 L=1.5e-07 W=7.6e-07 $X=14630 $Y=69030 $dt=15
M768 3 689 522 3 nfet_01v8 L=1.5e-07 W=7.6e-07 $X=14630 $Y=77310 $dt=15
M769 3 690 523 3 nfet_01v8 L=1.5e-07 W=7.6e-07 $X=14630 $Y=85590 $dt=15
M770 3 691 524 3 nfet_01v8 L=1.5e-07 W=7.6e-07 $X=14630 $Y=93870 $dt=15
M771 3 692 525 3 nfet_01v8 L=1.5e-07 W=7.6e-07 $X=14630 $Y=102150 $dt=15
M772 3 693 526 3 nfet_01v8 L=1.5e-07 W=7.6e-07 $X=14630 $Y=110430 $dt=15
M773 3 694 527 3 nfet_01v8 L=1.5e-07 W=7.6e-07 $X=14630 $Y=118710 $dt=15
M774 3 695 528 3 nfet_01v8 L=1.5e-07 W=7.6e-07 $X=14630 $Y=126990 $dt=15
M775 3 696 529 3 nfet_01v8 L=1.5e-07 W=7.6e-07 $X=14630 $Y=135270 $dt=15
M776 3 697 530 3 nfet_01v8 L=1.5e-07 W=7.6e-07 $X=14630 $Y=143550 $dt=15
M777 3 698 531 3 nfet_01v8 L=1.5e-07 W=7.6e-07 $X=14630 $Y=151830 $dt=15
M778 3 699 532 3 nfet_01v8 L=1.5e-07 W=7.6e-07 $X=14630 $Y=160110 $dt=15
M779 495 700 3 3 nfet_01v8 L=1.5e-07 W=7.6e-07 $X=15000 $Y=13010 $dt=15
M780 496 701 3 3 nfet_01v8 L=1.5e-07 W=7.6e-07 $X=15000 $Y=21290 $dt=15
M781 497 702 3 3 nfet_01v8 L=1.5e-07 W=7.6e-07 $X=15000 $Y=29570 $dt=15
M782 498 703 3 3 nfet_01v8 L=1.5e-07 W=7.6e-07 $X=15000 $Y=37850 $dt=15
M783 499 704 3 3 nfet_01v8 L=1.5e-07 W=7.6e-07 $X=15000 $Y=46130 $dt=15
M784 500 705 3 3 nfet_01v8 L=1.5e-07 W=7.6e-07 $X=15000 $Y=54410 $dt=15
M785 501 706 3 3 nfet_01v8 L=1.5e-07 W=7.6e-07 $X=15000 $Y=62690 $dt=15
M786 502 707 3 3 nfet_01v8 L=1.5e-07 W=7.6e-07 $X=15000 $Y=70970 $dt=15
M787 503 708 3 3 nfet_01v8 L=1.5e-07 W=7.6e-07 $X=15000 $Y=79250 $dt=15
M788 504 709 3 3 nfet_01v8 L=1.5e-07 W=7.6e-07 $X=15000 $Y=87530 $dt=15
M789 505 710 3 3 nfet_01v8 L=1.5e-07 W=7.6e-07 $X=15000 $Y=95810 $dt=15
M790 506 711 3 3 nfet_01v8 L=1.5e-07 W=7.6e-07 $X=15000 $Y=104090 $dt=15
M791 507 712 3 3 nfet_01v8 L=1.5e-07 W=7.6e-07 $X=15000 $Y=112370 $dt=15
M792 508 713 3 3 nfet_01v8 L=1.5e-07 W=7.6e-07 $X=15000 $Y=120650 $dt=15
M793 509 714 3 3 nfet_01v8 L=1.5e-07 W=7.6e-07 $X=15000 $Y=128930 $dt=15
M794 510 715 3 3 nfet_01v8 L=1.5e-07 W=7.6e-07 $X=15000 $Y=137210 $dt=15
M795 511 716 3 3 nfet_01v8 L=1.5e-07 W=7.6e-07 $X=15000 $Y=145490 $dt=15
M796 512 717 3 3 nfet_01v8 L=1.5e-07 W=7.6e-07 $X=15000 $Y=153770 $dt=15
M797 513 718 3 3 nfet_01v8 L=1.5e-07 W=7.6e-07 $X=15000 $Y=162050 $dt=15
M798 514 681 3 3 nfet_01v8 L=1.5e-07 W=7.6e-07 $X=15060 $Y=11070 $dt=15
M799 515 682 3 3 nfet_01v8 L=1.5e-07 W=7.6e-07 $X=15060 $Y=19350 $dt=15
M800 516 683 3 3 nfet_01v8 L=1.5e-07 W=7.6e-07 $X=15060 $Y=27630 $dt=15
M801 517 684 3 3 nfet_01v8 L=1.5e-07 W=7.6e-07 $X=15060 $Y=35910 $dt=15
M802 518 685 3 3 nfet_01v8 L=1.5e-07 W=7.6e-07 $X=15060 $Y=44190 $dt=15
M803 519 686 3 3 nfet_01v8 L=1.5e-07 W=7.6e-07 $X=15060 $Y=52470 $dt=15
M804 520 687 3 3 nfet_01v8 L=1.5e-07 W=7.6e-07 $X=15060 $Y=60750 $dt=15
M805 521 688 3 3 nfet_01v8 L=1.5e-07 W=7.6e-07 $X=15060 $Y=69030 $dt=15
M806 522 689 3 3 nfet_01v8 L=1.5e-07 W=7.6e-07 $X=15060 $Y=77310 $dt=15
M807 523 690 3 3 nfet_01v8 L=1.5e-07 W=7.6e-07 $X=15060 $Y=85590 $dt=15
M808 524 691 3 3 nfet_01v8 L=1.5e-07 W=7.6e-07 $X=15060 $Y=93870 $dt=15
M809 525 692 3 3 nfet_01v8 L=1.5e-07 W=7.6e-07 $X=15060 $Y=102150 $dt=15
M810 526 693 3 3 nfet_01v8 L=1.5e-07 W=7.6e-07 $X=15060 $Y=110430 $dt=15
M811 527 694 3 3 nfet_01v8 L=1.5e-07 W=7.6e-07 $X=15060 $Y=118710 $dt=15
M812 528 695 3 3 nfet_01v8 L=1.5e-07 W=7.6e-07 $X=15060 $Y=126990 $dt=15
M813 529 696 3 3 nfet_01v8 L=1.5e-07 W=7.6e-07 $X=15060 $Y=135270 $dt=15
M814 530 697 3 3 nfet_01v8 L=1.5e-07 W=7.6e-07 $X=15060 $Y=143550 $dt=15
M815 531 698 3 3 nfet_01v8 L=1.5e-07 W=7.6e-07 $X=15060 $Y=151830 $dt=15
M816 532 699 3 3 nfet_01v8 L=1.5e-07 W=7.6e-07 $X=15060 $Y=160110 $dt=15
M817 3 700 495 3 nfet_01v8 L=1.5e-07 W=7.6e-07 $X=15430 $Y=13010 $dt=15
M818 3 701 496 3 nfet_01v8 L=1.5e-07 W=7.6e-07 $X=15430 $Y=21290 $dt=15
M819 3 702 497 3 nfet_01v8 L=1.5e-07 W=7.6e-07 $X=15430 $Y=29570 $dt=15
M820 3 703 498 3 nfet_01v8 L=1.5e-07 W=7.6e-07 $X=15430 $Y=37850 $dt=15
M821 3 704 499 3 nfet_01v8 L=1.5e-07 W=7.6e-07 $X=15430 $Y=46130 $dt=15
M822 3 705 500 3 nfet_01v8 L=1.5e-07 W=7.6e-07 $X=15430 $Y=54410 $dt=15
M823 3 706 501 3 nfet_01v8 L=1.5e-07 W=7.6e-07 $X=15430 $Y=62690 $dt=15
M824 3 707 502 3 nfet_01v8 L=1.5e-07 W=7.6e-07 $X=15430 $Y=70970 $dt=15
M825 3 708 503 3 nfet_01v8 L=1.5e-07 W=7.6e-07 $X=15430 $Y=79250 $dt=15
M826 3 709 504 3 nfet_01v8 L=1.5e-07 W=7.6e-07 $X=15430 $Y=87530 $dt=15
M827 3 710 505 3 nfet_01v8 L=1.5e-07 W=7.6e-07 $X=15430 $Y=95810 $dt=15
M828 3 711 506 3 nfet_01v8 L=1.5e-07 W=7.6e-07 $X=15430 $Y=104090 $dt=15
M829 3 712 507 3 nfet_01v8 L=1.5e-07 W=7.6e-07 $X=15430 $Y=112370 $dt=15
M830 3 713 508 3 nfet_01v8 L=1.5e-07 W=7.6e-07 $X=15430 $Y=120650 $dt=15
M831 3 714 509 3 nfet_01v8 L=1.5e-07 W=7.6e-07 $X=15430 $Y=128930 $dt=15
M832 3 715 510 3 nfet_01v8 L=1.5e-07 W=7.6e-07 $X=15430 $Y=137210 $dt=15
M833 3 716 511 3 nfet_01v8 L=1.5e-07 W=7.6e-07 $X=15430 $Y=145490 $dt=15
M834 3 717 512 3 nfet_01v8 L=1.5e-07 W=7.6e-07 $X=15430 $Y=153770 $dt=15
M835 3 718 513 3 nfet_01v8 L=1.5e-07 W=7.6e-07 $X=15430 $Y=162050 $dt=15
M836 3 681 514 3 nfet_01v8 L=1.5e-07 W=7.6e-07 $X=15490 $Y=11070 $dt=15
M837 3 682 515 3 nfet_01v8 L=1.5e-07 W=7.6e-07 $X=15490 $Y=19350 $dt=15
M838 3 683 516 3 nfet_01v8 L=1.5e-07 W=7.6e-07 $X=15490 $Y=27630 $dt=15
M839 3 684 517 3 nfet_01v8 L=1.5e-07 W=7.6e-07 $X=15490 $Y=35910 $dt=15
M840 3 685 518 3 nfet_01v8 L=1.5e-07 W=7.6e-07 $X=15490 $Y=44190 $dt=15
M841 3 686 519 3 nfet_01v8 L=1.5e-07 W=7.6e-07 $X=15490 $Y=52470 $dt=15
M842 3 687 520 3 nfet_01v8 L=1.5e-07 W=7.6e-07 $X=15490 $Y=60750 $dt=15
M843 3 688 521 3 nfet_01v8 L=1.5e-07 W=7.6e-07 $X=15490 $Y=69030 $dt=15
M844 3 689 522 3 nfet_01v8 L=1.5e-07 W=7.6e-07 $X=15490 $Y=77310 $dt=15
M845 3 690 523 3 nfet_01v8 L=1.5e-07 W=7.6e-07 $X=15490 $Y=85590 $dt=15
M846 3 691 524 3 nfet_01v8 L=1.5e-07 W=7.6e-07 $X=15490 $Y=93870 $dt=15
M847 3 692 525 3 nfet_01v8 L=1.5e-07 W=7.6e-07 $X=15490 $Y=102150 $dt=15
M848 3 693 526 3 nfet_01v8 L=1.5e-07 W=7.6e-07 $X=15490 $Y=110430 $dt=15
M849 3 694 527 3 nfet_01v8 L=1.5e-07 W=7.6e-07 $X=15490 $Y=118710 $dt=15
M850 3 695 528 3 nfet_01v8 L=1.5e-07 W=7.6e-07 $X=15490 $Y=126990 $dt=15
M851 3 696 529 3 nfet_01v8 L=1.5e-07 W=7.6e-07 $X=15490 $Y=135270 $dt=15
M852 3 697 530 3 nfet_01v8 L=1.5e-07 W=7.6e-07 $X=15490 $Y=143550 $dt=15
M853 3 698 531 3 nfet_01v8 L=1.5e-07 W=7.6e-07 $X=15490 $Y=151830 $dt=15
M854 3 699 532 3 nfet_01v8 L=1.5e-07 W=7.6e-07 $X=15490 $Y=160110 $dt=15
M855 667 534 324 3 nfet_01v8 L=1.5e-07 W=1.5e-06 $X=17630 $Y=13190 $dt=15
M856 668 536 324 3 nfet_01v8 L=1.5e-07 W=1.5e-06 $X=17630 $Y=21470 $dt=15
M857 669 538 324 3 nfet_01v8 L=1.5e-07 W=1.5e-06 $X=17630 $Y=29750 $dt=15
M858 670 540 324 3 nfet_01v8 L=1.5e-07 W=1.5e-06 $X=17630 $Y=38030 $dt=15
M859 671 542 324 3 nfet_01v8 L=1.5e-07 W=1.5e-06 $X=17630 $Y=46310 $dt=15
M860 672 544 324 3 nfet_01v8 L=1.5e-07 W=1.5e-06 $X=17630 $Y=54590 $dt=15
M861 673 546 324 3 nfet_01v8 L=1.5e-07 W=1.5e-06 $X=17630 $Y=62870 $dt=15
M862 3 1 3 3 nfet_01v8 L=5.8e-07 W=1.5e-06 $X=17630 $Y=71150 $dt=15
M863 3 1 3 3 nfet_01v8 L=5.8e-07 W=1.5e-06 $X=17630 $Y=79430 $dt=15
M864 3 1 3 3 nfet_01v8 L=5.8e-07 W=1.5e-06 $X=17630 $Y=87710 $dt=15
M865 3 1 3 3 nfet_01v8 L=5.8e-07 W=1.5e-06 $X=17630 $Y=95990 $dt=15
M866 3 1 3 3 nfet_01v8 L=5.8e-07 W=1.5e-06 $X=17630 $Y=104270 $dt=15
M867 674 558 324 3 nfet_01v8 L=1.5e-07 W=1.5e-06 $X=17630 $Y=112550 $dt=15
M868 675 560 324 3 nfet_01v8 L=1.5e-07 W=1.5e-06 $X=17630 $Y=120830 $dt=15
M869 676 562 324 3 nfet_01v8 L=1.5e-07 W=1.5e-06 $X=17630 $Y=129110 $dt=15
M870 677 564 324 3 nfet_01v8 L=1.5e-07 W=1.5e-06 $X=17630 $Y=137390 $dt=15
M871 678 566 324 3 nfet_01v8 L=1.5e-07 W=1.5e-06 $X=17630 $Y=145670 $dt=15
M872 679 568 324 3 nfet_01v8 L=1.5e-07 W=1.5e-06 $X=17630 $Y=153950 $dt=15
M873 680 570 324 3 nfet_01v8 L=1.5e-07 W=1.5e-06 $X=17630 $Y=162230 $dt=15
M874 667 514 667 3 nfet_01v8 L=1.5e-07 W=1.5e-06 $X=18060 $Y=13190 $dt=15
M875 668 515 668 3 nfet_01v8 L=1.5e-07 W=1.5e-06 $X=18060 $Y=21470 $dt=15
M876 669 516 669 3 nfet_01v8 L=1.5e-07 W=1.5e-06 $X=18060 $Y=29750 $dt=15
M877 670 517 670 3 nfet_01v8 L=1.5e-07 W=1.5e-06 $X=18060 $Y=38030 $dt=15
M878 671 518 671 3 nfet_01v8 L=1.5e-07 W=1.5e-06 $X=18060 $Y=46310 $dt=15
M879 672 519 672 3 nfet_01v8 L=1.5e-07 W=1.5e-06 $X=18060 $Y=54590 $dt=15
M880 673 520 673 3 nfet_01v8 L=1.5e-07 W=1.5e-06 $X=18060 $Y=62870 $dt=15
M881 674 526 674 3 nfet_01v8 L=1.5e-07 W=1.5e-06 $X=18060 $Y=112550 $dt=15
M882 675 527 675 3 nfet_01v8 L=1.5e-07 W=1.5e-06 $X=18060 $Y=120830 $dt=15
M883 676 528 676 3 nfet_01v8 L=1.5e-07 W=1.5e-06 $X=18060 $Y=129110 $dt=15
M884 677 529 677 3 nfet_01v8 L=1.5e-07 W=1.5e-06 $X=18060 $Y=137390 $dt=15
M885 678 530 678 3 nfet_01v8 L=1.5e-07 W=1.5e-06 $X=18060 $Y=145670 $dt=15
M886 679 531 679 3 nfet_01v8 L=1.5e-07 W=1.5e-06 $X=18060 $Y=153950 $dt=15
M887 680 532 680 3 nfet_01v8 L=1.5e-07 W=1.5e-06 $X=18060 $Y=162230 $dt=15
M888 3 1 3 3 nfet_01v8 L=5.8e-07 W=1.5e-06 $X=23750 $Y=71150 $dt=15
M889 3 1 3 3 nfet_01v8 L=5.8e-07 W=1.5e-06 $X=23750 $Y=79430 $dt=15
M890 3 1 3 3 nfet_01v8 L=5.8e-07 W=1.5e-06 $X=23750 $Y=87710 $dt=15
M891 3 1 3 3 nfet_01v8 L=5.8e-07 W=1.5e-06 $X=23750 $Y=95990 $dt=15
M892 3 1 3 3 nfet_01v8 L=5.8e-07 W=1.5e-06 $X=23750 $Y=104270 $dt=15
M893 667 495 309 3 nfet_01v8 L=1.5e-07 W=1.5e-06 $X=23760 $Y=13190 $dt=15
M894 668 496 309 3 nfet_01v8 L=1.5e-07 W=1.5e-06 $X=23760 $Y=21470 $dt=15
M895 669 497 309 3 nfet_01v8 L=1.5e-07 W=1.5e-06 $X=23760 $Y=29750 $dt=15
M896 670 498 309 3 nfet_01v8 L=1.5e-07 W=1.5e-06 $X=23760 $Y=38030 $dt=15
M897 671 499 309 3 nfet_01v8 L=1.5e-07 W=1.5e-06 $X=23760 $Y=46310 $dt=15
M898 672 500 309 3 nfet_01v8 L=1.5e-07 W=1.5e-06 $X=23760 $Y=54590 $dt=15
M899 673 501 309 3 nfet_01v8 L=1.5e-07 W=1.5e-06 $X=23760 $Y=62870 $dt=15
M900 674 507 309 3 nfet_01v8 L=1.5e-07 W=1.5e-06 $X=23760 $Y=112550 $dt=15
M901 675 508 309 3 nfet_01v8 L=1.5e-07 W=1.5e-06 $X=23760 $Y=120830 $dt=15
M902 676 509 309 3 nfet_01v8 L=1.5e-07 W=1.5e-06 $X=23760 $Y=129110 $dt=15
M903 677 510 309 3 nfet_01v8 L=1.5e-07 W=1.5e-06 $X=23760 $Y=137390 $dt=15
M904 678 511 309 3 nfet_01v8 L=1.5e-07 W=1.5e-06 $X=23760 $Y=145670 $dt=15
M905 679 512 309 3 nfet_01v8 L=1.5e-07 W=1.5e-06 $X=23760 $Y=153950 $dt=15
M906 680 513 309 3 nfet_01v8 L=1.5e-07 W=1.5e-06 $X=23760 $Y=162230 $dt=15
M907 308 458 667 3 nfet_01v8 L=1.5e-07 W=1.5e-06 $X=24190 $Y=13190 $dt=15
M908 308 460 668 3 nfet_01v8 L=1.5e-07 W=1.5e-06 $X=24190 $Y=21470 $dt=15
M909 308 462 669 3 nfet_01v8 L=1.5e-07 W=1.5e-06 $X=24190 $Y=29750 $dt=15
M910 308 464 670 3 nfet_01v8 L=1.5e-07 W=1.5e-06 $X=24190 $Y=38030 $dt=15
M911 308 466 671 3 nfet_01v8 L=1.5e-07 W=1.5e-06 $X=24190 $Y=46310 $dt=15
M912 308 468 672 3 nfet_01v8 L=1.5e-07 W=1.5e-06 $X=24190 $Y=54590 $dt=15
M913 308 470 673 3 nfet_01v8 L=1.5e-07 W=1.5e-06 $X=24190 $Y=62870 $dt=15
M914 308 482 674 3 nfet_01v8 L=1.5e-07 W=1.5e-06 $X=24190 $Y=112550 $dt=15
M915 308 484 675 3 nfet_01v8 L=1.5e-07 W=1.5e-06 $X=24190 $Y=120830 $dt=15
M916 308 486 676 3 nfet_01v8 L=1.5e-07 W=1.5e-06 $X=24190 $Y=129110 $dt=15
M917 308 488 677 3 nfet_01v8 L=1.5e-07 W=1.5e-06 $X=24190 $Y=137390 $dt=15
M918 308 490 678 3 nfet_01v8 L=1.5e-07 W=1.5e-06 $X=24190 $Y=145670 $dt=15
M919 308 492 679 3 nfet_01v8 L=1.5e-07 W=1.5e-06 $X=24190 $Y=153950 $dt=15
M920 308 494 680 3 nfet_01v8 L=1.5e-07 W=1.5e-06 $X=24190 $Y=162230 $dt=15
M921 653 534 324 3 nfet_01v8 L=1.5e-07 W=1.5e-06 $X=25910 $Y=13190 $dt=15
M922 654 536 324 3 nfet_01v8 L=1.5e-07 W=1.5e-06 $X=25910 $Y=21470 $dt=15
M923 655 538 324 3 nfet_01v8 L=1.5e-07 W=1.5e-06 $X=25910 $Y=29750 $dt=15
M924 656 540 324 3 nfet_01v8 L=1.5e-07 W=1.5e-06 $X=25910 $Y=38030 $dt=15
M925 657 542 324 3 nfet_01v8 L=1.5e-07 W=1.5e-06 $X=25910 $Y=46310 $dt=15
M926 658 544 324 3 nfet_01v8 L=1.5e-07 W=1.5e-06 $X=25910 $Y=54590 $dt=15
M927 659 546 324 3 nfet_01v8 L=1.5e-07 W=1.5e-06 $X=25910 $Y=62870 $dt=15
M928 3 1 3 3 nfet_01v8 L=5.8e-07 W=1.5e-06 $X=25910 $Y=71150 $dt=15
M929 3 1 3 3 nfet_01v8 L=5.8e-07 W=1.5e-06 $X=25910 $Y=79430 $dt=15
M930 3 1 3 3 nfet_01v8 L=5.8e-07 W=1.5e-06 $X=25910 $Y=87710 $dt=15
M931 3 1 3 3 nfet_01v8 L=5.8e-07 W=1.5e-06 $X=25910 $Y=95990 $dt=15
M932 3 1 3 3 nfet_01v8 L=5.8e-07 W=1.5e-06 $X=25910 $Y=104270 $dt=15
M933 660 558 324 3 nfet_01v8 L=1.5e-07 W=1.5e-06 $X=25910 $Y=112550 $dt=15
M934 661 560 324 3 nfet_01v8 L=1.5e-07 W=1.5e-06 $X=25910 $Y=120830 $dt=15
M935 662 562 324 3 nfet_01v8 L=1.5e-07 W=1.5e-06 $X=25910 $Y=129110 $dt=15
M936 663 564 324 3 nfet_01v8 L=1.5e-07 W=1.5e-06 $X=25910 $Y=137390 $dt=15
M937 664 566 324 3 nfet_01v8 L=1.5e-07 W=1.5e-06 $X=25910 $Y=145670 $dt=15
M938 665 568 324 3 nfet_01v8 L=1.5e-07 W=1.5e-06 $X=25910 $Y=153950 $dt=15
M939 666 570 324 3 nfet_01v8 L=1.5e-07 W=1.5e-06 $X=25910 $Y=162230 $dt=15
M940 653 514 653 3 nfet_01v8 L=1.5e-07 W=1.5e-06 $X=26340 $Y=13190 $dt=15
M941 654 515 654 3 nfet_01v8 L=1.5e-07 W=1.5e-06 $X=26340 $Y=21470 $dt=15
M942 655 516 655 3 nfet_01v8 L=1.5e-07 W=1.5e-06 $X=26340 $Y=29750 $dt=15
M943 656 517 656 3 nfet_01v8 L=1.5e-07 W=1.5e-06 $X=26340 $Y=38030 $dt=15
M944 657 518 657 3 nfet_01v8 L=1.5e-07 W=1.5e-06 $X=26340 $Y=46310 $dt=15
M945 658 519 658 3 nfet_01v8 L=1.5e-07 W=1.5e-06 $X=26340 $Y=54590 $dt=15
M946 659 520 659 3 nfet_01v8 L=1.5e-07 W=1.5e-06 $X=26340 $Y=62870 $dt=15
M947 660 526 660 3 nfet_01v8 L=1.5e-07 W=1.5e-06 $X=26340 $Y=112550 $dt=15
M948 661 527 661 3 nfet_01v8 L=1.5e-07 W=1.5e-06 $X=26340 $Y=120830 $dt=15
M949 662 528 662 3 nfet_01v8 L=1.5e-07 W=1.5e-06 $X=26340 $Y=129110 $dt=15
M950 663 529 663 3 nfet_01v8 L=1.5e-07 W=1.5e-06 $X=26340 $Y=137390 $dt=15
M951 664 530 664 3 nfet_01v8 L=1.5e-07 W=1.5e-06 $X=26340 $Y=145670 $dt=15
M952 665 531 665 3 nfet_01v8 L=1.5e-07 W=1.5e-06 $X=26340 $Y=153950 $dt=15
M953 666 532 666 3 nfet_01v8 L=1.5e-07 W=1.5e-06 $X=26340 $Y=162230 $dt=15
M954 3 1 3 3 nfet_01v8 L=5.8e-07 W=1.5e-06 $X=32030 $Y=71150 $dt=15
M955 3 1 3 3 nfet_01v8 L=5.8e-07 W=1.5e-06 $X=32030 $Y=79430 $dt=15
M956 3 1 3 3 nfet_01v8 L=5.8e-07 W=1.5e-06 $X=32030 $Y=87710 $dt=15
M957 3 1 3 3 nfet_01v8 L=5.8e-07 W=1.5e-06 $X=32030 $Y=95990 $dt=15
M958 3 1 3 3 nfet_01v8 L=5.8e-07 W=1.5e-06 $X=32030 $Y=104270 $dt=15
M959 653 495 309 3 nfet_01v8 L=1.5e-07 W=1.5e-06 $X=32040 $Y=13190 $dt=15
M960 654 496 309 3 nfet_01v8 L=1.5e-07 W=1.5e-06 $X=32040 $Y=21470 $dt=15
M961 655 497 309 3 nfet_01v8 L=1.5e-07 W=1.5e-06 $X=32040 $Y=29750 $dt=15
M962 656 498 309 3 nfet_01v8 L=1.5e-07 W=1.5e-06 $X=32040 $Y=38030 $dt=15
M963 657 499 309 3 nfet_01v8 L=1.5e-07 W=1.5e-06 $X=32040 $Y=46310 $dt=15
M964 658 500 309 3 nfet_01v8 L=1.5e-07 W=1.5e-06 $X=32040 $Y=54590 $dt=15
M965 659 501 309 3 nfet_01v8 L=1.5e-07 W=1.5e-06 $X=32040 $Y=62870 $dt=15
M966 660 507 309 3 nfet_01v8 L=1.5e-07 W=1.5e-06 $X=32040 $Y=112550 $dt=15
M967 661 508 309 3 nfet_01v8 L=1.5e-07 W=1.5e-06 $X=32040 $Y=120830 $dt=15
M968 662 509 309 3 nfet_01v8 L=1.5e-07 W=1.5e-06 $X=32040 $Y=129110 $dt=15
M969 663 510 309 3 nfet_01v8 L=1.5e-07 W=1.5e-06 $X=32040 $Y=137390 $dt=15
M970 664 511 309 3 nfet_01v8 L=1.5e-07 W=1.5e-06 $X=32040 $Y=145670 $dt=15
M971 665 512 309 3 nfet_01v8 L=1.5e-07 W=1.5e-06 $X=32040 $Y=153950 $dt=15
M972 666 513 309 3 nfet_01v8 L=1.5e-07 W=1.5e-06 $X=32040 $Y=162230 $dt=15
M973 308 458 653 3 nfet_01v8 L=1.5e-07 W=1.5e-06 $X=32470 $Y=13190 $dt=15
M974 308 460 654 3 nfet_01v8 L=1.5e-07 W=1.5e-06 $X=32470 $Y=21470 $dt=15
M975 308 462 655 3 nfet_01v8 L=1.5e-07 W=1.5e-06 $X=32470 $Y=29750 $dt=15
M976 308 464 656 3 nfet_01v8 L=1.5e-07 W=1.5e-06 $X=32470 $Y=38030 $dt=15
M977 308 466 657 3 nfet_01v8 L=1.5e-07 W=1.5e-06 $X=32470 $Y=46310 $dt=15
M978 308 468 658 3 nfet_01v8 L=1.5e-07 W=1.5e-06 $X=32470 $Y=54590 $dt=15
M979 308 470 659 3 nfet_01v8 L=1.5e-07 W=1.5e-06 $X=32470 $Y=62870 $dt=15
M980 308 482 660 3 nfet_01v8 L=1.5e-07 W=1.5e-06 $X=32470 $Y=112550 $dt=15
M981 308 484 661 3 nfet_01v8 L=1.5e-07 W=1.5e-06 $X=32470 $Y=120830 $dt=15
M982 308 486 662 3 nfet_01v8 L=1.5e-07 W=1.5e-06 $X=32470 $Y=129110 $dt=15
M983 308 488 663 3 nfet_01v8 L=1.5e-07 W=1.5e-06 $X=32470 $Y=137390 $dt=15
M984 308 490 664 3 nfet_01v8 L=1.5e-07 W=1.5e-06 $X=32470 $Y=145670 $dt=15
M985 308 492 665 3 nfet_01v8 L=1.5e-07 W=1.5e-06 $X=32470 $Y=153950 $dt=15
M986 308 494 666 3 nfet_01v8 L=1.5e-07 W=1.5e-06 $X=32470 $Y=162230 $dt=15
M987 639 534 324 3 nfet_01v8 L=1.5e-07 W=1.5e-06 $X=34190 $Y=13190 $dt=15
M988 640 536 324 3 nfet_01v8 L=1.5e-07 W=1.5e-06 $X=34190 $Y=21470 $dt=15
M989 641 538 324 3 nfet_01v8 L=1.5e-07 W=1.5e-06 $X=34190 $Y=29750 $dt=15
M990 642 540 324 3 nfet_01v8 L=1.5e-07 W=1.5e-06 $X=34190 $Y=38030 $dt=15
M991 643 542 324 3 nfet_01v8 L=1.5e-07 W=1.5e-06 $X=34190 $Y=46310 $dt=15
M992 644 544 324 3 nfet_01v8 L=1.5e-07 W=1.5e-06 $X=34190 $Y=54590 $dt=15
M993 645 546 324 3 nfet_01v8 L=1.5e-07 W=1.5e-06 $X=34190 $Y=62870 $dt=15
M994 3 1 3 3 nfet_01v8 L=5.8e-07 W=1.5e-06 $X=34190 $Y=71150 $dt=15
M995 3 1 3 3 nfet_01v8 L=5.8e-07 W=1.5e-06 $X=34190 $Y=79430 $dt=15
M996 3 1 3 3 nfet_01v8 L=5.8e-07 W=1.5e-06 $X=34190 $Y=87710 $dt=15
M997 3 1 3 3 nfet_01v8 L=5.8e-07 W=1.5e-06 $X=34190 $Y=95990 $dt=15
M998 3 1 3 3 nfet_01v8 L=5.8e-07 W=1.5e-06 $X=34190 $Y=104270 $dt=15
M999 646 558 324 3 nfet_01v8 L=1.5e-07 W=1.5e-06 $X=34190 $Y=112550 $dt=15
M1000 647 560 324 3 nfet_01v8 L=1.5e-07 W=1.5e-06 $X=34190 $Y=120830 $dt=15
M1001 648 562 324 3 nfet_01v8 L=1.5e-07 W=1.5e-06 $X=34190 $Y=129110 $dt=15
M1002 649 564 324 3 nfet_01v8 L=1.5e-07 W=1.5e-06 $X=34190 $Y=137390 $dt=15
M1003 650 566 324 3 nfet_01v8 L=1.5e-07 W=1.5e-06 $X=34190 $Y=145670 $dt=15
M1004 651 568 324 3 nfet_01v8 L=1.5e-07 W=1.5e-06 $X=34190 $Y=153950 $dt=15
M1005 652 570 324 3 nfet_01v8 L=1.5e-07 W=1.5e-06 $X=34190 $Y=162230 $dt=15
M1006 639 514 639 3 nfet_01v8 L=1.5e-07 W=1.5e-06 $X=34620 $Y=13190 $dt=15
M1007 640 515 640 3 nfet_01v8 L=1.5e-07 W=1.5e-06 $X=34620 $Y=21470 $dt=15
M1008 641 516 641 3 nfet_01v8 L=1.5e-07 W=1.5e-06 $X=34620 $Y=29750 $dt=15
M1009 642 517 642 3 nfet_01v8 L=1.5e-07 W=1.5e-06 $X=34620 $Y=38030 $dt=15
M1010 643 518 643 3 nfet_01v8 L=1.5e-07 W=1.5e-06 $X=34620 $Y=46310 $dt=15
M1011 644 519 644 3 nfet_01v8 L=1.5e-07 W=1.5e-06 $X=34620 $Y=54590 $dt=15
M1012 645 520 645 3 nfet_01v8 L=1.5e-07 W=1.5e-06 $X=34620 $Y=62870 $dt=15
M1013 646 526 646 3 nfet_01v8 L=1.5e-07 W=1.5e-06 $X=34620 $Y=112550 $dt=15
M1014 647 527 647 3 nfet_01v8 L=1.5e-07 W=1.5e-06 $X=34620 $Y=120830 $dt=15
M1015 648 528 648 3 nfet_01v8 L=1.5e-07 W=1.5e-06 $X=34620 $Y=129110 $dt=15
M1016 649 529 649 3 nfet_01v8 L=1.5e-07 W=1.5e-06 $X=34620 $Y=137390 $dt=15
M1017 650 530 650 3 nfet_01v8 L=1.5e-07 W=1.5e-06 $X=34620 $Y=145670 $dt=15
M1018 651 531 651 3 nfet_01v8 L=1.5e-07 W=1.5e-06 $X=34620 $Y=153950 $dt=15
M1019 652 532 652 3 nfet_01v8 L=1.5e-07 W=1.5e-06 $X=34620 $Y=162230 $dt=15
M1020 3 1 3 3 nfet_01v8 L=5.8e-07 W=1.5e-06 $X=40310 $Y=71150 $dt=15
M1021 3 1 3 3 nfet_01v8 L=5.8e-07 W=1.5e-06 $X=40310 $Y=79430 $dt=15
M1022 3 1 3 3 nfet_01v8 L=5.8e-07 W=1.5e-06 $X=40310 $Y=87710 $dt=15
M1023 3 1 3 3 nfet_01v8 L=5.8e-07 W=1.5e-06 $X=40310 $Y=95990 $dt=15
M1024 3 1 3 3 nfet_01v8 L=5.8e-07 W=1.5e-06 $X=40310 $Y=104270 $dt=15
M1025 639 495 309 3 nfet_01v8 L=1.5e-07 W=1.5e-06 $X=40320 $Y=13190 $dt=15
M1026 640 496 309 3 nfet_01v8 L=1.5e-07 W=1.5e-06 $X=40320 $Y=21470 $dt=15
M1027 641 497 309 3 nfet_01v8 L=1.5e-07 W=1.5e-06 $X=40320 $Y=29750 $dt=15
M1028 642 498 309 3 nfet_01v8 L=1.5e-07 W=1.5e-06 $X=40320 $Y=38030 $dt=15
M1029 643 499 309 3 nfet_01v8 L=1.5e-07 W=1.5e-06 $X=40320 $Y=46310 $dt=15
M1030 644 500 309 3 nfet_01v8 L=1.5e-07 W=1.5e-06 $X=40320 $Y=54590 $dt=15
M1031 645 501 309 3 nfet_01v8 L=1.5e-07 W=1.5e-06 $X=40320 $Y=62870 $dt=15
M1032 646 507 309 3 nfet_01v8 L=1.5e-07 W=1.5e-06 $X=40320 $Y=112550 $dt=15
M1033 647 508 309 3 nfet_01v8 L=1.5e-07 W=1.5e-06 $X=40320 $Y=120830 $dt=15
M1034 648 509 309 3 nfet_01v8 L=1.5e-07 W=1.5e-06 $X=40320 $Y=129110 $dt=15
M1035 649 510 309 3 nfet_01v8 L=1.5e-07 W=1.5e-06 $X=40320 $Y=137390 $dt=15
M1036 650 511 309 3 nfet_01v8 L=1.5e-07 W=1.5e-06 $X=40320 $Y=145670 $dt=15
M1037 651 512 309 3 nfet_01v8 L=1.5e-07 W=1.5e-06 $X=40320 $Y=153950 $dt=15
M1038 652 513 309 3 nfet_01v8 L=1.5e-07 W=1.5e-06 $X=40320 $Y=162230 $dt=15
M1039 308 458 639 3 nfet_01v8 L=1.5e-07 W=1.5e-06 $X=40750 $Y=13190 $dt=15
M1040 308 460 640 3 nfet_01v8 L=1.5e-07 W=1.5e-06 $X=40750 $Y=21470 $dt=15
M1041 308 462 641 3 nfet_01v8 L=1.5e-07 W=1.5e-06 $X=40750 $Y=29750 $dt=15
M1042 308 464 642 3 nfet_01v8 L=1.5e-07 W=1.5e-06 $X=40750 $Y=38030 $dt=15
M1043 308 466 643 3 nfet_01v8 L=1.5e-07 W=1.5e-06 $X=40750 $Y=46310 $dt=15
M1044 308 468 644 3 nfet_01v8 L=1.5e-07 W=1.5e-06 $X=40750 $Y=54590 $dt=15
M1045 308 470 645 3 nfet_01v8 L=1.5e-07 W=1.5e-06 $X=40750 $Y=62870 $dt=15
M1046 308 482 646 3 nfet_01v8 L=1.5e-07 W=1.5e-06 $X=40750 $Y=112550 $dt=15
M1047 308 484 647 3 nfet_01v8 L=1.5e-07 W=1.5e-06 $X=40750 $Y=120830 $dt=15
M1048 308 486 648 3 nfet_01v8 L=1.5e-07 W=1.5e-06 $X=40750 $Y=129110 $dt=15
M1049 308 488 649 3 nfet_01v8 L=1.5e-07 W=1.5e-06 $X=40750 $Y=137390 $dt=15
M1050 308 490 650 3 nfet_01v8 L=1.5e-07 W=1.5e-06 $X=40750 $Y=145670 $dt=15
M1051 308 492 651 3 nfet_01v8 L=1.5e-07 W=1.5e-06 $X=40750 $Y=153950 $dt=15
M1052 308 494 652 3 nfet_01v8 L=1.5e-07 W=1.5e-06 $X=40750 $Y=162230 $dt=15
M1053 625 534 324 3 nfet_01v8 L=1.5e-07 W=1.5e-06 $X=42470 $Y=13190 $dt=15
M1054 626 536 324 3 nfet_01v8 L=1.5e-07 W=1.5e-06 $X=42470 $Y=21470 $dt=15
M1055 627 538 324 3 nfet_01v8 L=1.5e-07 W=1.5e-06 $X=42470 $Y=29750 $dt=15
M1056 628 540 324 3 nfet_01v8 L=1.5e-07 W=1.5e-06 $X=42470 $Y=38030 $dt=15
M1057 629 542 324 3 nfet_01v8 L=1.5e-07 W=1.5e-06 $X=42470 $Y=46310 $dt=15
M1058 630 544 324 3 nfet_01v8 L=1.5e-07 W=1.5e-06 $X=42470 $Y=54590 $dt=15
M1059 631 546 324 3 nfet_01v8 L=1.5e-07 W=1.5e-06 $X=42470 $Y=62870 $dt=15
M1060 3 1 3 3 nfet_01v8 L=5.8e-07 W=1.5e-06 $X=42470 $Y=71150 $dt=15
M1061 3 1 3 3 nfet_01v8 L=5.8e-07 W=1.5e-06 $X=42470 $Y=79430 $dt=15
M1062 3 1 3 3 nfet_01v8 L=5.8e-07 W=1.5e-06 $X=42470 $Y=87710 $dt=15
M1063 3 1 3 3 nfet_01v8 L=5.8e-07 W=1.5e-06 $X=42470 $Y=95990 $dt=15
M1064 3 1 3 3 nfet_01v8 L=5.8e-07 W=1.5e-06 $X=42470 $Y=104270 $dt=15
M1065 632 558 324 3 nfet_01v8 L=1.5e-07 W=1.5e-06 $X=42470 $Y=112550 $dt=15
M1066 633 560 324 3 nfet_01v8 L=1.5e-07 W=1.5e-06 $X=42470 $Y=120830 $dt=15
M1067 634 562 324 3 nfet_01v8 L=1.5e-07 W=1.5e-06 $X=42470 $Y=129110 $dt=15
M1068 635 564 324 3 nfet_01v8 L=1.5e-07 W=1.5e-06 $X=42470 $Y=137390 $dt=15
M1069 636 566 324 3 nfet_01v8 L=1.5e-07 W=1.5e-06 $X=42470 $Y=145670 $dt=15
M1070 637 568 324 3 nfet_01v8 L=1.5e-07 W=1.5e-06 $X=42470 $Y=153950 $dt=15
M1071 638 570 324 3 nfet_01v8 L=1.5e-07 W=1.5e-06 $X=42470 $Y=162230 $dt=15
M1072 625 514 625 3 nfet_01v8 L=1.5e-07 W=1.5e-06 $X=42900 $Y=13190 $dt=15
M1073 626 515 626 3 nfet_01v8 L=1.5e-07 W=1.5e-06 $X=42900 $Y=21470 $dt=15
M1074 627 516 627 3 nfet_01v8 L=1.5e-07 W=1.5e-06 $X=42900 $Y=29750 $dt=15
M1075 628 517 628 3 nfet_01v8 L=1.5e-07 W=1.5e-06 $X=42900 $Y=38030 $dt=15
M1076 629 518 629 3 nfet_01v8 L=1.5e-07 W=1.5e-06 $X=42900 $Y=46310 $dt=15
M1077 630 519 630 3 nfet_01v8 L=1.5e-07 W=1.5e-06 $X=42900 $Y=54590 $dt=15
M1078 631 520 631 3 nfet_01v8 L=1.5e-07 W=1.5e-06 $X=42900 $Y=62870 $dt=15
M1079 632 526 632 3 nfet_01v8 L=1.5e-07 W=1.5e-06 $X=42900 $Y=112550 $dt=15
M1080 633 527 633 3 nfet_01v8 L=1.5e-07 W=1.5e-06 $X=42900 $Y=120830 $dt=15
M1081 634 528 634 3 nfet_01v8 L=1.5e-07 W=1.5e-06 $X=42900 $Y=129110 $dt=15
M1082 635 529 635 3 nfet_01v8 L=1.5e-07 W=1.5e-06 $X=42900 $Y=137390 $dt=15
M1083 636 530 636 3 nfet_01v8 L=1.5e-07 W=1.5e-06 $X=42900 $Y=145670 $dt=15
M1084 637 531 637 3 nfet_01v8 L=1.5e-07 W=1.5e-06 $X=42900 $Y=153950 $dt=15
M1085 638 532 638 3 nfet_01v8 L=1.5e-07 W=1.5e-06 $X=42900 $Y=162230 $dt=15
M1086 3 1 3 3 nfet_01v8 L=5.8e-07 W=1.5e-06 $X=48590 $Y=71150 $dt=15
M1087 3 1 3 3 nfet_01v8 L=5.8e-07 W=1.5e-06 $X=48590 $Y=79430 $dt=15
M1088 3 1 3 3 nfet_01v8 L=5.8e-07 W=1.5e-06 $X=48590 $Y=87710 $dt=15
M1089 3 1 3 3 nfet_01v8 L=5.8e-07 W=1.5e-06 $X=48590 $Y=95990 $dt=15
M1090 3 1 3 3 nfet_01v8 L=5.8e-07 W=1.5e-06 $X=48590 $Y=104270 $dt=15
M1091 625 495 309 3 nfet_01v8 L=1.5e-07 W=1.5e-06 $X=48600 $Y=13190 $dt=15
M1092 626 496 309 3 nfet_01v8 L=1.5e-07 W=1.5e-06 $X=48600 $Y=21470 $dt=15
M1093 627 497 309 3 nfet_01v8 L=1.5e-07 W=1.5e-06 $X=48600 $Y=29750 $dt=15
M1094 628 498 309 3 nfet_01v8 L=1.5e-07 W=1.5e-06 $X=48600 $Y=38030 $dt=15
M1095 629 499 309 3 nfet_01v8 L=1.5e-07 W=1.5e-06 $X=48600 $Y=46310 $dt=15
M1096 630 500 309 3 nfet_01v8 L=1.5e-07 W=1.5e-06 $X=48600 $Y=54590 $dt=15
M1097 631 501 309 3 nfet_01v8 L=1.5e-07 W=1.5e-06 $X=48600 $Y=62870 $dt=15
M1098 632 507 309 3 nfet_01v8 L=1.5e-07 W=1.5e-06 $X=48600 $Y=112550 $dt=15
M1099 633 508 309 3 nfet_01v8 L=1.5e-07 W=1.5e-06 $X=48600 $Y=120830 $dt=15
M1100 634 509 309 3 nfet_01v8 L=1.5e-07 W=1.5e-06 $X=48600 $Y=129110 $dt=15
M1101 635 510 309 3 nfet_01v8 L=1.5e-07 W=1.5e-06 $X=48600 $Y=137390 $dt=15
M1102 636 511 309 3 nfet_01v8 L=1.5e-07 W=1.5e-06 $X=48600 $Y=145670 $dt=15
M1103 637 512 309 3 nfet_01v8 L=1.5e-07 W=1.5e-06 $X=48600 $Y=153950 $dt=15
M1104 638 513 309 3 nfet_01v8 L=1.5e-07 W=1.5e-06 $X=48600 $Y=162230 $dt=15
M1105 308 458 625 3 nfet_01v8 L=1.5e-07 W=1.5e-06 $X=49030 $Y=13190 $dt=15
M1106 308 460 626 3 nfet_01v8 L=1.5e-07 W=1.5e-06 $X=49030 $Y=21470 $dt=15
M1107 308 462 627 3 nfet_01v8 L=1.5e-07 W=1.5e-06 $X=49030 $Y=29750 $dt=15
M1108 308 464 628 3 nfet_01v8 L=1.5e-07 W=1.5e-06 $X=49030 $Y=38030 $dt=15
M1109 308 466 629 3 nfet_01v8 L=1.5e-07 W=1.5e-06 $X=49030 $Y=46310 $dt=15
M1110 308 468 630 3 nfet_01v8 L=1.5e-07 W=1.5e-06 $X=49030 $Y=54590 $dt=15
M1111 308 470 631 3 nfet_01v8 L=1.5e-07 W=1.5e-06 $X=49030 $Y=62870 $dt=15
M1112 308 482 632 3 nfet_01v8 L=1.5e-07 W=1.5e-06 $X=49030 $Y=112550 $dt=15
M1113 308 484 633 3 nfet_01v8 L=1.5e-07 W=1.5e-06 $X=49030 $Y=120830 $dt=15
M1114 308 486 634 3 nfet_01v8 L=1.5e-07 W=1.5e-06 $X=49030 $Y=129110 $dt=15
M1115 308 488 635 3 nfet_01v8 L=1.5e-07 W=1.5e-06 $X=49030 $Y=137390 $dt=15
M1116 308 490 636 3 nfet_01v8 L=1.5e-07 W=1.5e-06 $X=49030 $Y=145670 $dt=15
M1117 308 492 637 3 nfet_01v8 L=1.5e-07 W=1.5e-06 $X=49030 $Y=153950 $dt=15
M1118 308 494 638 3 nfet_01v8 L=1.5e-07 W=1.5e-06 $X=49030 $Y=162230 $dt=15
M1119 607 534 324 3 nfet_01v8 L=1.5e-07 W=1.5e-06 $X=50750 $Y=13190 $dt=15
M1120 608 536 324 3 nfet_01v8 L=1.5e-07 W=1.5e-06 $X=50750 $Y=21470 $dt=15
M1121 609 538 324 3 nfet_01v8 L=1.5e-07 W=1.5e-06 $X=50750 $Y=29750 $dt=15
M1122 610 540 324 3 nfet_01v8 L=1.5e-07 W=1.5e-06 $X=50750 $Y=38030 $dt=15
M1123 611 542 324 3 nfet_01v8 L=1.5e-07 W=1.5e-06 $X=50750 $Y=46310 $dt=15
M1124 612 544 324 3 nfet_01v8 L=1.5e-07 W=1.5e-06 $X=50750 $Y=54590 $dt=15
M1125 613 546 324 3 nfet_01v8 L=1.5e-07 W=1.5e-06 $X=50750 $Y=62870 $dt=15
M1126 614 548 324 3 nfet_01v8 L=1.5e-07 W=1.5e-06 $X=50750 $Y=71150 $dt=15
M1127 615 550 324 3 nfet_01v8 L=1.5e-07 W=1.5e-06 $X=50750 $Y=79430 $dt=15
M1128 3 1 3 3 nfet_01v8 L=5.8e-07 W=1.5e-06 $X=50750 $Y=87710 $dt=15
M1129 616 554 324 3 nfet_01v8 L=1.5e-07 W=1.5e-06 $X=50750 $Y=95990 $dt=15
M1130 617 556 324 3 nfet_01v8 L=1.5e-07 W=1.5e-06 $X=50750 $Y=104270 $dt=15
M1131 618 558 324 3 nfet_01v8 L=1.5e-07 W=1.5e-06 $X=50750 $Y=112550 $dt=15
M1132 619 560 324 3 nfet_01v8 L=1.5e-07 W=1.5e-06 $X=50750 $Y=120830 $dt=15
M1133 620 562 324 3 nfet_01v8 L=1.5e-07 W=1.5e-06 $X=50750 $Y=129110 $dt=15
M1134 621 564 324 3 nfet_01v8 L=1.5e-07 W=1.5e-06 $X=50750 $Y=137390 $dt=15
M1135 622 566 324 3 nfet_01v8 L=1.5e-07 W=1.5e-06 $X=50750 $Y=145670 $dt=15
M1136 623 568 324 3 nfet_01v8 L=1.5e-07 W=1.5e-06 $X=50750 $Y=153950 $dt=15
M1137 624 570 324 3 nfet_01v8 L=1.5e-07 W=1.5e-06 $X=50750 $Y=162230 $dt=15
M1138 607 514 607 3 nfet_01v8 L=1.5e-07 W=1.5e-06 $X=51180 $Y=13190 $dt=15
M1139 608 515 608 3 nfet_01v8 L=1.5e-07 W=1.5e-06 $X=51180 $Y=21470 $dt=15
M1140 609 516 609 3 nfet_01v8 L=1.5e-07 W=1.5e-06 $X=51180 $Y=29750 $dt=15
M1141 610 517 610 3 nfet_01v8 L=1.5e-07 W=1.5e-06 $X=51180 $Y=38030 $dt=15
M1142 611 518 611 3 nfet_01v8 L=1.5e-07 W=1.5e-06 $X=51180 $Y=46310 $dt=15
M1143 612 519 612 3 nfet_01v8 L=1.5e-07 W=1.5e-06 $X=51180 $Y=54590 $dt=15
M1144 613 520 613 3 nfet_01v8 L=1.5e-07 W=1.5e-06 $X=51180 $Y=62870 $dt=15
M1145 614 521 614 3 nfet_01v8 L=1.5e-07 W=1.5e-06 $X=51180 $Y=71150 $dt=15
M1146 615 522 615 3 nfet_01v8 L=1.5e-07 W=1.5e-06 $X=51180 $Y=79430 $dt=15
M1147 616 524 616 3 nfet_01v8 L=1.5e-07 W=1.5e-06 $X=51180 $Y=95990 $dt=15
M1148 617 525 617 3 nfet_01v8 L=1.5e-07 W=1.5e-06 $X=51180 $Y=104270 $dt=15
M1149 618 526 618 3 nfet_01v8 L=1.5e-07 W=1.5e-06 $X=51180 $Y=112550 $dt=15
M1150 619 527 619 3 nfet_01v8 L=1.5e-07 W=1.5e-06 $X=51180 $Y=120830 $dt=15
M1151 620 528 620 3 nfet_01v8 L=1.5e-07 W=1.5e-06 $X=51180 $Y=129110 $dt=15
M1152 621 529 621 3 nfet_01v8 L=1.5e-07 W=1.5e-06 $X=51180 $Y=137390 $dt=15
M1153 622 530 622 3 nfet_01v8 L=1.5e-07 W=1.5e-06 $X=51180 $Y=145670 $dt=15
M1154 623 531 623 3 nfet_01v8 L=1.5e-07 W=1.5e-06 $X=51180 $Y=153950 $dt=15
M1155 624 532 624 3 nfet_01v8 L=1.5e-07 W=1.5e-06 $X=51180 $Y=162230 $dt=15
M1156 3 1 3 3 nfet_01v8 L=5.8e-07 W=1.5e-06 $X=56870 $Y=87710 $dt=15
M1157 607 495 309 3 nfet_01v8 L=1.5e-07 W=1.5e-06 $X=56880 $Y=13190 $dt=15
M1158 608 496 309 3 nfet_01v8 L=1.5e-07 W=1.5e-06 $X=56880 $Y=21470 $dt=15
M1159 609 497 309 3 nfet_01v8 L=1.5e-07 W=1.5e-06 $X=56880 $Y=29750 $dt=15
M1160 610 498 309 3 nfet_01v8 L=1.5e-07 W=1.5e-06 $X=56880 $Y=38030 $dt=15
M1161 611 499 309 3 nfet_01v8 L=1.5e-07 W=1.5e-06 $X=56880 $Y=46310 $dt=15
M1162 612 500 309 3 nfet_01v8 L=1.5e-07 W=1.5e-06 $X=56880 $Y=54590 $dt=15
M1163 613 501 309 3 nfet_01v8 L=1.5e-07 W=1.5e-06 $X=56880 $Y=62870 $dt=15
M1164 614 502 309 3 nfet_01v8 L=1.5e-07 W=1.5e-06 $X=56880 $Y=71150 $dt=15
M1165 615 503 309 3 nfet_01v8 L=1.5e-07 W=1.5e-06 $X=56880 $Y=79430 $dt=15
M1166 616 505 309 3 nfet_01v8 L=1.5e-07 W=1.5e-06 $X=56880 $Y=95990 $dt=15
M1167 617 506 309 3 nfet_01v8 L=1.5e-07 W=1.5e-06 $X=56880 $Y=104270 $dt=15
M1168 618 507 309 3 nfet_01v8 L=1.5e-07 W=1.5e-06 $X=56880 $Y=112550 $dt=15
M1169 619 508 309 3 nfet_01v8 L=1.5e-07 W=1.5e-06 $X=56880 $Y=120830 $dt=15
M1170 620 509 309 3 nfet_01v8 L=1.5e-07 W=1.5e-06 $X=56880 $Y=129110 $dt=15
M1171 621 510 309 3 nfet_01v8 L=1.5e-07 W=1.5e-06 $X=56880 $Y=137390 $dt=15
M1172 622 511 309 3 nfet_01v8 L=1.5e-07 W=1.5e-06 $X=56880 $Y=145670 $dt=15
M1173 623 512 309 3 nfet_01v8 L=1.5e-07 W=1.5e-06 $X=56880 $Y=153950 $dt=15
M1174 624 513 309 3 nfet_01v8 L=1.5e-07 W=1.5e-06 $X=56880 $Y=162230 $dt=15
M1175 308 458 607 3 nfet_01v8 L=1.5e-07 W=1.5e-06 $X=57310 $Y=13190 $dt=15
M1176 308 460 608 3 nfet_01v8 L=1.5e-07 W=1.5e-06 $X=57310 $Y=21470 $dt=15
M1177 308 462 609 3 nfet_01v8 L=1.5e-07 W=1.5e-06 $X=57310 $Y=29750 $dt=15
M1178 308 464 610 3 nfet_01v8 L=1.5e-07 W=1.5e-06 $X=57310 $Y=38030 $dt=15
M1179 308 466 611 3 nfet_01v8 L=1.5e-07 W=1.5e-06 $X=57310 $Y=46310 $dt=15
M1180 308 468 612 3 nfet_01v8 L=1.5e-07 W=1.5e-06 $X=57310 $Y=54590 $dt=15
M1181 308 470 613 3 nfet_01v8 L=1.5e-07 W=1.5e-06 $X=57310 $Y=62870 $dt=15
M1182 308 472 614 3 nfet_01v8 L=1.5e-07 W=1.5e-06 $X=57310 $Y=71150 $dt=15
M1183 308 474 615 3 nfet_01v8 L=1.5e-07 W=1.5e-06 $X=57310 $Y=79430 $dt=15
M1184 308 478 616 3 nfet_01v8 L=1.5e-07 W=1.5e-06 $X=57310 $Y=95990 $dt=15
M1185 308 480 617 3 nfet_01v8 L=1.5e-07 W=1.5e-06 $X=57310 $Y=104270 $dt=15
M1186 308 482 618 3 nfet_01v8 L=1.5e-07 W=1.5e-06 $X=57310 $Y=112550 $dt=15
M1187 308 484 619 3 nfet_01v8 L=1.5e-07 W=1.5e-06 $X=57310 $Y=120830 $dt=15
M1188 308 486 620 3 nfet_01v8 L=1.5e-07 W=1.5e-06 $X=57310 $Y=129110 $dt=15
M1189 308 488 621 3 nfet_01v8 L=1.5e-07 W=1.5e-06 $X=57310 $Y=137390 $dt=15
M1190 308 490 622 3 nfet_01v8 L=1.5e-07 W=1.5e-06 $X=57310 $Y=145670 $dt=15
M1191 308 492 623 3 nfet_01v8 L=1.5e-07 W=1.5e-06 $X=57310 $Y=153950 $dt=15
M1192 308 494 624 3 nfet_01v8 L=1.5e-07 W=1.5e-06 $X=57310 $Y=162230 $dt=15
M1193 589 534 324 3 nfet_01v8 L=1.5e-07 W=1.5e-06 $X=59030 $Y=13190 $dt=15
M1194 590 536 324 3 nfet_01v8 L=1.5e-07 W=1.5e-06 $X=59030 $Y=21470 $dt=15
M1195 591 538 324 3 nfet_01v8 L=1.5e-07 W=1.5e-06 $X=59030 $Y=29750 $dt=15
M1196 592 540 324 3 nfet_01v8 L=1.5e-07 W=1.5e-06 $X=59030 $Y=38030 $dt=15
M1197 593 542 324 3 nfet_01v8 L=1.5e-07 W=1.5e-06 $X=59030 $Y=46310 $dt=15
M1198 594 544 324 3 nfet_01v8 L=1.5e-07 W=1.5e-06 $X=59030 $Y=54590 $dt=15
M1199 595 546 324 3 nfet_01v8 L=1.5e-07 W=1.5e-06 $X=59030 $Y=62870 $dt=15
M1200 596 548 324 3 nfet_01v8 L=1.5e-07 W=1.5e-06 $X=59030 $Y=71150 $dt=15
M1201 597 550 324 3 nfet_01v8 L=1.5e-07 W=1.5e-06 $X=59030 $Y=79430 $dt=15
M1202 3 1 3 3 nfet_01v8 L=5.8e-07 W=1.5e-06 $X=59030 $Y=87710 $dt=15
M1203 598 554 324 3 nfet_01v8 L=1.5e-07 W=1.5e-06 $X=59030 $Y=95990 $dt=15
M1204 599 556 324 3 nfet_01v8 L=1.5e-07 W=1.5e-06 $X=59030 $Y=104270 $dt=15
M1205 600 558 324 3 nfet_01v8 L=1.5e-07 W=1.5e-06 $X=59030 $Y=112550 $dt=15
M1206 601 560 324 3 nfet_01v8 L=1.5e-07 W=1.5e-06 $X=59030 $Y=120830 $dt=15
M1207 602 562 324 3 nfet_01v8 L=1.5e-07 W=1.5e-06 $X=59030 $Y=129110 $dt=15
M1208 603 564 324 3 nfet_01v8 L=1.5e-07 W=1.5e-06 $X=59030 $Y=137390 $dt=15
M1209 604 566 324 3 nfet_01v8 L=1.5e-07 W=1.5e-06 $X=59030 $Y=145670 $dt=15
M1210 605 568 324 3 nfet_01v8 L=1.5e-07 W=1.5e-06 $X=59030 $Y=153950 $dt=15
M1211 606 570 324 3 nfet_01v8 L=1.5e-07 W=1.5e-06 $X=59030 $Y=162230 $dt=15
M1212 589 514 589 3 nfet_01v8 L=1.5e-07 W=1.5e-06 $X=59460 $Y=13190 $dt=15
M1213 590 515 590 3 nfet_01v8 L=1.5e-07 W=1.5e-06 $X=59460 $Y=21470 $dt=15
M1214 591 516 591 3 nfet_01v8 L=1.5e-07 W=1.5e-06 $X=59460 $Y=29750 $dt=15
M1215 592 517 592 3 nfet_01v8 L=1.5e-07 W=1.5e-06 $X=59460 $Y=38030 $dt=15
M1216 593 518 593 3 nfet_01v8 L=1.5e-07 W=1.5e-06 $X=59460 $Y=46310 $dt=15
M1217 594 519 594 3 nfet_01v8 L=1.5e-07 W=1.5e-06 $X=59460 $Y=54590 $dt=15
M1218 595 520 595 3 nfet_01v8 L=1.5e-07 W=1.5e-06 $X=59460 $Y=62870 $dt=15
M1219 596 521 596 3 nfet_01v8 L=1.5e-07 W=1.5e-06 $X=59460 $Y=71150 $dt=15
M1220 597 522 597 3 nfet_01v8 L=1.5e-07 W=1.5e-06 $X=59460 $Y=79430 $dt=15
M1221 598 524 598 3 nfet_01v8 L=1.5e-07 W=1.5e-06 $X=59460 $Y=95990 $dt=15
M1222 599 525 599 3 nfet_01v8 L=1.5e-07 W=1.5e-06 $X=59460 $Y=104270 $dt=15
M1223 600 526 600 3 nfet_01v8 L=1.5e-07 W=1.5e-06 $X=59460 $Y=112550 $dt=15
M1224 601 527 601 3 nfet_01v8 L=1.5e-07 W=1.5e-06 $X=59460 $Y=120830 $dt=15
M1225 602 528 602 3 nfet_01v8 L=1.5e-07 W=1.5e-06 $X=59460 $Y=129110 $dt=15
M1226 603 529 603 3 nfet_01v8 L=1.5e-07 W=1.5e-06 $X=59460 $Y=137390 $dt=15
M1227 604 530 604 3 nfet_01v8 L=1.5e-07 W=1.5e-06 $X=59460 $Y=145670 $dt=15
M1228 605 531 605 3 nfet_01v8 L=1.5e-07 W=1.5e-06 $X=59460 $Y=153950 $dt=15
M1229 606 532 606 3 nfet_01v8 L=1.5e-07 W=1.5e-06 $X=59460 $Y=162230 $dt=15
M1230 3 1 3 3 nfet_01v8 L=5.8e-07 W=1.5e-06 $X=65150 $Y=87710 $dt=15
M1231 589 495 309 3 nfet_01v8 L=1.5e-07 W=1.5e-06 $X=65160 $Y=13190 $dt=15
M1232 590 496 309 3 nfet_01v8 L=1.5e-07 W=1.5e-06 $X=65160 $Y=21470 $dt=15
M1233 591 497 309 3 nfet_01v8 L=1.5e-07 W=1.5e-06 $X=65160 $Y=29750 $dt=15
M1234 592 498 309 3 nfet_01v8 L=1.5e-07 W=1.5e-06 $X=65160 $Y=38030 $dt=15
M1235 593 499 309 3 nfet_01v8 L=1.5e-07 W=1.5e-06 $X=65160 $Y=46310 $dt=15
M1236 594 500 309 3 nfet_01v8 L=1.5e-07 W=1.5e-06 $X=65160 $Y=54590 $dt=15
M1237 595 501 309 3 nfet_01v8 L=1.5e-07 W=1.5e-06 $X=65160 $Y=62870 $dt=15
M1238 596 502 309 3 nfet_01v8 L=1.5e-07 W=1.5e-06 $X=65160 $Y=71150 $dt=15
M1239 597 503 309 3 nfet_01v8 L=1.5e-07 W=1.5e-06 $X=65160 $Y=79430 $dt=15
M1240 598 505 309 3 nfet_01v8 L=1.5e-07 W=1.5e-06 $X=65160 $Y=95990 $dt=15
M1241 599 506 309 3 nfet_01v8 L=1.5e-07 W=1.5e-06 $X=65160 $Y=104270 $dt=15
M1242 600 507 309 3 nfet_01v8 L=1.5e-07 W=1.5e-06 $X=65160 $Y=112550 $dt=15
M1243 601 508 309 3 nfet_01v8 L=1.5e-07 W=1.5e-06 $X=65160 $Y=120830 $dt=15
M1244 602 509 309 3 nfet_01v8 L=1.5e-07 W=1.5e-06 $X=65160 $Y=129110 $dt=15
M1245 603 510 309 3 nfet_01v8 L=1.5e-07 W=1.5e-06 $X=65160 $Y=137390 $dt=15
M1246 604 511 309 3 nfet_01v8 L=1.5e-07 W=1.5e-06 $X=65160 $Y=145670 $dt=15
M1247 605 512 309 3 nfet_01v8 L=1.5e-07 W=1.5e-06 $X=65160 $Y=153950 $dt=15
M1248 606 513 309 3 nfet_01v8 L=1.5e-07 W=1.5e-06 $X=65160 $Y=162230 $dt=15
M1249 308 458 589 3 nfet_01v8 L=1.5e-07 W=1.5e-06 $X=65590 $Y=13190 $dt=15
M1250 308 460 590 3 nfet_01v8 L=1.5e-07 W=1.5e-06 $X=65590 $Y=21470 $dt=15
M1251 308 462 591 3 nfet_01v8 L=1.5e-07 W=1.5e-06 $X=65590 $Y=29750 $dt=15
M1252 308 464 592 3 nfet_01v8 L=1.5e-07 W=1.5e-06 $X=65590 $Y=38030 $dt=15
M1253 308 466 593 3 nfet_01v8 L=1.5e-07 W=1.5e-06 $X=65590 $Y=46310 $dt=15
M1254 308 468 594 3 nfet_01v8 L=1.5e-07 W=1.5e-06 $X=65590 $Y=54590 $dt=15
M1255 308 470 595 3 nfet_01v8 L=1.5e-07 W=1.5e-06 $X=65590 $Y=62870 $dt=15
M1256 308 472 596 3 nfet_01v8 L=1.5e-07 W=1.5e-06 $X=65590 $Y=71150 $dt=15
M1257 308 474 597 3 nfet_01v8 L=1.5e-07 W=1.5e-06 $X=65590 $Y=79430 $dt=15
M1258 308 478 598 3 nfet_01v8 L=1.5e-07 W=1.5e-06 $X=65590 $Y=95990 $dt=15
M1259 308 480 599 3 nfet_01v8 L=1.5e-07 W=1.5e-06 $X=65590 $Y=104270 $dt=15
M1260 308 482 600 3 nfet_01v8 L=1.5e-07 W=1.5e-06 $X=65590 $Y=112550 $dt=15
M1261 308 484 601 3 nfet_01v8 L=1.5e-07 W=1.5e-06 $X=65590 $Y=120830 $dt=15
M1262 308 486 602 3 nfet_01v8 L=1.5e-07 W=1.5e-06 $X=65590 $Y=129110 $dt=15
M1263 308 488 603 3 nfet_01v8 L=1.5e-07 W=1.5e-06 $X=65590 $Y=137390 $dt=15
M1264 308 490 604 3 nfet_01v8 L=1.5e-07 W=1.5e-06 $X=65590 $Y=145670 $dt=15
M1265 308 492 605 3 nfet_01v8 L=1.5e-07 W=1.5e-06 $X=65590 $Y=153950 $dt=15
M1266 308 494 606 3 nfet_01v8 L=1.5e-07 W=1.5e-06 $X=65590 $Y=162230 $dt=15
M1267 571 534 324 3 nfet_01v8 L=1.5e-07 W=1.5e-06 $X=67310 $Y=13190 $dt=15
M1268 572 536 324 3 nfet_01v8 L=1.5e-07 W=1.5e-06 $X=67310 $Y=21470 $dt=15
M1269 573 538 324 3 nfet_01v8 L=1.5e-07 W=1.5e-06 $X=67310 $Y=29750 $dt=15
M1270 574 540 324 3 nfet_01v8 L=1.5e-07 W=1.5e-06 $X=67310 $Y=38030 $dt=15
M1271 575 542 324 3 nfet_01v8 L=1.5e-07 W=1.5e-06 $X=67310 $Y=46310 $dt=15
M1272 576 544 324 3 nfet_01v8 L=1.5e-07 W=1.5e-06 $X=67310 $Y=54590 $dt=15
M1273 577 546 324 3 nfet_01v8 L=1.5e-07 W=1.5e-06 $X=67310 $Y=62870 $dt=15
M1274 578 548 324 3 nfet_01v8 L=1.5e-07 W=1.5e-06 $X=67310 $Y=71150 $dt=15
M1275 579 550 324 3 nfet_01v8 L=1.5e-07 W=1.5e-06 $X=67310 $Y=79430 $dt=15
M1276 3 1 3 3 nfet_01v8 L=5.8e-07 W=1.5e-06 $X=67310 $Y=87710 $dt=15
M1277 580 554 324 3 nfet_01v8 L=1.5e-07 W=1.5e-06 $X=67310 $Y=95990 $dt=15
M1278 581 556 324 3 nfet_01v8 L=1.5e-07 W=1.5e-06 $X=67310 $Y=104270 $dt=15
M1279 582 558 324 3 nfet_01v8 L=1.5e-07 W=1.5e-06 $X=67310 $Y=112550 $dt=15
M1280 583 560 324 3 nfet_01v8 L=1.5e-07 W=1.5e-06 $X=67310 $Y=120830 $dt=15
M1281 584 562 324 3 nfet_01v8 L=1.5e-07 W=1.5e-06 $X=67310 $Y=129110 $dt=15
M1282 585 564 324 3 nfet_01v8 L=1.5e-07 W=1.5e-06 $X=67310 $Y=137390 $dt=15
M1283 586 566 324 3 nfet_01v8 L=1.5e-07 W=1.5e-06 $X=67310 $Y=145670 $dt=15
M1284 587 568 324 3 nfet_01v8 L=1.5e-07 W=1.5e-06 $X=67310 $Y=153950 $dt=15
M1285 588 570 324 3 nfet_01v8 L=1.5e-07 W=1.5e-06 $X=67310 $Y=162230 $dt=15
M1286 571 514 571 3 nfet_01v8 L=1.5e-07 W=1.5e-06 $X=67740 $Y=13190 $dt=15
M1287 572 515 572 3 nfet_01v8 L=1.5e-07 W=1.5e-06 $X=67740 $Y=21470 $dt=15
M1288 573 516 573 3 nfet_01v8 L=1.5e-07 W=1.5e-06 $X=67740 $Y=29750 $dt=15
M1289 574 517 574 3 nfet_01v8 L=1.5e-07 W=1.5e-06 $X=67740 $Y=38030 $dt=15
M1290 575 518 575 3 nfet_01v8 L=1.5e-07 W=1.5e-06 $X=67740 $Y=46310 $dt=15
M1291 576 519 576 3 nfet_01v8 L=1.5e-07 W=1.5e-06 $X=67740 $Y=54590 $dt=15
M1292 577 520 577 3 nfet_01v8 L=1.5e-07 W=1.5e-06 $X=67740 $Y=62870 $dt=15
M1293 578 521 578 3 nfet_01v8 L=1.5e-07 W=1.5e-06 $X=67740 $Y=71150 $dt=15
M1294 579 522 579 3 nfet_01v8 L=1.5e-07 W=1.5e-06 $X=67740 $Y=79430 $dt=15
M1295 580 524 580 3 nfet_01v8 L=1.5e-07 W=1.5e-06 $X=67740 $Y=95990 $dt=15
M1296 581 525 581 3 nfet_01v8 L=1.5e-07 W=1.5e-06 $X=67740 $Y=104270 $dt=15
M1297 582 526 582 3 nfet_01v8 L=1.5e-07 W=1.5e-06 $X=67740 $Y=112550 $dt=15
M1298 583 527 583 3 nfet_01v8 L=1.5e-07 W=1.5e-06 $X=67740 $Y=120830 $dt=15
M1299 584 528 584 3 nfet_01v8 L=1.5e-07 W=1.5e-06 $X=67740 $Y=129110 $dt=15
M1300 585 529 585 3 nfet_01v8 L=1.5e-07 W=1.5e-06 $X=67740 $Y=137390 $dt=15
M1301 586 530 586 3 nfet_01v8 L=1.5e-07 W=1.5e-06 $X=67740 $Y=145670 $dt=15
M1302 587 531 587 3 nfet_01v8 L=1.5e-07 W=1.5e-06 $X=67740 $Y=153950 $dt=15
M1303 588 532 588 3 nfet_01v8 L=1.5e-07 W=1.5e-06 $X=67740 $Y=162230 $dt=15
M1304 3 1 3 3 nfet_01v8 L=5.8e-07 W=1.5e-06 $X=73430 $Y=87710 $dt=15
M1305 571 495 309 3 nfet_01v8 L=1.5e-07 W=1.5e-06 $X=73440 $Y=13190 $dt=15
M1306 572 496 309 3 nfet_01v8 L=1.5e-07 W=1.5e-06 $X=73440 $Y=21470 $dt=15
M1307 573 497 309 3 nfet_01v8 L=1.5e-07 W=1.5e-06 $X=73440 $Y=29750 $dt=15
M1308 574 498 309 3 nfet_01v8 L=1.5e-07 W=1.5e-06 $X=73440 $Y=38030 $dt=15
M1309 575 499 309 3 nfet_01v8 L=1.5e-07 W=1.5e-06 $X=73440 $Y=46310 $dt=15
M1310 576 500 309 3 nfet_01v8 L=1.5e-07 W=1.5e-06 $X=73440 $Y=54590 $dt=15
M1311 577 501 309 3 nfet_01v8 L=1.5e-07 W=1.5e-06 $X=73440 $Y=62870 $dt=15
M1312 578 502 309 3 nfet_01v8 L=1.5e-07 W=1.5e-06 $X=73440 $Y=71150 $dt=15
M1313 579 503 309 3 nfet_01v8 L=1.5e-07 W=1.5e-06 $X=73440 $Y=79430 $dt=15
M1314 580 505 309 3 nfet_01v8 L=1.5e-07 W=1.5e-06 $X=73440 $Y=95990 $dt=15
M1315 581 506 309 3 nfet_01v8 L=1.5e-07 W=1.5e-06 $X=73440 $Y=104270 $dt=15
M1316 582 507 309 3 nfet_01v8 L=1.5e-07 W=1.5e-06 $X=73440 $Y=112550 $dt=15
M1317 583 508 309 3 nfet_01v8 L=1.5e-07 W=1.5e-06 $X=73440 $Y=120830 $dt=15
M1318 584 509 309 3 nfet_01v8 L=1.5e-07 W=1.5e-06 $X=73440 $Y=129110 $dt=15
M1319 585 510 309 3 nfet_01v8 L=1.5e-07 W=1.5e-06 $X=73440 $Y=137390 $dt=15
M1320 586 511 309 3 nfet_01v8 L=1.5e-07 W=1.5e-06 $X=73440 $Y=145670 $dt=15
M1321 587 512 309 3 nfet_01v8 L=1.5e-07 W=1.5e-06 $X=73440 $Y=153950 $dt=15
M1322 588 513 309 3 nfet_01v8 L=1.5e-07 W=1.5e-06 $X=73440 $Y=162230 $dt=15
M1323 308 458 571 3 nfet_01v8 L=1.5e-07 W=1.5e-06 $X=73870 $Y=13190 $dt=15
M1324 308 460 572 3 nfet_01v8 L=1.5e-07 W=1.5e-06 $X=73870 $Y=21470 $dt=15
M1325 308 462 573 3 nfet_01v8 L=1.5e-07 W=1.5e-06 $X=73870 $Y=29750 $dt=15
M1326 308 464 574 3 nfet_01v8 L=1.5e-07 W=1.5e-06 $X=73870 $Y=38030 $dt=15
M1327 308 466 575 3 nfet_01v8 L=1.5e-07 W=1.5e-06 $X=73870 $Y=46310 $dt=15
M1328 308 468 576 3 nfet_01v8 L=1.5e-07 W=1.5e-06 $X=73870 $Y=54590 $dt=15
M1329 308 470 577 3 nfet_01v8 L=1.5e-07 W=1.5e-06 $X=73870 $Y=62870 $dt=15
M1330 308 472 578 3 nfet_01v8 L=1.5e-07 W=1.5e-06 $X=73870 $Y=71150 $dt=15
M1331 308 474 579 3 nfet_01v8 L=1.5e-07 W=1.5e-06 $X=73870 $Y=79430 $dt=15
M1332 308 478 580 3 nfet_01v8 L=1.5e-07 W=1.5e-06 $X=73870 $Y=95990 $dt=15
M1333 308 480 581 3 nfet_01v8 L=1.5e-07 W=1.5e-06 $X=73870 $Y=104270 $dt=15
M1334 308 482 582 3 nfet_01v8 L=1.5e-07 W=1.5e-06 $X=73870 $Y=112550 $dt=15
M1335 308 484 583 3 nfet_01v8 L=1.5e-07 W=1.5e-06 $X=73870 $Y=120830 $dt=15
M1336 308 486 584 3 nfet_01v8 L=1.5e-07 W=1.5e-06 $X=73870 $Y=129110 $dt=15
M1337 308 488 585 3 nfet_01v8 L=1.5e-07 W=1.5e-06 $X=73870 $Y=137390 $dt=15
M1338 308 490 586 3 nfet_01v8 L=1.5e-07 W=1.5e-06 $X=73870 $Y=145670 $dt=15
M1339 308 492 587 3 nfet_01v8 L=1.5e-07 W=1.5e-06 $X=73870 $Y=153950 $dt=15
M1340 308 494 588 3 nfet_01v8 L=1.5e-07 W=1.5e-06 $X=73870 $Y=162230 $dt=15
M1341 438 534 324 3 nfet_01v8 L=1.5e-07 W=1.5e-06 $X=75590 $Y=13190 $dt=15
M1342 439 536 324 3 nfet_01v8 L=1.5e-07 W=1.5e-06 $X=75590 $Y=21470 $dt=15
M1343 440 538 324 3 nfet_01v8 L=1.5e-07 W=1.5e-06 $X=75590 $Y=29750 $dt=15
M1344 441 540 324 3 nfet_01v8 L=1.5e-07 W=1.5e-06 $X=75590 $Y=38030 $dt=15
M1345 442 542 324 3 nfet_01v8 L=1.5e-07 W=1.5e-06 $X=75590 $Y=46310 $dt=15
M1346 443 544 324 3 nfet_01v8 L=1.5e-07 W=1.5e-06 $X=75590 $Y=54590 $dt=15
M1347 444 546 324 3 nfet_01v8 L=1.5e-07 W=1.5e-06 $X=75590 $Y=62870 $dt=15
M1348 445 548 324 3 nfet_01v8 L=1.5e-07 W=1.5e-06 $X=75590 $Y=71150 $dt=15
M1349 446 550 324 3 nfet_01v8 L=1.5e-07 W=1.5e-06 $X=75590 $Y=79430 $dt=15
M1350 447 552 324 3 nfet_01v8 L=1.5e-07 W=1.5e-06 $X=75590 $Y=87710 $dt=15
M1351 448 554 324 3 nfet_01v8 L=1.5e-07 W=1.5e-06 $X=75590 $Y=95990 $dt=15
M1352 449 556 324 3 nfet_01v8 L=1.5e-07 W=1.5e-06 $X=75590 $Y=104270 $dt=15
M1353 450 558 324 3 nfet_01v8 L=1.5e-07 W=1.5e-06 $X=75590 $Y=112550 $dt=15
M1354 451 560 324 3 nfet_01v8 L=1.5e-07 W=1.5e-06 $X=75590 $Y=120830 $dt=15
M1355 452 562 324 3 nfet_01v8 L=1.5e-07 W=1.5e-06 $X=75590 $Y=129110 $dt=15
M1356 453 564 324 3 nfet_01v8 L=1.5e-07 W=1.5e-06 $X=75590 $Y=137390 $dt=15
M1357 454 566 324 3 nfet_01v8 L=1.5e-07 W=1.5e-06 $X=75590 $Y=145670 $dt=15
M1358 455 568 324 3 nfet_01v8 L=1.5e-07 W=1.5e-06 $X=75590 $Y=153950 $dt=15
M1359 456 570 324 3 nfet_01v8 L=1.5e-07 W=1.5e-06 $X=75590 $Y=162230 $dt=15
M1360 438 514 438 3 nfet_01v8 L=1.5e-07 W=1.5e-06 $X=76020 $Y=13190 $dt=15
M1361 439 515 439 3 nfet_01v8 L=1.5e-07 W=1.5e-06 $X=76020 $Y=21470 $dt=15
M1362 440 516 440 3 nfet_01v8 L=1.5e-07 W=1.5e-06 $X=76020 $Y=29750 $dt=15
M1363 441 517 441 3 nfet_01v8 L=1.5e-07 W=1.5e-06 $X=76020 $Y=38030 $dt=15
M1364 442 518 442 3 nfet_01v8 L=1.5e-07 W=1.5e-06 $X=76020 $Y=46310 $dt=15
M1365 443 519 443 3 nfet_01v8 L=1.5e-07 W=1.5e-06 $X=76020 $Y=54590 $dt=15
M1366 444 520 444 3 nfet_01v8 L=1.5e-07 W=1.5e-06 $X=76020 $Y=62870 $dt=15
M1367 445 521 445 3 nfet_01v8 L=1.5e-07 W=1.5e-06 $X=76020 $Y=71150 $dt=15
M1368 446 522 446 3 nfet_01v8 L=1.5e-07 W=1.5e-06 $X=76020 $Y=79430 $dt=15
M1369 447 523 447 3 nfet_01v8 L=1.5e-07 W=1.5e-06 $X=76020 $Y=87710 $dt=15
M1370 448 524 448 3 nfet_01v8 L=1.5e-07 W=1.5e-06 $X=76020 $Y=95990 $dt=15
M1371 449 525 449 3 nfet_01v8 L=1.5e-07 W=1.5e-06 $X=76020 $Y=104270 $dt=15
M1372 450 526 450 3 nfet_01v8 L=1.5e-07 W=1.5e-06 $X=76020 $Y=112550 $dt=15
M1373 451 527 451 3 nfet_01v8 L=1.5e-07 W=1.5e-06 $X=76020 $Y=120830 $dt=15
M1374 452 528 452 3 nfet_01v8 L=1.5e-07 W=1.5e-06 $X=76020 $Y=129110 $dt=15
M1375 453 529 453 3 nfet_01v8 L=1.5e-07 W=1.5e-06 $X=76020 $Y=137390 $dt=15
M1376 454 530 454 3 nfet_01v8 L=1.5e-07 W=1.5e-06 $X=76020 $Y=145670 $dt=15
M1377 455 531 455 3 nfet_01v8 L=1.5e-07 W=1.5e-06 $X=76020 $Y=153950 $dt=15
M1378 456 532 456 3 nfet_01v8 L=1.5e-07 W=1.5e-06 $X=76020 $Y=162230 $dt=15
M1379 438 495 309 3 nfet_01v8 L=1.5e-07 W=1.5e-06 $X=81720 $Y=13190 $dt=15
M1380 439 496 309 3 nfet_01v8 L=1.5e-07 W=1.5e-06 $X=81720 $Y=21470 $dt=15
M1381 440 497 309 3 nfet_01v8 L=1.5e-07 W=1.5e-06 $X=81720 $Y=29750 $dt=15
M1382 441 498 309 3 nfet_01v8 L=1.5e-07 W=1.5e-06 $X=81720 $Y=38030 $dt=15
M1383 442 499 309 3 nfet_01v8 L=1.5e-07 W=1.5e-06 $X=81720 $Y=46310 $dt=15
M1384 443 500 309 3 nfet_01v8 L=1.5e-07 W=1.5e-06 $X=81720 $Y=54590 $dt=15
M1385 444 501 309 3 nfet_01v8 L=1.5e-07 W=1.5e-06 $X=81720 $Y=62870 $dt=15
M1386 445 502 309 3 nfet_01v8 L=1.5e-07 W=1.5e-06 $X=81720 $Y=71150 $dt=15
M1387 446 503 309 3 nfet_01v8 L=1.5e-07 W=1.5e-06 $X=81720 $Y=79430 $dt=15
M1388 447 504 309 3 nfet_01v8 L=1.5e-07 W=1.5e-06 $X=81720 $Y=87710 $dt=15
M1389 448 505 309 3 nfet_01v8 L=1.5e-07 W=1.5e-06 $X=81720 $Y=95990 $dt=15
M1390 449 506 309 3 nfet_01v8 L=1.5e-07 W=1.5e-06 $X=81720 $Y=104270 $dt=15
M1391 450 507 309 3 nfet_01v8 L=1.5e-07 W=1.5e-06 $X=81720 $Y=112550 $dt=15
M1392 451 508 309 3 nfet_01v8 L=1.5e-07 W=1.5e-06 $X=81720 $Y=120830 $dt=15
M1393 452 509 309 3 nfet_01v8 L=1.5e-07 W=1.5e-06 $X=81720 $Y=129110 $dt=15
M1394 453 510 309 3 nfet_01v8 L=1.5e-07 W=1.5e-06 $X=81720 $Y=137390 $dt=15
M1395 454 511 309 3 nfet_01v8 L=1.5e-07 W=1.5e-06 $X=81720 $Y=145670 $dt=15
M1396 455 512 309 3 nfet_01v8 L=1.5e-07 W=1.5e-06 $X=81720 $Y=153950 $dt=15
M1397 456 513 309 3 nfet_01v8 L=1.5e-07 W=1.5e-06 $X=81720 $Y=162230 $dt=15
M1398 308 458 438 3 nfet_01v8 L=1.5e-07 W=1.5e-06 $X=82150 $Y=13190 $dt=15
M1399 308 460 439 3 nfet_01v8 L=1.5e-07 W=1.5e-06 $X=82150 $Y=21470 $dt=15
M1400 308 462 440 3 nfet_01v8 L=1.5e-07 W=1.5e-06 $X=82150 $Y=29750 $dt=15
M1401 308 464 441 3 nfet_01v8 L=1.5e-07 W=1.5e-06 $X=82150 $Y=38030 $dt=15
M1402 308 466 442 3 nfet_01v8 L=1.5e-07 W=1.5e-06 $X=82150 $Y=46310 $dt=15
M1403 308 468 443 3 nfet_01v8 L=1.5e-07 W=1.5e-06 $X=82150 $Y=54590 $dt=15
M1404 308 470 444 3 nfet_01v8 L=1.5e-07 W=1.5e-06 $X=82150 $Y=62870 $dt=15
M1405 308 472 445 3 nfet_01v8 L=1.5e-07 W=1.5e-06 $X=82150 $Y=71150 $dt=15
M1406 308 474 446 3 nfet_01v8 L=1.5e-07 W=1.5e-06 $X=82150 $Y=79430 $dt=15
M1407 308 476 447 3 nfet_01v8 L=1.5e-07 W=1.5e-06 $X=82150 $Y=87710 $dt=15
M1408 308 478 448 3 nfet_01v8 L=1.5e-07 W=1.5e-06 $X=82150 $Y=95990 $dt=15
M1409 308 480 449 3 nfet_01v8 L=1.5e-07 W=1.5e-06 $X=82150 $Y=104270 $dt=15
M1410 308 482 450 3 nfet_01v8 L=1.5e-07 W=1.5e-06 $X=82150 $Y=112550 $dt=15
M1411 308 484 451 3 nfet_01v8 L=1.5e-07 W=1.5e-06 $X=82150 $Y=120830 $dt=15
M1412 308 486 452 3 nfet_01v8 L=1.5e-07 W=1.5e-06 $X=82150 $Y=129110 $dt=15
M1413 308 488 453 3 nfet_01v8 L=1.5e-07 W=1.5e-06 $X=82150 $Y=137390 $dt=15
M1414 308 490 454 3 nfet_01v8 L=1.5e-07 W=1.5e-06 $X=82150 $Y=145670 $dt=15
M1415 308 492 455 3 nfet_01v8 L=1.5e-07 W=1.5e-06 $X=82150 $Y=153950 $dt=15
M1416 308 494 456 3 nfet_01v8 L=1.5e-07 W=1.5e-06 $X=82150 $Y=162230 $dt=15
M1417 419 156 324 3 nfet_01v8 L=1.5e-07 W=1.5e-06 $X=83870 $Y=13190 $dt=15
M1418 420 157 324 3 nfet_01v8 L=1.5e-07 W=1.5e-06 $X=83870 $Y=21470 $dt=15
M1419 421 158 324 3 nfet_01v8 L=1.5e-07 W=1.5e-06 $X=83870 $Y=29750 $dt=15
M1420 422 159 324 3 nfet_01v8 L=1.5e-07 W=1.5e-06 $X=83870 $Y=38030 $dt=15
M1421 423 160 324 3 nfet_01v8 L=1.5e-07 W=1.5e-06 $X=83870 $Y=46310 $dt=15
M1422 424 161 324 3 nfet_01v8 L=1.5e-07 W=1.5e-06 $X=83870 $Y=54590 $dt=15
M1423 425 162 324 3 nfet_01v8 L=1.5e-07 W=1.5e-06 $X=83870 $Y=62870 $dt=15
M1424 426 163 324 3 nfet_01v8 L=1.5e-07 W=1.5e-06 $X=83870 $Y=71150 $dt=15
M1425 427 164 324 3 nfet_01v8 L=1.5e-07 W=1.5e-06 $X=83870 $Y=79430 $dt=15
M1426 428 165 324 3 nfet_01v8 L=1.5e-07 W=1.5e-06 $X=83870 $Y=87710 $dt=15
M1427 429 166 324 3 nfet_01v8 L=1.5e-07 W=1.5e-06 $X=83870 $Y=95990 $dt=15
M1428 430 167 324 3 nfet_01v8 L=1.5e-07 W=1.5e-06 $X=83870 $Y=104270 $dt=15
M1429 431 168 324 3 nfet_01v8 L=1.5e-07 W=1.5e-06 $X=83870 $Y=112550 $dt=15
M1430 432 169 324 3 nfet_01v8 L=1.5e-07 W=1.5e-06 $X=83870 $Y=120830 $dt=15
M1431 433 170 324 3 nfet_01v8 L=1.5e-07 W=1.5e-06 $X=83870 $Y=129110 $dt=15
M1432 434 171 324 3 nfet_01v8 L=1.5e-07 W=1.5e-06 $X=83870 $Y=137390 $dt=15
M1433 435 172 324 3 nfet_01v8 L=1.5e-07 W=1.5e-06 $X=83870 $Y=145670 $dt=15
M1434 436 173 324 3 nfet_01v8 L=1.5e-07 W=1.5e-06 $X=83870 $Y=153950 $dt=15
M1435 437 174 324 3 nfet_01v8 L=1.5e-07 W=1.5e-06 $X=83870 $Y=162230 $dt=15
M1436 419 289 419 3 nfet_01v8 L=1.5e-07 W=1.5e-06 $X=84300 $Y=13190 $dt=15
M1437 420 290 420 3 nfet_01v8 L=1.5e-07 W=1.5e-06 $X=84300 $Y=21470 $dt=15
M1438 421 291 421 3 nfet_01v8 L=1.5e-07 W=1.5e-06 $X=84300 $Y=29750 $dt=15
M1439 422 292 422 3 nfet_01v8 L=1.5e-07 W=1.5e-06 $X=84300 $Y=38030 $dt=15
M1440 423 293 423 3 nfet_01v8 L=1.5e-07 W=1.5e-06 $X=84300 $Y=46310 $dt=15
M1441 424 294 424 3 nfet_01v8 L=1.5e-07 W=1.5e-06 $X=84300 $Y=54590 $dt=15
M1442 425 295 425 3 nfet_01v8 L=1.5e-07 W=1.5e-06 $X=84300 $Y=62870 $dt=15
M1443 426 296 426 3 nfet_01v8 L=1.5e-07 W=1.5e-06 $X=84300 $Y=71150 $dt=15
M1444 427 297 427 3 nfet_01v8 L=1.5e-07 W=1.5e-06 $X=84300 $Y=79430 $dt=15
M1445 428 298 428 3 nfet_01v8 L=1.5e-07 W=1.5e-06 $X=84300 $Y=87710 $dt=15
M1446 429 299 429 3 nfet_01v8 L=1.5e-07 W=1.5e-06 $X=84300 $Y=95990 $dt=15
M1447 430 300 430 3 nfet_01v8 L=1.5e-07 W=1.5e-06 $X=84300 $Y=104270 $dt=15
M1448 431 301 431 3 nfet_01v8 L=1.5e-07 W=1.5e-06 $X=84300 $Y=112550 $dt=15
M1449 432 302 432 3 nfet_01v8 L=1.5e-07 W=1.5e-06 $X=84300 $Y=120830 $dt=15
M1450 433 303 433 3 nfet_01v8 L=1.5e-07 W=1.5e-06 $X=84300 $Y=129110 $dt=15
M1451 434 304 434 3 nfet_01v8 L=1.5e-07 W=1.5e-06 $X=84300 $Y=137390 $dt=15
M1452 435 305 435 3 nfet_01v8 L=1.5e-07 W=1.5e-06 $X=84300 $Y=145670 $dt=15
M1453 436 306 436 3 nfet_01v8 L=1.5e-07 W=1.5e-06 $X=84300 $Y=153950 $dt=15
M1454 437 307 437 3 nfet_01v8 L=1.5e-07 W=1.5e-06 $X=84300 $Y=162230 $dt=15
M1455 419 270 309 3 nfet_01v8 L=1.5e-07 W=1.5e-06 $X=90000 $Y=13190 $dt=15
M1456 420 271 309 3 nfet_01v8 L=1.5e-07 W=1.5e-06 $X=90000 $Y=21470 $dt=15
M1457 421 272 309 3 nfet_01v8 L=1.5e-07 W=1.5e-06 $X=90000 $Y=29750 $dt=15
M1458 422 273 309 3 nfet_01v8 L=1.5e-07 W=1.5e-06 $X=90000 $Y=38030 $dt=15
M1459 423 274 309 3 nfet_01v8 L=1.5e-07 W=1.5e-06 $X=90000 $Y=46310 $dt=15
M1460 424 275 309 3 nfet_01v8 L=1.5e-07 W=1.5e-06 $X=90000 $Y=54590 $dt=15
M1461 425 276 309 3 nfet_01v8 L=1.5e-07 W=1.5e-06 $X=90000 $Y=62870 $dt=15
M1462 426 277 309 3 nfet_01v8 L=1.5e-07 W=1.5e-06 $X=90000 $Y=71150 $dt=15
M1463 427 278 309 3 nfet_01v8 L=1.5e-07 W=1.5e-06 $X=90000 $Y=79430 $dt=15
M1464 428 279 309 3 nfet_01v8 L=1.5e-07 W=1.5e-06 $X=90000 $Y=87710 $dt=15
M1465 429 280 309 3 nfet_01v8 L=1.5e-07 W=1.5e-06 $X=90000 $Y=95990 $dt=15
M1466 430 281 309 3 nfet_01v8 L=1.5e-07 W=1.5e-06 $X=90000 $Y=104270 $dt=15
M1467 431 282 309 3 nfet_01v8 L=1.5e-07 W=1.5e-06 $X=90000 $Y=112550 $dt=15
M1468 432 283 309 3 nfet_01v8 L=1.5e-07 W=1.5e-06 $X=90000 $Y=120830 $dt=15
M1469 433 284 309 3 nfet_01v8 L=1.5e-07 W=1.5e-06 $X=90000 $Y=129110 $dt=15
M1470 434 285 309 3 nfet_01v8 L=1.5e-07 W=1.5e-06 $X=90000 $Y=137390 $dt=15
M1471 435 286 309 3 nfet_01v8 L=1.5e-07 W=1.5e-06 $X=90000 $Y=145670 $dt=15
M1472 436 287 309 3 nfet_01v8 L=1.5e-07 W=1.5e-06 $X=90000 $Y=153950 $dt=15
M1473 437 288 309 3 nfet_01v8 L=1.5e-07 W=1.5e-06 $X=90000 $Y=162230 $dt=15
M1474 308 232 419 3 nfet_01v8 L=1.5e-07 W=1.5e-06 $X=90430 $Y=13190 $dt=15
M1475 308 233 420 3 nfet_01v8 L=1.5e-07 W=1.5e-06 $X=90430 $Y=21470 $dt=15
M1476 308 234 421 3 nfet_01v8 L=1.5e-07 W=1.5e-06 $X=90430 $Y=29750 $dt=15
M1477 308 235 422 3 nfet_01v8 L=1.5e-07 W=1.5e-06 $X=90430 $Y=38030 $dt=15
M1478 308 236 423 3 nfet_01v8 L=1.5e-07 W=1.5e-06 $X=90430 $Y=46310 $dt=15
M1479 308 237 424 3 nfet_01v8 L=1.5e-07 W=1.5e-06 $X=90430 $Y=54590 $dt=15
M1480 308 238 425 3 nfet_01v8 L=1.5e-07 W=1.5e-06 $X=90430 $Y=62870 $dt=15
M1481 308 239 426 3 nfet_01v8 L=1.5e-07 W=1.5e-06 $X=90430 $Y=71150 $dt=15
M1482 308 240 427 3 nfet_01v8 L=1.5e-07 W=1.5e-06 $X=90430 $Y=79430 $dt=15
M1483 308 241 428 3 nfet_01v8 L=1.5e-07 W=1.5e-06 $X=90430 $Y=87710 $dt=15
M1484 308 242 429 3 nfet_01v8 L=1.5e-07 W=1.5e-06 $X=90430 $Y=95990 $dt=15
M1485 308 243 430 3 nfet_01v8 L=1.5e-07 W=1.5e-06 $X=90430 $Y=104270 $dt=15
M1486 308 244 431 3 nfet_01v8 L=1.5e-07 W=1.5e-06 $X=90430 $Y=112550 $dt=15
M1487 308 245 432 3 nfet_01v8 L=1.5e-07 W=1.5e-06 $X=90430 $Y=120830 $dt=15
M1488 308 246 433 3 nfet_01v8 L=1.5e-07 W=1.5e-06 $X=90430 $Y=129110 $dt=15
M1489 308 247 434 3 nfet_01v8 L=1.5e-07 W=1.5e-06 $X=90430 $Y=137390 $dt=15
M1490 308 248 435 3 nfet_01v8 L=1.5e-07 W=1.5e-06 $X=90430 $Y=145670 $dt=15
M1491 308 249 436 3 nfet_01v8 L=1.5e-07 W=1.5e-06 $X=90430 $Y=153950 $dt=15
M1492 308 250 437 3 nfet_01v8 L=1.5e-07 W=1.5e-06 $X=90430 $Y=162230 $dt=15
M1493 401 156 324 3 nfet_01v8 L=1.5e-07 W=1.5e-06 $X=92150 $Y=13190 $dt=15
M1494 402 157 324 3 nfet_01v8 L=1.5e-07 W=1.5e-06 $X=92150 $Y=21470 $dt=15
M1495 403 158 324 3 nfet_01v8 L=1.5e-07 W=1.5e-06 $X=92150 $Y=29750 $dt=15
M1496 404 159 324 3 nfet_01v8 L=1.5e-07 W=1.5e-06 $X=92150 $Y=38030 $dt=15
M1497 405 160 324 3 nfet_01v8 L=1.5e-07 W=1.5e-06 $X=92150 $Y=46310 $dt=15
M1498 406 161 324 3 nfet_01v8 L=1.5e-07 W=1.5e-06 $X=92150 $Y=54590 $dt=15
M1499 407 162 324 3 nfet_01v8 L=1.5e-07 W=1.5e-06 $X=92150 $Y=62870 $dt=15
M1500 408 163 324 3 nfet_01v8 L=1.5e-07 W=1.5e-06 $X=92150 $Y=71150 $dt=15
M1501 409 164 324 3 nfet_01v8 L=1.5e-07 W=1.5e-06 $X=92150 $Y=79430 $dt=15
M1502 3 1 3 3 nfet_01v8 L=5.8e-07 W=1.5e-06 $X=92150 $Y=87710 $dt=15
M1503 410 166 324 3 nfet_01v8 L=1.5e-07 W=1.5e-06 $X=92150 $Y=95990 $dt=15
M1504 411 167 324 3 nfet_01v8 L=1.5e-07 W=1.5e-06 $X=92150 $Y=104270 $dt=15
M1505 412 168 324 3 nfet_01v8 L=1.5e-07 W=1.5e-06 $X=92150 $Y=112550 $dt=15
M1506 413 169 324 3 nfet_01v8 L=1.5e-07 W=1.5e-06 $X=92150 $Y=120830 $dt=15
M1507 414 170 324 3 nfet_01v8 L=1.5e-07 W=1.5e-06 $X=92150 $Y=129110 $dt=15
M1508 415 171 324 3 nfet_01v8 L=1.5e-07 W=1.5e-06 $X=92150 $Y=137390 $dt=15
M1509 416 172 324 3 nfet_01v8 L=1.5e-07 W=1.5e-06 $X=92150 $Y=145670 $dt=15
M1510 417 173 324 3 nfet_01v8 L=1.5e-07 W=1.5e-06 $X=92150 $Y=153950 $dt=15
M1511 418 174 324 3 nfet_01v8 L=1.5e-07 W=1.5e-06 $X=92150 $Y=162230 $dt=15
M1512 401 289 401 3 nfet_01v8 L=1.5e-07 W=1.5e-06 $X=92580 $Y=13190 $dt=15
M1513 402 290 402 3 nfet_01v8 L=1.5e-07 W=1.5e-06 $X=92580 $Y=21470 $dt=15
M1514 403 291 403 3 nfet_01v8 L=1.5e-07 W=1.5e-06 $X=92580 $Y=29750 $dt=15
M1515 404 292 404 3 nfet_01v8 L=1.5e-07 W=1.5e-06 $X=92580 $Y=38030 $dt=15
M1516 405 293 405 3 nfet_01v8 L=1.5e-07 W=1.5e-06 $X=92580 $Y=46310 $dt=15
M1517 406 294 406 3 nfet_01v8 L=1.5e-07 W=1.5e-06 $X=92580 $Y=54590 $dt=15
M1518 407 295 407 3 nfet_01v8 L=1.5e-07 W=1.5e-06 $X=92580 $Y=62870 $dt=15
M1519 408 296 408 3 nfet_01v8 L=1.5e-07 W=1.5e-06 $X=92580 $Y=71150 $dt=15
M1520 409 297 409 3 nfet_01v8 L=1.5e-07 W=1.5e-06 $X=92580 $Y=79430 $dt=15
M1521 410 299 410 3 nfet_01v8 L=1.5e-07 W=1.5e-06 $X=92580 $Y=95990 $dt=15
M1522 411 300 411 3 nfet_01v8 L=1.5e-07 W=1.5e-06 $X=92580 $Y=104270 $dt=15
M1523 412 301 412 3 nfet_01v8 L=1.5e-07 W=1.5e-06 $X=92580 $Y=112550 $dt=15
M1524 413 302 413 3 nfet_01v8 L=1.5e-07 W=1.5e-06 $X=92580 $Y=120830 $dt=15
M1525 414 303 414 3 nfet_01v8 L=1.5e-07 W=1.5e-06 $X=92580 $Y=129110 $dt=15
M1526 415 304 415 3 nfet_01v8 L=1.5e-07 W=1.5e-06 $X=92580 $Y=137390 $dt=15
M1527 416 305 416 3 nfet_01v8 L=1.5e-07 W=1.5e-06 $X=92580 $Y=145670 $dt=15
M1528 417 306 417 3 nfet_01v8 L=1.5e-07 W=1.5e-06 $X=92580 $Y=153950 $dt=15
M1529 418 307 418 3 nfet_01v8 L=1.5e-07 W=1.5e-06 $X=92580 $Y=162230 $dt=15
M1530 3 1 3 3 nfet_01v8 L=5.8e-07 W=1.5e-06 $X=98270 $Y=87710 $dt=15
M1531 401 270 309 3 nfet_01v8 L=1.5e-07 W=1.5e-06 $X=98280 $Y=13190 $dt=15
M1532 402 271 309 3 nfet_01v8 L=1.5e-07 W=1.5e-06 $X=98280 $Y=21470 $dt=15
M1533 403 272 309 3 nfet_01v8 L=1.5e-07 W=1.5e-06 $X=98280 $Y=29750 $dt=15
M1534 404 273 309 3 nfet_01v8 L=1.5e-07 W=1.5e-06 $X=98280 $Y=38030 $dt=15
M1535 405 274 309 3 nfet_01v8 L=1.5e-07 W=1.5e-06 $X=98280 $Y=46310 $dt=15
M1536 406 275 309 3 nfet_01v8 L=1.5e-07 W=1.5e-06 $X=98280 $Y=54590 $dt=15
M1537 407 276 309 3 nfet_01v8 L=1.5e-07 W=1.5e-06 $X=98280 $Y=62870 $dt=15
M1538 408 277 309 3 nfet_01v8 L=1.5e-07 W=1.5e-06 $X=98280 $Y=71150 $dt=15
M1539 409 278 309 3 nfet_01v8 L=1.5e-07 W=1.5e-06 $X=98280 $Y=79430 $dt=15
M1540 410 280 309 3 nfet_01v8 L=1.5e-07 W=1.5e-06 $X=98280 $Y=95990 $dt=15
M1541 411 281 309 3 nfet_01v8 L=1.5e-07 W=1.5e-06 $X=98280 $Y=104270 $dt=15
M1542 412 282 309 3 nfet_01v8 L=1.5e-07 W=1.5e-06 $X=98280 $Y=112550 $dt=15
M1543 413 283 309 3 nfet_01v8 L=1.5e-07 W=1.5e-06 $X=98280 $Y=120830 $dt=15
M1544 414 284 309 3 nfet_01v8 L=1.5e-07 W=1.5e-06 $X=98280 $Y=129110 $dt=15
M1545 415 285 309 3 nfet_01v8 L=1.5e-07 W=1.5e-06 $X=98280 $Y=137390 $dt=15
M1546 416 286 309 3 nfet_01v8 L=1.5e-07 W=1.5e-06 $X=98280 $Y=145670 $dt=15
M1547 417 287 309 3 nfet_01v8 L=1.5e-07 W=1.5e-06 $X=98280 $Y=153950 $dt=15
M1548 418 288 309 3 nfet_01v8 L=1.5e-07 W=1.5e-06 $X=98280 $Y=162230 $dt=15
M1549 308 232 401 3 nfet_01v8 L=1.5e-07 W=1.5e-06 $X=98710 $Y=13190 $dt=15
M1550 308 233 402 3 nfet_01v8 L=1.5e-07 W=1.5e-06 $X=98710 $Y=21470 $dt=15
M1551 308 234 403 3 nfet_01v8 L=1.5e-07 W=1.5e-06 $X=98710 $Y=29750 $dt=15
M1552 308 235 404 3 nfet_01v8 L=1.5e-07 W=1.5e-06 $X=98710 $Y=38030 $dt=15
M1553 308 236 405 3 nfet_01v8 L=1.5e-07 W=1.5e-06 $X=98710 $Y=46310 $dt=15
M1554 308 237 406 3 nfet_01v8 L=1.5e-07 W=1.5e-06 $X=98710 $Y=54590 $dt=15
M1555 308 238 407 3 nfet_01v8 L=1.5e-07 W=1.5e-06 $X=98710 $Y=62870 $dt=15
M1556 308 239 408 3 nfet_01v8 L=1.5e-07 W=1.5e-06 $X=98710 $Y=71150 $dt=15
M1557 308 240 409 3 nfet_01v8 L=1.5e-07 W=1.5e-06 $X=98710 $Y=79430 $dt=15
M1558 308 242 410 3 nfet_01v8 L=1.5e-07 W=1.5e-06 $X=98710 $Y=95990 $dt=15
M1559 308 243 411 3 nfet_01v8 L=1.5e-07 W=1.5e-06 $X=98710 $Y=104270 $dt=15
M1560 308 244 412 3 nfet_01v8 L=1.5e-07 W=1.5e-06 $X=98710 $Y=112550 $dt=15
M1561 308 245 413 3 nfet_01v8 L=1.5e-07 W=1.5e-06 $X=98710 $Y=120830 $dt=15
M1562 308 246 414 3 nfet_01v8 L=1.5e-07 W=1.5e-06 $X=98710 $Y=129110 $dt=15
M1563 308 247 415 3 nfet_01v8 L=1.5e-07 W=1.5e-06 $X=98710 $Y=137390 $dt=15
M1564 308 248 416 3 nfet_01v8 L=1.5e-07 W=1.5e-06 $X=98710 $Y=145670 $dt=15
M1565 308 249 417 3 nfet_01v8 L=1.5e-07 W=1.5e-06 $X=98710 $Y=153950 $dt=15
M1566 308 250 418 3 nfet_01v8 L=1.5e-07 W=1.5e-06 $X=98710 $Y=162230 $dt=15
M1567 384 156 324 3 nfet_01v8 L=1.5e-07 W=1.5e-06 $X=100430 $Y=13190 $dt=15
M1568 385 157 324 3 nfet_01v8 L=1.5e-07 W=1.5e-06 $X=100430 $Y=21470 $dt=15
M1569 386 158 324 3 nfet_01v8 L=1.5e-07 W=1.5e-06 $X=100430 $Y=29750 $dt=15
M1570 387 159 324 3 nfet_01v8 L=1.5e-07 W=1.5e-06 $X=100430 $Y=38030 $dt=15
M1571 388 160 324 3 nfet_01v8 L=1.5e-07 W=1.5e-06 $X=100430 $Y=46310 $dt=15
M1572 389 161 324 3 nfet_01v8 L=1.5e-07 W=1.5e-06 $X=100430 $Y=54590 $dt=15
M1573 390 162 324 3 nfet_01v8 L=1.5e-07 W=1.5e-06 $X=100430 $Y=62870 $dt=15
M1574 391 163 324 3 nfet_01v8 L=1.5e-07 W=1.5e-06 $X=100430 $Y=71150 $dt=15
M1575 392 164 324 3 nfet_01v8 L=1.5e-07 W=1.5e-06 $X=100430 $Y=79430 $dt=15
M1576 3 1 3 3 nfet_01v8 L=5.8e-07 W=1.5e-06 $X=100430 $Y=87710 $dt=15
M1577 3 1 3 3 nfet_01v8 L=5.8e-07 W=1.5e-06 $X=100430 $Y=95990 $dt=15
M1578 393 167 324 3 nfet_01v8 L=1.5e-07 W=1.5e-06 $X=100430 $Y=104270 $dt=15
M1579 394 168 324 3 nfet_01v8 L=1.5e-07 W=1.5e-06 $X=100430 $Y=112550 $dt=15
M1580 395 169 324 3 nfet_01v8 L=1.5e-07 W=1.5e-06 $X=100430 $Y=120830 $dt=15
M1581 396 170 324 3 nfet_01v8 L=1.5e-07 W=1.5e-06 $X=100430 $Y=129110 $dt=15
M1582 397 171 324 3 nfet_01v8 L=1.5e-07 W=1.5e-06 $X=100430 $Y=137390 $dt=15
M1583 398 172 324 3 nfet_01v8 L=1.5e-07 W=1.5e-06 $X=100430 $Y=145670 $dt=15
M1584 399 173 324 3 nfet_01v8 L=1.5e-07 W=1.5e-06 $X=100430 $Y=153950 $dt=15
M1585 400 174 324 3 nfet_01v8 L=1.5e-07 W=1.5e-06 $X=100430 $Y=162230 $dt=15
M1586 384 289 384 3 nfet_01v8 L=1.5e-07 W=1.5e-06 $X=100860 $Y=13190 $dt=15
M1587 385 290 385 3 nfet_01v8 L=1.5e-07 W=1.5e-06 $X=100860 $Y=21470 $dt=15
M1588 386 291 386 3 nfet_01v8 L=1.5e-07 W=1.5e-06 $X=100860 $Y=29750 $dt=15
M1589 387 292 387 3 nfet_01v8 L=1.5e-07 W=1.5e-06 $X=100860 $Y=38030 $dt=15
M1590 388 293 388 3 nfet_01v8 L=1.5e-07 W=1.5e-06 $X=100860 $Y=46310 $dt=15
M1591 389 294 389 3 nfet_01v8 L=1.5e-07 W=1.5e-06 $X=100860 $Y=54590 $dt=15
M1592 390 295 390 3 nfet_01v8 L=1.5e-07 W=1.5e-06 $X=100860 $Y=62870 $dt=15
M1593 391 296 391 3 nfet_01v8 L=1.5e-07 W=1.5e-06 $X=100860 $Y=71150 $dt=15
M1594 392 297 392 3 nfet_01v8 L=1.5e-07 W=1.5e-06 $X=100860 $Y=79430 $dt=15
M1595 393 300 393 3 nfet_01v8 L=1.5e-07 W=1.5e-06 $X=100860 $Y=104270 $dt=15
M1596 394 301 394 3 nfet_01v8 L=1.5e-07 W=1.5e-06 $X=100860 $Y=112550 $dt=15
M1597 395 302 395 3 nfet_01v8 L=1.5e-07 W=1.5e-06 $X=100860 $Y=120830 $dt=15
M1598 396 303 396 3 nfet_01v8 L=1.5e-07 W=1.5e-06 $X=100860 $Y=129110 $dt=15
M1599 397 304 397 3 nfet_01v8 L=1.5e-07 W=1.5e-06 $X=100860 $Y=137390 $dt=15
M1600 398 305 398 3 nfet_01v8 L=1.5e-07 W=1.5e-06 $X=100860 $Y=145670 $dt=15
M1601 399 306 399 3 nfet_01v8 L=1.5e-07 W=1.5e-06 $X=100860 $Y=153950 $dt=15
M1602 400 307 400 3 nfet_01v8 L=1.5e-07 W=1.5e-06 $X=100860 $Y=162230 $dt=15
M1603 3 1 3 3 nfet_01v8 L=5.8e-07 W=1.5e-06 $X=106550 $Y=87710 $dt=15
M1604 3 1 3 3 nfet_01v8 L=5.8e-07 W=1.5e-06 $X=106550 $Y=95990 $dt=15
M1605 384 270 309 3 nfet_01v8 L=1.5e-07 W=1.5e-06 $X=106560 $Y=13190 $dt=15
M1606 385 271 309 3 nfet_01v8 L=1.5e-07 W=1.5e-06 $X=106560 $Y=21470 $dt=15
M1607 386 272 309 3 nfet_01v8 L=1.5e-07 W=1.5e-06 $X=106560 $Y=29750 $dt=15
M1608 387 273 309 3 nfet_01v8 L=1.5e-07 W=1.5e-06 $X=106560 $Y=38030 $dt=15
M1609 388 274 309 3 nfet_01v8 L=1.5e-07 W=1.5e-06 $X=106560 $Y=46310 $dt=15
M1610 389 275 309 3 nfet_01v8 L=1.5e-07 W=1.5e-06 $X=106560 $Y=54590 $dt=15
M1611 390 276 309 3 nfet_01v8 L=1.5e-07 W=1.5e-06 $X=106560 $Y=62870 $dt=15
M1612 391 277 309 3 nfet_01v8 L=1.5e-07 W=1.5e-06 $X=106560 $Y=71150 $dt=15
M1613 392 278 309 3 nfet_01v8 L=1.5e-07 W=1.5e-06 $X=106560 $Y=79430 $dt=15
M1614 393 281 309 3 nfet_01v8 L=1.5e-07 W=1.5e-06 $X=106560 $Y=104270 $dt=15
M1615 394 282 309 3 nfet_01v8 L=1.5e-07 W=1.5e-06 $X=106560 $Y=112550 $dt=15
M1616 395 283 309 3 nfet_01v8 L=1.5e-07 W=1.5e-06 $X=106560 $Y=120830 $dt=15
M1617 396 284 309 3 nfet_01v8 L=1.5e-07 W=1.5e-06 $X=106560 $Y=129110 $dt=15
M1618 397 285 309 3 nfet_01v8 L=1.5e-07 W=1.5e-06 $X=106560 $Y=137390 $dt=15
M1619 398 286 309 3 nfet_01v8 L=1.5e-07 W=1.5e-06 $X=106560 $Y=145670 $dt=15
M1620 399 287 309 3 nfet_01v8 L=1.5e-07 W=1.5e-06 $X=106560 $Y=153950 $dt=15
M1621 400 288 309 3 nfet_01v8 L=1.5e-07 W=1.5e-06 $X=106560 $Y=162230 $dt=15
M1622 308 232 384 3 nfet_01v8 L=1.5e-07 W=1.5e-06 $X=106990 $Y=13190 $dt=15
M1623 308 233 385 3 nfet_01v8 L=1.5e-07 W=1.5e-06 $X=106990 $Y=21470 $dt=15
M1624 308 234 386 3 nfet_01v8 L=1.5e-07 W=1.5e-06 $X=106990 $Y=29750 $dt=15
M1625 308 235 387 3 nfet_01v8 L=1.5e-07 W=1.5e-06 $X=106990 $Y=38030 $dt=15
M1626 308 236 388 3 nfet_01v8 L=1.5e-07 W=1.5e-06 $X=106990 $Y=46310 $dt=15
M1627 308 237 389 3 nfet_01v8 L=1.5e-07 W=1.5e-06 $X=106990 $Y=54590 $dt=15
M1628 308 238 390 3 nfet_01v8 L=1.5e-07 W=1.5e-06 $X=106990 $Y=62870 $dt=15
M1629 308 239 391 3 nfet_01v8 L=1.5e-07 W=1.5e-06 $X=106990 $Y=71150 $dt=15
M1630 308 240 392 3 nfet_01v8 L=1.5e-07 W=1.5e-06 $X=106990 $Y=79430 $dt=15
M1631 308 243 393 3 nfet_01v8 L=1.5e-07 W=1.5e-06 $X=106990 $Y=104270 $dt=15
M1632 308 244 394 3 nfet_01v8 L=1.5e-07 W=1.5e-06 $X=106990 $Y=112550 $dt=15
M1633 308 245 395 3 nfet_01v8 L=1.5e-07 W=1.5e-06 $X=106990 $Y=120830 $dt=15
M1634 308 246 396 3 nfet_01v8 L=1.5e-07 W=1.5e-06 $X=106990 $Y=129110 $dt=15
M1635 308 247 397 3 nfet_01v8 L=1.5e-07 W=1.5e-06 $X=106990 $Y=137390 $dt=15
M1636 308 248 398 3 nfet_01v8 L=1.5e-07 W=1.5e-06 $X=106990 $Y=145670 $dt=15
M1637 308 249 399 3 nfet_01v8 L=1.5e-07 W=1.5e-06 $X=106990 $Y=153950 $dt=15
M1638 308 250 400 3 nfet_01v8 L=1.5e-07 W=1.5e-06 $X=106990 $Y=162230 $dt=15
M1639 367 156 324 3 nfet_01v8 L=1.5e-07 W=1.5e-06 $X=108710 $Y=13190 $dt=15
M1640 368 157 324 3 nfet_01v8 L=1.5e-07 W=1.5e-06 $X=108710 $Y=21470 $dt=15
M1641 369 158 324 3 nfet_01v8 L=1.5e-07 W=1.5e-06 $X=108710 $Y=29750 $dt=15
M1642 370 159 324 3 nfet_01v8 L=1.5e-07 W=1.5e-06 $X=108710 $Y=38030 $dt=15
M1643 371 160 324 3 nfet_01v8 L=1.5e-07 W=1.5e-06 $X=108710 $Y=46310 $dt=15
M1644 372 161 324 3 nfet_01v8 L=1.5e-07 W=1.5e-06 $X=108710 $Y=54590 $dt=15
M1645 373 162 324 3 nfet_01v8 L=1.5e-07 W=1.5e-06 $X=108710 $Y=62870 $dt=15
M1646 374 163 324 3 nfet_01v8 L=1.5e-07 W=1.5e-06 $X=108710 $Y=71150 $dt=15
M1647 375 164 324 3 nfet_01v8 L=1.5e-07 W=1.5e-06 $X=108710 $Y=79430 $dt=15
M1648 3 1 3 3 nfet_01v8 L=5.8e-07 W=1.5e-06 $X=108710 $Y=87710 $dt=15
M1649 3 1 3 3 nfet_01v8 L=5.8e-07 W=1.5e-06 $X=108710 $Y=95990 $dt=15
M1650 376 167 324 3 nfet_01v8 L=1.5e-07 W=1.5e-06 $X=108710 $Y=104270 $dt=15
M1651 377 168 324 3 nfet_01v8 L=1.5e-07 W=1.5e-06 $X=108710 $Y=112550 $dt=15
M1652 378 169 324 3 nfet_01v8 L=1.5e-07 W=1.5e-06 $X=108710 $Y=120830 $dt=15
M1653 379 170 324 3 nfet_01v8 L=1.5e-07 W=1.5e-06 $X=108710 $Y=129110 $dt=15
M1654 380 171 324 3 nfet_01v8 L=1.5e-07 W=1.5e-06 $X=108710 $Y=137390 $dt=15
M1655 381 172 324 3 nfet_01v8 L=1.5e-07 W=1.5e-06 $X=108710 $Y=145670 $dt=15
M1656 382 173 324 3 nfet_01v8 L=1.5e-07 W=1.5e-06 $X=108710 $Y=153950 $dt=15
M1657 383 174 324 3 nfet_01v8 L=1.5e-07 W=1.5e-06 $X=108710 $Y=162230 $dt=15
M1658 367 289 367 3 nfet_01v8 L=1.5e-07 W=1.5e-06 $X=109140 $Y=13190 $dt=15
M1659 368 290 368 3 nfet_01v8 L=1.5e-07 W=1.5e-06 $X=109140 $Y=21470 $dt=15
M1660 369 291 369 3 nfet_01v8 L=1.5e-07 W=1.5e-06 $X=109140 $Y=29750 $dt=15
M1661 370 292 370 3 nfet_01v8 L=1.5e-07 W=1.5e-06 $X=109140 $Y=38030 $dt=15
M1662 371 293 371 3 nfet_01v8 L=1.5e-07 W=1.5e-06 $X=109140 $Y=46310 $dt=15
M1663 372 294 372 3 nfet_01v8 L=1.5e-07 W=1.5e-06 $X=109140 $Y=54590 $dt=15
M1664 373 295 373 3 nfet_01v8 L=1.5e-07 W=1.5e-06 $X=109140 $Y=62870 $dt=15
M1665 374 296 374 3 nfet_01v8 L=1.5e-07 W=1.5e-06 $X=109140 $Y=71150 $dt=15
M1666 375 297 375 3 nfet_01v8 L=1.5e-07 W=1.5e-06 $X=109140 $Y=79430 $dt=15
M1667 376 300 376 3 nfet_01v8 L=1.5e-07 W=1.5e-06 $X=109140 $Y=104270 $dt=15
M1668 377 301 377 3 nfet_01v8 L=1.5e-07 W=1.5e-06 $X=109140 $Y=112550 $dt=15
M1669 378 302 378 3 nfet_01v8 L=1.5e-07 W=1.5e-06 $X=109140 $Y=120830 $dt=15
M1670 379 303 379 3 nfet_01v8 L=1.5e-07 W=1.5e-06 $X=109140 $Y=129110 $dt=15
M1671 380 304 380 3 nfet_01v8 L=1.5e-07 W=1.5e-06 $X=109140 $Y=137390 $dt=15
M1672 381 305 381 3 nfet_01v8 L=1.5e-07 W=1.5e-06 $X=109140 $Y=145670 $dt=15
M1673 382 306 382 3 nfet_01v8 L=1.5e-07 W=1.5e-06 $X=109140 $Y=153950 $dt=15
M1674 383 307 383 3 nfet_01v8 L=1.5e-07 W=1.5e-06 $X=109140 $Y=162230 $dt=15
M1675 3 1 3 3 nfet_01v8 L=5.8e-07 W=1.5e-06 $X=114830 $Y=87710 $dt=15
M1676 3 1 3 3 nfet_01v8 L=5.8e-07 W=1.5e-06 $X=114830 $Y=95990 $dt=15
M1677 367 270 309 3 nfet_01v8 L=1.5e-07 W=1.5e-06 $X=114840 $Y=13190 $dt=15
M1678 368 271 309 3 nfet_01v8 L=1.5e-07 W=1.5e-06 $X=114840 $Y=21470 $dt=15
M1679 369 272 309 3 nfet_01v8 L=1.5e-07 W=1.5e-06 $X=114840 $Y=29750 $dt=15
M1680 370 273 309 3 nfet_01v8 L=1.5e-07 W=1.5e-06 $X=114840 $Y=38030 $dt=15
M1681 371 274 309 3 nfet_01v8 L=1.5e-07 W=1.5e-06 $X=114840 $Y=46310 $dt=15
M1682 372 275 309 3 nfet_01v8 L=1.5e-07 W=1.5e-06 $X=114840 $Y=54590 $dt=15
M1683 373 276 309 3 nfet_01v8 L=1.5e-07 W=1.5e-06 $X=114840 $Y=62870 $dt=15
M1684 374 277 309 3 nfet_01v8 L=1.5e-07 W=1.5e-06 $X=114840 $Y=71150 $dt=15
M1685 375 278 309 3 nfet_01v8 L=1.5e-07 W=1.5e-06 $X=114840 $Y=79430 $dt=15
M1686 376 281 309 3 nfet_01v8 L=1.5e-07 W=1.5e-06 $X=114840 $Y=104270 $dt=15
M1687 377 282 309 3 nfet_01v8 L=1.5e-07 W=1.5e-06 $X=114840 $Y=112550 $dt=15
M1688 378 283 309 3 nfet_01v8 L=1.5e-07 W=1.5e-06 $X=114840 $Y=120830 $dt=15
M1689 379 284 309 3 nfet_01v8 L=1.5e-07 W=1.5e-06 $X=114840 $Y=129110 $dt=15
M1690 380 285 309 3 nfet_01v8 L=1.5e-07 W=1.5e-06 $X=114840 $Y=137390 $dt=15
M1691 381 286 309 3 nfet_01v8 L=1.5e-07 W=1.5e-06 $X=114840 $Y=145670 $dt=15
M1692 382 287 309 3 nfet_01v8 L=1.5e-07 W=1.5e-06 $X=114840 $Y=153950 $dt=15
M1693 383 288 309 3 nfet_01v8 L=1.5e-07 W=1.5e-06 $X=114840 $Y=162230 $dt=15
M1694 308 232 367 3 nfet_01v8 L=1.5e-07 W=1.5e-06 $X=115270 $Y=13190 $dt=15
M1695 308 233 368 3 nfet_01v8 L=1.5e-07 W=1.5e-06 $X=115270 $Y=21470 $dt=15
M1696 308 234 369 3 nfet_01v8 L=1.5e-07 W=1.5e-06 $X=115270 $Y=29750 $dt=15
M1697 308 235 370 3 nfet_01v8 L=1.5e-07 W=1.5e-06 $X=115270 $Y=38030 $dt=15
M1698 308 236 371 3 nfet_01v8 L=1.5e-07 W=1.5e-06 $X=115270 $Y=46310 $dt=15
M1699 308 237 372 3 nfet_01v8 L=1.5e-07 W=1.5e-06 $X=115270 $Y=54590 $dt=15
M1700 308 238 373 3 nfet_01v8 L=1.5e-07 W=1.5e-06 $X=115270 $Y=62870 $dt=15
M1701 308 239 374 3 nfet_01v8 L=1.5e-07 W=1.5e-06 $X=115270 $Y=71150 $dt=15
M1702 308 240 375 3 nfet_01v8 L=1.5e-07 W=1.5e-06 $X=115270 $Y=79430 $dt=15
M1703 308 243 376 3 nfet_01v8 L=1.5e-07 W=1.5e-06 $X=115270 $Y=104270 $dt=15
M1704 308 244 377 3 nfet_01v8 L=1.5e-07 W=1.5e-06 $X=115270 $Y=112550 $dt=15
M1705 308 245 378 3 nfet_01v8 L=1.5e-07 W=1.5e-06 $X=115270 $Y=120830 $dt=15
M1706 308 246 379 3 nfet_01v8 L=1.5e-07 W=1.5e-06 $X=115270 $Y=129110 $dt=15
M1707 308 247 380 3 nfet_01v8 L=1.5e-07 W=1.5e-06 $X=115270 $Y=137390 $dt=15
M1708 308 248 381 3 nfet_01v8 L=1.5e-07 W=1.5e-06 $X=115270 $Y=145670 $dt=15
M1709 308 249 382 3 nfet_01v8 L=1.5e-07 W=1.5e-06 $X=115270 $Y=153950 $dt=15
M1710 308 250 383 3 nfet_01v8 L=1.5e-07 W=1.5e-06 $X=115270 $Y=162230 $dt=15
M1711 353 156 324 3 nfet_01v8 L=1.5e-07 W=1.5e-06 $X=116990 $Y=13190 $dt=15
M1712 354 157 324 3 nfet_01v8 L=1.5e-07 W=1.5e-06 $X=116990 $Y=21470 $dt=15
M1713 355 158 324 3 nfet_01v8 L=1.5e-07 W=1.5e-06 $X=116990 $Y=29750 $dt=15
M1714 356 159 324 3 nfet_01v8 L=1.5e-07 W=1.5e-06 $X=116990 $Y=38030 $dt=15
M1715 357 160 324 3 nfet_01v8 L=1.5e-07 W=1.5e-06 $X=116990 $Y=46310 $dt=15
M1716 358 161 324 3 nfet_01v8 L=1.5e-07 W=1.5e-06 $X=116990 $Y=54590 $dt=15
M1717 359 162 324 3 nfet_01v8 L=1.5e-07 W=1.5e-06 $X=116990 $Y=62870 $dt=15
M1718 3 1 3 3 nfet_01v8 L=5.8e-07 W=1.5e-06 $X=116990 $Y=71150 $dt=15
M1719 3 1 3 3 nfet_01v8 L=5.8e-07 W=1.5e-06 $X=116990 $Y=79430 $dt=15
M1720 3 1 3 3 nfet_01v8 L=5.8e-07 W=1.5e-06 $X=116990 $Y=87710 $dt=15
M1721 3 1 3 3 nfet_01v8 L=5.8e-07 W=1.5e-06 $X=116990 $Y=95990 $dt=15
M1722 3 1 3 3 nfet_01v8 L=5.8e-07 W=1.5e-06 $X=116990 $Y=104270 $dt=15
M1723 360 168 324 3 nfet_01v8 L=1.5e-07 W=1.5e-06 $X=116990 $Y=112550 $dt=15
M1724 361 169 324 3 nfet_01v8 L=1.5e-07 W=1.5e-06 $X=116990 $Y=120830 $dt=15
M1725 362 170 324 3 nfet_01v8 L=1.5e-07 W=1.5e-06 $X=116990 $Y=129110 $dt=15
M1726 363 171 324 3 nfet_01v8 L=1.5e-07 W=1.5e-06 $X=116990 $Y=137390 $dt=15
M1727 364 172 324 3 nfet_01v8 L=1.5e-07 W=1.5e-06 $X=116990 $Y=145670 $dt=15
M1728 365 173 324 3 nfet_01v8 L=1.5e-07 W=1.5e-06 $X=116990 $Y=153950 $dt=15
M1729 366 174 324 3 nfet_01v8 L=1.5e-07 W=1.5e-06 $X=116990 $Y=162230 $dt=15
M1730 353 289 353 3 nfet_01v8 L=1.5e-07 W=1.5e-06 $X=117420 $Y=13190 $dt=15
M1731 354 290 354 3 nfet_01v8 L=1.5e-07 W=1.5e-06 $X=117420 $Y=21470 $dt=15
M1732 355 291 355 3 nfet_01v8 L=1.5e-07 W=1.5e-06 $X=117420 $Y=29750 $dt=15
M1733 356 292 356 3 nfet_01v8 L=1.5e-07 W=1.5e-06 $X=117420 $Y=38030 $dt=15
M1734 357 293 357 3 nfet_01v8 L=1.5e-07 W=1.5e-06 $X=117420 $Y=46310 $dt=15
M1735 358 294 358 3 nfet_01v8 L=1.5e-07 W=1.5e-06 $X=117420 $Y=54590 $dt=15
M1736 359 295 359 3 nfet_01v8 L=1.5e-07 W=1.5e-06 $X=117420 $Y=62870 $dt=15
M1737 360 301 360 3 nfet_01v8 L=1.5e-07 W=1.5e-06 $X=117420 $Y=112550 $dt=15
M1738 361 302 361 3 nfet_01v8 L=1.5e-07 W=1.5e-06 $X=117420 $Y=120830 $dt=15
M1739 362 303 362 3 nfet_01v8 L=1.5e-07 W=1.5e-06 $X=117420 $Y=129110 $dt=15
M1740 363 304 363 3 nfet_01v8 L=1.5e-07 W=1.5e-06 $X=117420 $Y=137390 $dt=15
M1741 364 305 364 3 nfet_01v8 L=1.5e-07 W=1.5e-06 $X=117420 $Y=145670 $dt=15
M1742 365 306 365 3 nfet_01v8 L=1.5e-07 W=1.5e-06 $X=117420 $Y=153950 $dt=15
M1743 366 307 366 3 nfet_01v8 L=1.5e-07 W=1.5e-06 $X=117420 $Y=162230 $dt=15
M1744 3 1 3 3 nfet_01v8 L=5.8e-07 W=1.5e-06 $X=123110 $Y=71150 $dt=15
M1745 3 1 3 3 nfet_01v8 L=5.8e-07 W=1.5e-06 $X=123110 $Y=79430 $dt=15
M1746 3 1 3 3 nfet_01v8 L=5.8e-07 W=1.5e-06 $X=123110 $Y=87710 $dt=15
M1747 3 1 3 3 nfet_01v8 L=5.8e-07 W=1.5e-06 $X=123110 $Y=95990 $dt=15
M1748 3 1 3 3 nfet_01v8 L=5.8e-07 W=1.5e-06 $X=123110 $Y=104270 $dt=15
M1749 353 270 309 3 nfet_01v8 L=1.5e-07 W=1.5e-06 $X=123120 $Y=13190 $dt=15
M1750 354 271 309 3 nfet_01v8 L=1.5e-07 W=1.5e-06 $X=123120 $Y=21470 $dt=15
M1751 355 272 309 3 nfet_01v8 L=1.5e-07 W=1.5e-06 $X=123120 $Y=29750 $dt=15
M1752 356 273 309 3 nfet_01v8 L=1.5e-07 W=1.5e-06 $X=123120 $Y=38030 $dt=15
M1753 357 274 309 3 nfet_01v8 L=1.5e-07 W=1.5e-06 $X=123120 $Y=46310 $dt=15
M1754 358 275 309 3 nfet_01v8 L=1.5e-07 W=1.5e-06 $X=123120 $Y=54590 $dt=15
M1755 359 276 309 3 nfet_01v8 L=1.5e-07 W=1.5e-06 $X=123120 $Y=62870 $dt=15
M1756 360 282 309 3 nfet_01v8 L=1.5e-07 W=1.5e-06 $X=123120 $Y=112550 $dt=15
M1757 361 283 309 3 nfet_01v8 L=1.5e-07 W=1.5e-06 $X=123120 $Y=120830 $dt=15
M1758 362 284 309 3 nfet_01v8 L=1.5e-07 W=1.5e-06 $X=123120 $Y=129110 $dt=15
M1759 363 285 309 3 nfet_01v8 L=1.5e-07 W=1.5e-06 $X=123120 $Y=137390 $dt=15
M1760 364 286 309 3 nfet_01v8 L=1.5e-07 W=1.5e-06 $X=123120 $Y=145670 $dt=15
M1761 365 287 309 3 nfet_01v8 L=1.5e-07 W=1.5e-06 $X=123120 $Y=153950 $dt=15
M1762 366 288 309 3 nfet_01v8 L=1.5e-07 W=1.5e-06 $X=123120 $Y=162230 $dt=15
M1763 308 232 353 3 nfet_01v8 L=1.5e-07 W=1.5e-06 $X=123550 $Y=13190 $dt=15
M1764 308 233 354 3 nfet_01v8 L=1.5e-07 W=1.5e-06 $X=123550 $Y=21470 $dt=15
M1765 308 234 355 3 nfet_01v8 L=1.5e-07 W=1.5e-06 $X=123550 $Y=29750 $dt=15
M1766 308 235 356 3 nfet_01v8 L=1.5e-07 W=1.5e-06 $X=123550 $Y=38030 $dt=15
M1767 308 236 357 3 nfet_01v8 L=1.5e-07 W=1.5e-06 $X=123550 $Y=46310 $dt=15
M1768 308 237 358 3 nfet_01v8 L=1.5e-07 W=1.5e-06 $X=123550 $Y=54590 $dt=15
M1769 308 238 359 3 nfet_01v8 L=1.5e-07 W=1.5e-06 $X=123550 $Y=62870 $dt=15
M1770 308 244 360 3 nfet_01v8 L=1.5e-07 W=1.5e-06 $X=123550 $Y=112550 $dt=15
M1771 308 245 361 3 nfet_01v8 L=1.5e-07 W=1.5e-06 $X=123550 $Y=120830 $dt=15
M1772 308 246 362 3 nfet_01v8 L=1.5e-07 W=1.5e-06 $X=123550 $Y=129110 $dt=15
M1773 308 247 363 3 nfet_01v8 L=1.5e-07 W=1.5e-06 $X=123550 $Y=137390 $dt=15
M1774 308 248 364 3 nfet_01v8 L=1.5e-07 W=1.5e-06 $X=123550 $Y=145670 $dt=15
M1775 308 249 365 3 nfet_01v8 L=1.5e-07 W=1.5e-06 $X=123550 $Y=153950 $dt=15
M1776 308 250 366 3 nfet_01v8 L=1.5e-07 W=1.5e-06 $X=123550 $Y=162230 $dt=15
M1777 339 156 324 3 nfet_01v8 L=1.5e-07 W=1.5e-06 $X=125270 $Y=13190 $dt=15
M1778 340 157 324 3 nfet_01v8 L=1.5e-07 W=1.5e-06 $X=125270 $Y=21470 $dt=15
M1779 341 158 324 3 nfet_01v8 L=1.5e-07 W=1.5e-06 $X=125270 $Y=29750 $dt=15
M1780 342 159 324 3 nfet_01v8 L=1.5e-07 W=1.5e-06 $X=125270 $Y=38030 $dt=15
M1781 343 160 324 3 nfet_01v8 L=1.5e-07 W=1.5e-06 $X=125270 $Y=46310 $dt=15
M1782 344 161 324 3 nfet_01v8 L=1.5e-07 W=1.5e-06 $X=125270 $Y=54590 $dt=15
M1783 345 162 324 3 nfet_01v8 L=1.5e-07 W=1.5e-06 $X=125270 $Y=62870 $dt=15
M1784 3 1 3 3 nfet_01v8 L=5.8e-07 W=1.5e-06 $X=125270 $Y=71150 $dt=15
M1785 3 1 3 3 nfet_01v8 L=5.8e-07 W=1.5e-06 $X=125270 $Y=79430 $dt=15
M1786 3 1 3 3 nfet_01v8 L=5.8e-07 W=1.5e-06 $X=125270 $Y=87710 $dt=15
M1787 3 1 3 3 nfet_01v8 L=5.8e-07 W=1.5e-06 $X=125270 $Y=95990 $dt=15
M1788 3 1 3 3 nfet_01v8 L=5.8e-07 W=1.5e-06 $X=125270 $Y=104270 $dt=15
M1789 346 168 324 3 nfet_01v8 L=1.5e-07 W=1.5e-06 $X=125270 $Y=112550 $dt=15
M1790 347 169 324 3 nfet_01v8 L=1.5e-07 W=1.5e-06 $X=125270 $Y=120830 $dt=15
M1791 348 170 324 3 nfet_01v8 L=1.5e-07 W=1.5e-06 $X=125270 $Y=129110 $dt=15
M1792 349 171 324 3 nfet_01v8 L=1.5e-07 W=1.5e-06 $X=125270 $Y=137390 $dt=15
M1793 350 172 324 3 nfet_01v8 L=1.5e-07 W=1.5e-06 $X=125270 $Y=145670 $dt=15
M1794 351 173 324 3 nfet_01v8 L=1.5e-07 W=1.5e-06 $X=125270 $Y=153950 $dt=15
M1795 352 174 324 3 nfet_01v8 L=1.5e-07 W=1.5e-06 $X=125270 $Y=162230 $dt=15
M1796 339 289 339 3 nfet_01v8 L=1.5e-07 W=1.5e-06 $X=125700 $Y=13190 $dt=15
M1797 340 290 340 3 nfet_01v8 L=1.5e-07 W=1.5e-06 $X=125700 $Y=21470 $dt=15
M1798 341 291 341 3 nfet_01v8 L=1.5e-07 W=1.5e-06 $X=125700 $Y=29750 $dt=15
M1799 342 292 342 3 nfet_01v8 L=1.5e-07 W=1.5e-06 $X=125700 $Y=38030 $dt=15
M1800 343 293 343 3 nfet_01v8 L=1.5e-07 W=1.5e-06 $X=125700 $Y=46310 $dt=15
M1801 344 294 344 3 nfet_01v8 L=1.5e-07 W=1.5e-06 $X=125700 $Y=54590 $dt=15
M1802 345 295 345 3 nfet_01v8 L=1.5e-07 W=1.5e-06 $X=125700 $Y=62870 $dt=15
M1803 346 301 346 3 nfet_01v8 L=1.5e-07 W=1.5e-06 $X=125700 $Y=112550 $dt=15
M1804 347 302 347 3 nfet_01v8 L=1.5e-07 W=1.5e-06 $X=125700 $Y=120830 $dt=15
M1805 348 303 348 3 nfet_01v8 L=1.5e-07 W=1.5e-06 $X=125700 $Y=129110 $dt=15
M1806 349 304 349 3 nfet_01v8 L=1.5e-07 W=1.5e-06 $X=125700 $Y=137390 $dt=15
M1807 350 305 350 3 nfet_01v8 L=1.5e-07 W=1.5e-06 $X=125700 $Y=145670 $dt=15
M1808 351 306 351 3 nfet_01v8 L=1.5e-07 W=1.5e-06 $X=125700 $Y=153950 $dt=15
M1809 352 307 352 3 nfet_01v8 L=1.5e-07 W=1.5e-06 $X=125700 $Y=162230 $dt=15
M1810 3 1 3 3 nfet_01v8 L=5.8e-07 W=1.5e-06 $X=131390 $Y=71150 $dt=15
M1811 3 1 3 3 nfet_01v8 L=5.8e-07 W=1.5e-06 $X=131390 $Y=79430 $dt=15
M1812 3 1 3 3 nfet_01v8 L=5.8e-07 W=1.5e-06 $X=131390 $Y=87710 $dt=15
M1813 3 1 3 3 nfet_01v8 L=5.8e-07 W=1.5e-06 $X=131390 $Y=95990 $dt=15
M1814 3 1 3 3 nfet_01v8 L=5.8e-07 W=1.5e-06 $X=131390 $Y=104270 $dt=15
M1815 339 270 309 3 nfet_01v8 L=1.5e-07 W=1.5e-06 $X=131400 $Y=13190 $dt=15
M1816 340 271 309 3 nfet_01v8 L=1.5e-07 W=1.5e-06 $X=131400 $Y=21470 $dt=15
M1817 341 272 309 3 nfet_01v8 L=1.5e-07 W=1.5e-06 $X=131400 $Y=29750 $dt=15
M1818 342 273 309 3 nfet_01v8 L=1.5e-07 W=1.5e-06 $X=131400 $Y=38030 $dt=15
M1819 343 274 309 3 nfet_01v8 L=1.5e-07 W=1.5e-06 $X=131400 $Y=46310 $dt=15
M1820 344 275 309 3 nfet_01v8 L=1.5e-07 W=1.5e-06 $X=131400 $Y=54590 $dt=15
M1821 345 276 309 3 nfet_01v8 L=1.5e-07 W=1.5e-06 $X=131400 $Y=62870 $dt=15
M1822 346 282 309 3 nfet_01v8 L=1.5e-07 W=1.5e-06 $X=131400 $Y=112550 $dt=15
M1823 347 283 309 3 nfet_01v8 L=1.5e-07 W=1.5e-06 $X=131400 $Y=120830 $dt=15
M1824 348 284 309 3 nfet_01v8 L=1.5e-07 W=1.5e-06 $X=131400 $Y=129110 $dt=15
M1825 349 285 309 3 nfet_01v8 L=1.5e-07 W=1.5e-06 $X=131400 $Y=137390 $dt=15
M1826 350 286 309 3 nfet_01v8 L=1.5e-07 W=1.5e-06 $X=131400 $Y=145670 $dt=15
M1827 351 287 309 3 nfet_01v8 L=1.5e-07 W=1.5e-06 $X=131400 $Y=153950 $dt=15
M1828 352 288 309 3 nfet_01v8 L=1.5e-07 W=1.5e-06 $X=131400 $Y=162230 $dt=15
M1829 308 232 339 3 nfet_01v8 L=1.5e-07 W=1.5e-06 $X=131830 $Y=13190 $dt=15
M1830 308 233 340 3 nfet_01v8 L=1.5e-07 W=1.5e-06 $X=131830 $Y=21470 $dt=15
M1831 308 234 341 3 nfet_01v8 L=1.5e-07 W=1.5e-06 $X=131830 $Y=29750 $dt=15
M1832 308 235 342 3 nfet_01v8 L=1.5e-07 W=1.5e-06 $X=131830 $Y=38030 $dt=15
M1833 308 236 343 3 nfet_01v8 L=1.5e-07 W=1.5e-06 $X=131830 $Y=46310 $dt=15
M1834 308 237 344 3 nfet_01v8 L=1.5e-07 W=1.5e-06 $X=131830 $Y=54590 $dt=15
M1835 308 238 345 3 nfet_01v8 L=1.5e-07 W=1.5e-06 $X=131830 $Y=62870 $dt=15
M1836 308 244 346 3 nfet_01v8 L=1.5e-07 W=1.5e-06 $X=131830 $Y=112550 $dt=15
M1837 308 245 347 3 nfet_01v8 L=1.5e-07 W=1.5e-06 $X=131830 $Y=120830 $dt=15
M1838 308 246 348 3 nfet_01v8 L=1.5e-07 W=1.5e-06 $X=131830 $Y=129110 $dt=15
M1839 308 247 349 3 nfet_01v8 L=1.5e-07 W=1.5e-06 $X=131830 $Y=137390 $dt=15
M1840 308 248 350 3 nfet_01v8 L=1.5e-07 W=1.5e-06 $X=131830 $Y=145670 $dt=15
M1841 308 249 351 3 nfet_01v8 L=1.5e-07 W=1.5e-06 $X=131830 $Y=153950 $dt=15
M1842 308 250 352 3 nfet_01v8 L=1.5e-07 W=1.5e-06 $X=131830 $Y=162230 $dt=15
M1843 325 156 324 3 nfet_01v8 L=1.5e-07 W=1.5e-06 $X=133550 $Y=13190 $dt=15
M1844 326 157 324 3 nfet_01v8 L=1.5e-07 W=1.5e-06 $X=133550 $Y=21470 $dt=15
M1845 327 158 324 3 nfet_01v8 L=1.5e-07 W=1.5e-06 $X=133550 $Y=29750 $dt=15
M1846 328 159 324 3 nfet_01v8 L=1.5e-07 W=1.5e-06 $X=133550 $Y=38030 $dt=15
M1847 329 160 324 3 nfet_01v8 L=1.5e-07 W=1.5e-06 $X=133550 $Y=46310 $dt=15
M1848 330 161 324 3 nfet_01v8 L=1.5e-07 W=1.5e-06 $X=133550 $Y=54590 $dt=15
M1849 331 162 324 3 nfet_01v8 L=1.5e-07 W=1.5e-06 $X=133550 $Y=62870 $dt=15
M1850 3 1 3 3 nfet_01v8 L=5.8e-07 W=1.5e-06 $X=133550 $Y=71150 $dt=15
M1851 3 1 3 3 nfet_01v8 L=5.8e-07 W=1.5e-06 $X=133550 $Y=79430 $dt=15
M1852 3 1 3 3 nfet_01v8 L=5.8e-07 W=1.5e-06 $X=133550 $Y=87710 $dt=15
M1853 3 1 3 3 nfet_01v8 L=5.8e-07 W=1.5e-06 $X=133550 $Y=95990 $dt=15
M1854 3 1 3 3 nfet_01v8 L=5.8e-07 W=1.5e-06 $X=133550 $Y=104270 $dt=15
M1855 332 168 324 3 nfet_01v8 L=1.5e-07 W=1.5e-06 $X=133550 $Y=112550 $dt=15
M1856 333 169 324 3 nfet_01v8 L=1.5e-07 W=1.5e-06 $X=133550 $Y=120830 $dt=15
M1857 334 170 324 3 nfet_01v8 L=1.5e-07 W=1.5e-06 $X=133550 $Y=129110 $dt=15
M1858 335 171 324 3 nfet_01v8 L=1.5e-07 W=1.5e-06 $X=133550 $Y=137390 $dt=15
M1859 336 172 324 3 nfet_01v8 L=1.5e-07 W=1.5e-06 $X=133550 $Y=145670 $dt=15
M1860 337 173 324 3 nfet_01v8 L=1.5e-07 W=1.5e-06 $X=133550 $Y=153950 $dt=15
M1861 338 174 324 3 nfet_01v8 L=1.5e-07 W=1.5e-06 $X=133550 $Y=162230 $dt=15
M1862 325 289 325 3 nfet_01v8 L=1.5e-07 W=1.5e-06 $X=133980 $Y=13190 $dt=15
M1863 326 290 326 3 nfet_01v8 L=1.5e-07 W=1.5e-06 $X=133980 $Y=21470 $dt=15
M1864 327 291 327 3 nfet_01v8 L=1.5e-07 W=1.5e-06 $X=133980 $Y=29750 $dt=15
M1865 328 292 328 3 nfet_01v8 L=1.5e-07 W=1.5e-06 $X=133980 $Y=38030 $dt=15
M1866 329 293 329 3 nfet_01v8 L=1.5e-07 W=1.5e-06 $X=133980 $Y=46310 $dt=15
M1867 330 294 330 3 nfet_01v8 L=1.5e-07 W=1.5e-06 $X=133980 $Y=54590 $dt=15
M1868 331 295 331 3 nfet_01v8 L=1.5e-07 W=1.5e-06 $X=133980 $Y=62870 $dt=15
M1869 332 301 332 3 nfet_01v8 L=1.5e-07 W=1.5e-06 $X=133980 $Y=112550 $dt=15
M1870 333 302 333 3 nfet_01v8 L=1.5e-07 W=1.5e-06 $X=133980 $Y=120830 $dt=15
M1871 334 303 334 3 nfet_01v8 L=1.5e-07 W=1.5e-06 $X=133980 $Y=129110 $dt=15
M1872 335 304 335 3 nfet_01v8 L=1.5e-07 W=1.5e-06 $X=133980 $Y=137390 $dt=15
M1873 336 305 336 3 nfet_01v8 L=1.5e-07 W=1.5e-06 $X=133980 $Y=145670 $dt=15
M1874 337 306 337 3 nfet_01v8 L=1.5e-07 W=1.5e-06 $X=133980 $Y=153950 $dt=15
M1875 338 307 338 3 nfet_01v8 L=1.5e-07 W=1.5e-06 $X=133980 $Y=162230 $dt=15
M1876 3 1 3 3 nfet_01v8 L=5.8e-07 W=1.5e-06 $X=139670 $Y=71150 $dt=15
M1877 3 1 3 3 nfet_01v8 L=5.8e-07 W=1.5e-06 $X=139670 $Y=79430 $dt=15
M1878 3 1 3 3 nfet_01v8 L=5.8e-07 W=1.5e-06 $X=139670 $Y=87710 $dt=15
M1879 3 1 3 3 nfet_01v8 L=5.8e-07 W=1.5e-06 $X=139670 $Y=95990 $dt=15
M1880 3 1 3 3 nfet_01v8 L=5.8e-07 W=1.5e-06 $X=139670 $Y=104270 $dt=15
M1881 325 270 309 3 nfet_01v8 L=1.5e-07 W=1.5e-06 $X=139680 $Y=13190 $dt=15
M1882 326 271 309 3 nfet_01v8 L=1.5e-07 W=1.5e-06 $X=139680 $Y=21470 $dt=15
M1883 327 272 309 3 nfet_01v8 L=1.5e-07 W=1.5e-06 $X=139680 $Y=29750 $dt=15
M1884 328 273 309 3 nfet_01v8 L=1.5e-07 W=1.5e-06 $X=139680 $Y=38030 $dt=15
M1885 329 274 309 3 nfet_01v8 L=1.5e-07 W=1.5e-06 $X=139680 $Y=46310 $dt=15
M1886 330 275 309 3 nfet_01v8 L=1.5e-07 W=1.5e-06 $X=139680 $Y=54590 $dt=15
M1887 331 276 309 3 nfet_01v8 L=1.5e-07 W=1.5e-06 $X=139680 $Y=62870 $dt=15
M1888 332 282 309 3 nfet_01v8 L=1.5e-07 W=1.5e-06 $X=139680 $Y=112550 $dt=15
M1889 333 283 309 3 nfet_01v8 L=1.5e-07 W=1.5e-06 $X=139680 $Y=120830 $dt=15
M1890 334 284 309 3 nfet_01v8 L=1.5e-07 W=1.5e-06 $X=139680 $Y=129110 $dt=15
M1891 335 285 309 3 nfet_01v8 L=1.5e-07 W=1.5e-06 $X=139680 $Y=137390 $dt=15
M1892 336 286 309 3 nfet_01v8 L=1.5e-07 W=1.5e-06 $X=139680 $Y=145670 $dt=15
M1893 337 287 309 3 nfet_01v8 L=1.5e-07 W=1.5e-06 $X=139680 $Y=153950 $dt=15
M1894 338 288 309 3 nfet_01v8 L=1.5e-07 W=1.5e-06 $X=139680 $Y=162230 $dt=15
M1895 308 232 325 3 nfet_01v8 L=1.5e-07 W=1.5e-06 $X=140110 $Y=13190 $dt=15
M1896 308 233 326 3 nfet_01v8 L=1.5e-07 W=1.5e-06 $X=140110 $Y=21470 $dt=15
M1897 308 234 327 3 nfet_01v8 L=1.5e-07 W=1.5e-06 $X=140110 $Y=29750 $dt=15
M1898 308 235 328 3 nfet_01v8 L=1.5e-07 W=1.5e-06 $X=140110 $Y=38030 $dt=15
M1899 308 236 329 3 nfet_01v8 L=1.5e-07 W=1.5e-06 $X=140110 $Y=46310 $dt=15
M1900 308 237 330 3 nfet_01v8 L=1.5e-07 W=1.5e-06 $X=140110 $Y=54590 $dt=15
M1901 308 238 331 3 nfet_01v8 L=1.5e-07 W=1.5e-06 $X=140110 $Y=62870 $dt=15
M1902 308 244 332 3 nfet_01v8 L=1.5e-07 W=1.5e-06 $X=140110 $Y=112550 $dt=15
M1903 308 245 333 3 nfet_01v8 L=1.5e-07 W=1.5e-06 $X=140110 $Y=120830 $dt=15
M1904 308 246 334 3 nfet_01v8 L=1.5e-07 W=1.5e-06 $X=140110 $Y=129110 $dt=15
M1905 308 247 335 3 nfet_01v8 L=1.5e-07 W=1.5e-06 $X=140110 $Y=137390 $dt=15
M1906 308 248 336 3 nfet_01v8 L=1.5e-07 W=1.5e-06 $X=140110 $Y=145670 $dt=15
M1907 308 249 337 3 nfet_01v8 L=1.5e-07 W=1.5e-06 $X=140110 $Y=153950 $dt=15
M1908 308 250 338 3 nfet_01v8 L=1.5e-07 W=1.5e-06 $X=140110 $Y=162230 $dt=15
M1909 310 156 324 3 nfet_01v8 L=1.5e-07 W=1.5e-06 $X=141830 $Y=13190 $dt=15
M1910 311 157 324 3 nfet_01v8 L=1.5e-07 W=1.5e-06 $X=141830 $Y=21470 $dt=15
M1911 312 158 324 3 nfet_01v8 L=1.5e-07 W=1.5e-06 $X=141830 $Y=29750 $dt=15
M1912 313 159 324 3 nfet_01v8 L=1.5e-07 W=1.5e-06 $X=141830 $Y=38030 $dt=15
M1913 314 160 324 3 nfet_01v8 L=1.5e-07 W=1.5e-06 $X=141830 $Y=46310 $dt=15
M1914 315 161 324 3 nfet_01v8 L=1.5e-07 W=1.5e-06 $X=141830 $Y=54590 $dt=15
M1915 316 162 324 3 nfet_01v8 L=1.5e-07 W=1.5e-06 $X=141830 $Y=62870 $dt=15
M1916 3 1 3 3 nfet_01v8 L=5.8e-07 W=1.5e-06 $X=141830 $Y=71150 $dt=15
M1917 3 1 3 3 nfet_01v8 L=5.8e-07 W=1.5e-06 $X=141830 $Y=79430 $dt=15
M1918 3 1 3 3 nfet_01v8 L=5.8e-07 W=1.5e-06 $X=141830 $Y=87710 $dt=15
M1919 3 1 3 3 nfet_01v8 L=5.8e-07 W=1.5e-06 $X=141830 $Y=95990 $dt=15
M1920 3 1 3 3 nfet_01v8 L=5.8e-07 W=1.5e-06 $X=141830 $Y=104270 $dt=15
M1921 317 168 324 3 nfet_01v8 L=1.5e-07 W=1.5e-06 $X=141830 $Y=112550 $dt=15
M1922 318 169 324 3 nfet_01v8 L=1.5e-07 W=1.5e-06 $X=141830 $Y=120830 $dt=15
M1923 319 170 324 3 nfet_01v8 L=1.5e-07 W=1.5e-06 $X=141830 $Y=129110 $dt=15
M1924 320 171 324 3 nfet_01v8 L=1.5e-07 W=1.5e-06 $X=141830 $Y=137390 $dt=15
M1925 321 172 324 3 nfet_01v8 L=1.5e-07 W=1.5e-06 $X=141830 $Y=145670 $dt=15
M1926 322 173 324 3 nfet_01v8 L=1.5e-07 W=1.5e-06 $X=141830 $Y=153950 $dt=15
M1927 323 174 324 3 nfet_01v8 L=1.5e-07 W=1.5e-06 $X=141830 $Y=162230 $dt=15
M1928 310 289 310 3 nfet_01v8 L=1.5e-07 W=1.5e-06 $X=142260 $Y=13190 $dt=15
M1929 311 290 311 3 nfet_01v8 L=1.5e-07 W=1.5e-06 $X=142260 $Y=21470 $dt=15
M1930 312 291 312 3 nfet_01v8 L=1.5e-07 W=1.5e-06 $X=142260 $Y=29750 $dt=15
M1931 313 292 313 3 nfet_01v8 L=1.5e-07 W=1.5e-06 $X=142260 $Y=38030 $dt=15
M1932 314 293 314 3 nfet_01v8 L=1.5e-07 W=1.5e-06 $X=142260 $Y=46310 $dt=15
M1933 315 294 315 3 nfet_01v8 L=1.5e-07 W=1.5e-06 $X=142260 $Y=54590 $dt=15
M1934 316 295 316 3 nfet_01v8 L=1.5e-07 W=1.5e-06 $X=142260 $Y=62870 $dt=15
M1935 317 301 317 3 nfet_01v8 L=1.5e-07 W=1.5e-06 $X=142260 $Y=112550 $dt=15
M1936 318 302 318 3 nfet_01v8 L=1.5e-07 W=1.5e-06 $X=142260 $Y=120830 $dt=15
M1937 319 303 319 3 nfet_01v8 L=1.5e-07 W=1.5e-06 $X=142260 $Y=129110 $dt=15
M1938 320 304 320 3 nfet_01v8 L=1.5e-07 W=1.5e-06 $X=142260 $Y=137390 $dt=15
M1939 321 305 321 3 nfet_01v8 L=1.5e-07 W=1.5e-06 $X=142260 $Y=145670 $dt=15
M1940 322 306 322 3 nfet_01v8 L=1.5e-07 W=1.5e-06 $X=142260 $Y=153950 $dt=15
M1941 323 307 323 3 nfet_01v8 L=1.5e-07 W=1.5e-06 $X=142260 $Y=162230 $dt=15
M1942 3 1 3 3 nfet_01v8 L=5.8e-07 W=1.5e-06 $X=147950 $Y=71150 $dt=15
M1943 3 1 3 3 nfet_01v8 L=5.8e-07 W=1.5e-06 $X=147950 $Y=79430 $dt=15
M1944 3 1 3 3 nfet_01v8 L=5.8e-07 W=1.5e-06 $X=147950 $Y=87710 $dt=15
M1945 3 1 3 3 nfet_01v8 L=5.8e-07 W=1.5e-06 $X=147950 $Y=95990 $dt=15
M1946 3 1 3 3 nfet_01v8 L=5.8e-07 W=1.5e-06 $X=147950 $Y=104270 $dt=15
M1947 310 270 309 3 nfet_01v8 L=1.5e-07 W=1.5e-06 $X=147960 $Y=13190 $dt=15
M1948 311 271 309 3 nfet_01v8 L=1.5e-07 W=1.5e-06 $X=147960 $Y=21470 $dt=15
M1949 312 272 309 3 nfet_01v8 L=1.5e-07 W=1.5e-06 $X=147960 $Y=29750 $dt=15
M1950 313 273 309 3 nfet_01v8 L=1.5e-07 W=1.5e-06 $X=147960 $Y=38030 $dt=15
M1951 314 274 309 3 nfet_01v8 L=1.5e-07 W=1.5e-06 $X=147960 $Y=46310 $dt=15
M1952 315 275 309 3 nfet_01v8 L=1.5e-07 W=1.5e-06 $X=147960 $Y=54590 $dt=15
M1953 316 276 309 3 nfet_01v8 L=1.5e-07 W=1.5e-06 $X=147960 $Y=62870 $dt=15
M1954 317 282 309 3 nfet_01v8 L=1.5e-07 W=1.5e-06 $X=147960 $Y=112550 $dt=15
M1955 318 283 309 3 nfet_01v8 L=1.5e-07 W=1.5e-06 $X=147960 $Y=120830 $dt=15
M1956 319 284 309 3 nfet_01v8 L=1.5e-07 W=1.5e-06 $X=147960 $Y=129110 $dt=15
M1957 320 285 309 3 nfet_01v8 L=1.5e-07 W=1.5e-06 $X=147960 $Y=137390 $dt=15
M1958 321 286 309 3 nfet_01v8 L=1.5e-07 W=1.5e-06 $X=147960 $Y=145670 $dt=15
M1959 322 287 309 3 nfet_01v8 L=1.5e-07 W=1.5e-06 $X=147960 $Y=153950 $dt=15
M1960 323 288 309 3 nfet_01v8 L=1.5e-07 W=1.5e-06 $X=147960 $Y=162230 $dt=15
M1961 308 232 310 3 nfet_01v8 L=1.5e-07 W=1.5e-06 $X=148390 $Y=13190 $dt=15
M1962 308 233 311 3 nfet_01v8 L=1.5e-07 W=1.5e-06 $X=148390 $Y=21470 $dt=15
M1963 308 234 312 3 nfet_01v8 L=1.5e-07 W=1.5e-06 $X=148390 $Y=29750 $dt=15
M1964 308 235 313 3 nfet_01v8 L=1.5e-07 W=1.5e-06 $X=148390 $Y=38030 $dt=15
M1965 308 236 314 3 nfet_01v8 L=1.5e-07 W=1.5e-06 $X=148390 $Y=46310 $dt=15
M1966 308 237 315 3 nfet_01v8 L=1.5e-07 W=1.5e-06 $X=148390 $Y=54590 $dt=15
M1967 308 238 316 3 nfet_01v8 L=1.5e-07 W=1.5e-06 $X=148390 $Y=62870 $dt=15
M1968 308 244 317 3 nfet_01v8 L=1.5e-07 W=1.5e-06 $X=148390 $Y=112550 $dt=15
M1969 308 245 318 3 nfet_01v8 L=1.5e-07 W=1.5e-06 $X=148390 $Y=120830 $dt=15
M1970 308 246 319 3 nfet_01v8 L=1.5e-07 W=1.5e-06 $X=148390 $Y=129110 $dt=15
M1971 308 247 320 3 nfet_01v8 L=1.5e-07 W=1.5e-06 $X=148390 $Y=137390 $dt=15
M1972 308 248 321 3 nfet_01v8 L=1.5e-07 W=1.5e-06 $X=148390 $Y=145670 $dt=15
M1973 308 249 322 3 nfet_01v8 L=1.5e-07 W=1.5e-06 $X=148390 $Y=153950 $dt=15
M1974 308 250 323 3 nfet_01v8 L=1.5e-07 W=1.5e-06 $X=148390 $Y=162230 $dt=15
M1975 289 118 3 3 nfet_01v8 L=1.5e-07 W=7.6e-07 $X=150530 $Y=11070 $dt=15
M1976 290 119 3 3 nfet_01v8 L=1.5e-07 W=7.6e-07 $X=150530 $Y=19350 $dt=15
M1977 291 120 3 3 nfet_01v8 L=1.5e-07 W=7.6e-07 $X=150530 $Y=27630 $dt=15
M1978 292 121 3 3 nfet_01v8 L=1.5e-07 W=7.6e-07 $X=150530 $Y=35910 $dt=15
M1979 293 122 3 3 nfet_01v8 L=1.5e-07 W=7.6e-07 $X=150530 $Y=44190 $dt=15
M1980 294 123 3 3 nfet_01v8 L=1.5e-07 W=7.6e-07 $X=150530 $Y=52470 $dt=15
M1981 295 124 3 3 nfet_01v8 L=1.5e-07 W=7.6e-07 $X=150530 $Y=60750 $dt=15
M1982 296 125 3 3 nfet_01v8 L=1.5e-07 W=7.6e-07 $X=150530 $Y=69030 $dt=15
M1983 297 126 3 3 nfet_01v8 L=1.5e-07 W=7.6e-07 $X=150530 $Y=77310 $dt=15
M1984 298 127 3 3 nfet_01v8 L=1.5e-07 W=7.6e-07 $X=150530 $Y=85590 $dt=15
M1985 299 128 3 3 nfet_01v8 L=1.5e-07 W=7.6e-07 $X=150530 $Y=93870 $dt=15
M1986 300 129 3 3 nfet_01v8 L=1.5e-07 W=7.6e-07 $X=150530 $Y=102150 $dt=15
M1987 301 130 3 3 nfet_01v8 L=1.5e-07 W=7.6e-07 $X=150530 $Y=110430 $dt=15
M1988 302 131 3 3 nfet_01v8 L=1.5e-07 W=7.6e-07 $X=150530 $Y=118710 $dt=15
M1989 303 132 3 3 nfet_01v8 L=1.5e-07 W=7.6e-07 $X=150530 $Y=126990 $dt=15
M1990 304 133 3 3 nfet_01v8 L=1.5e-07 W=7.6e-07 $X=150530 $Y=135270 $dt=15
M1991 305 134 3 3 nfet_01v8 L=1.5e-07 W=7.6e-07 $X=150530 $Y=143550 $dt=15
M1992 306 135 3 3 nfet_01v8 L=1.5e-07 W=7.6e-07 $X=150530 $Y=151830 $dt=15
M1993 307 136 3 3 nfet_01v8 L=1.5e-07 W=7.6e-07 $X=150530 $Y=160110 $dt=15
M1994 270 251 3 3 nfet_01v8 L=1.5e-07 W=7.6e-07 $X=150590 $Y=13010 $dt=15
M1995 271 252 3 3 nfet_01v8 L=1.5e-07 W=7.6e-07 $X=150590 $Y=21290 $dt=15
M1996 272 253 3 3 nfet_01v8 L=1.5e-07 W=7.6e-07 $X=150590 $Y=29570 $dt=15
M1997 273 254 3 3 nfet_01v8 L=1.5e-07 W=7.6e-07 $X=150590 $Y=37850 $dt=15
M1998 274 255 3 3 nfet_01v8 L=1.5e-07 W=7.6e-07 $X=150590 $Y=46130 $dt=15
M1999 275 256 3 3 nfet_01v8 L=1.5e-07 W=7.6e-07 $X=150590 $Y=54410 $dt=15
M2000 276 257 3 3 nfet_01v8 L=1.5e-07 W=7.6e-07 $X=150590 $Y=62690 $dt=15
M2001 277 258 3 3 nfet_01v8 L=1.5e-07 W=7.6e-07 $X=150590 $Y=70970 $dt=15
M2002 278 259 3 3 nfet_01v8 L=1.5e-07 W=7.6e-07 $X=150590 $Y=79250 $dt=15
M2003 279 260 3 3 nfet_01v8 L=1.5e-07 W=7.6e-07 $X=150590 $Y=87530 $dt=15
M2004 280 261 3 3 nfet_01v8 L=1.5e-07 W=7.6e-07 $X=150590 $Y=95810 $dt=15
M2005 281 262 3 3 nfet_01v8 L=1.5e-07 W=7.6e-07 $X=150590 $Y=104090 $dt=15
M2006 282 263 3 3 nfet_01v8 L=1.5e-07 W=7.6e-07 $X=150590 $Y=112370 $dt=15
M2007 283 264 3 3 nfet_01v8 L=1.5e-07 W=7.6e-07 $X=150590 $Y=120650 $dt=15
M2008 284 265 3 3 nfet_01v8 L=1.5e-07 W=7.6e-07 $X=150590 $Y=128930 $dt=15
M2009 285 266 3 3 nfet_01v8 L=1.5e-07 W=7.6e-07 $X=150590 $Y=137210 $dt=15
M2010 286 267 3 3 nfet_01v8 L=1.5e-07 W=7.6e-07 $X=150590 $Y=145490 $dt=15
M2011 287 268 3 3 nfet_01v8 L=1.5e-07 W=7.6e-07 $X=150590 $Y=153770 $dt=15
M2012 288 269 3 3 nfet_01v8 L=1.5e-07 W=7.6e-07 $X=150590 $Y=162050 $dt=15
M2013 3 118 289 3 nfet_01v8 L=1.5e-07 W=7.6e-07 $X=150960 $Y=11070 $dt=15
M2014 3 119 290 3 nfet_01v8 L=1.5e-07 W=7.6e-07 $X=150960 $Y=19350 $dt=15
M2015 3 120 291 3 nfet_01v8 L=1.5e-07 W=7.6e-07 $X=150960 $Y=27630 $dt=15
M2016 3 121 292 3 nfet_01v8 L=1.5e-07 W=7.6e-07 $X=150960 $Y=35910 $dt=15
M2017 3 122 293 3 nfet_01v8 L=1.5e-07 W=7.6e-07 $X=150960 $Y=44190 $dt=15
M2018 3 123 294 3 nfet_01v8 L=1.5e-07 W=7.6e-07 $X=150960 $Y=52470 $dt=15
M2019 3 124 295 3 nfet_01v8 L=1.5e-07 W=7.6e-07 $X=150960 $Y=60750 $dt=15
M2020 3 125 296 3 nfet_01v8 L=1.5e-07 W=7.6e-07 $X=150960 $Y=69030 $dt=15
M2021 3 126 297 3 nfet_01v8 L=1.5e-07 W=7.6e-07 $X=150960 $Y=77310 $dt=15
M2022 3 127 298 3 nfet_01v8 L=1.5e-07 W=7.6e-07 $X=150960 $Y=85590 $dt=15
M2023 3 128 299 3 nfet_01v8 L=1.5e-07 W=7.6e-07 $X=150960 $Y=93870 $dt=15
M2024 3 129 300 3 nfet_01v8 L=1.5e-07 W=7.6e-07 $X=150960 $Y=102150 $dt=15
M2025 3 130 301 3 nfet_01v8 L=1.5e-07 W=7.6e-07 $X=150960 $Y=110430 $dt=15
M2026 3 131 302 3 nfet_01v8 L=1.5e-07 W=7.6e-07 $X=150960 $Y=118710 $dt=15
M2027 3 132 303 3 nfet_01v8 L=1.5e-07 W=7.6e-07 $X=150960 $Y=126990 $dt=15
M2028 3 133 304 3 nfet_01v8 L=1.5e-07 W=7.6e-07 $X=150960 $Y=135270 $dt=15
M2029 3 134 305 3 nfet_01v8 L=1.5e-07 W=7.6e-07 $X=150960 $Y=143550 $dt=15
M2030 3 135 306 3 nfet_01v8 L=1.5e-07 W=7.6e-07 $X=150960 $Y=151830 $dt=15
M2031 3 136 307 3 nfet_01v8 L=1.5e-07 W=7.6e-07 $X=150960 $Y=160110 $dt=15
M2032 3 251 270 3 nfet_01v8 L=1.5e-07 W=7.6e-07 $X=151020 $Y=13010 $dt=15
M2033 3 252 271 3 nfet_01v8 L=1.5e-07 W=7.6e-07 $X=151020 $Y=21290 $dt=15
M2034 3 253 272 3 nfet_01v8 L=1.5e-07 W=7.6e-07 $X=151020 $Y=29570 $dt=15
M2035 3 254 273 3 nfet_01v8 L=1.5e-07 W=7.6e-07 $X=151020 $Y=37850 $dt=15
M2036 3 255 274 3 nfet_01v8 L=1.5e-07 W=7.6e-07 $X=151020 $Y=46130 $dt=15
M2037 3 256 275 3 nfet_01v8 L=1.5e-07 W=7.6e-07 $X=151020 $Y=54410 $dt=15
M2038 3 257 276 3 nfet_01v8 L=1.5e-07 W=7.6e-07 $X=151020 $Y=62690 $dt=15
M2039 3 258 277 3 nfet_01v8 L=1.5e-07 W=7.6e-07 $X=151020 $Y=70970 $dt=15
M2040 3 259 278 3 nfet_01v8 L=1.5e-07 W=7.6e-07 $X=151020 $Y=79250 $dt=15
M2041 3 260 279 3 nfet_01v8 L=1.5e-07 W=7.6e-07 $X=151020 $Y=87530 $dt=15
M2042 3 261 280 3 nfet_01v8 L=1.5e-07 W=7.6e-07 $X=151020 $Y=95810 $dt=15
M2043 3 262 281 3 nfet_01v8 L=1.5e-07 W=7.6e-07 $X=151020 $Y=104090 $dt=15
M2044 3 263 282 3 nfet_01v8 L=1.5e-07 W=7.6e-07 $X=151020 $Y=112370 $dt=15
M2045 3 264 283 3 nfet_01v8 L=1.5e-07 W=7.6e-07 $X=151020 $Y=120650 $dt=15
M2046 3 265 284 3 nfet_01v8 L=1.5e-07 W=7.6e-07 $X=151020 $Y=128930 $dt=15
M2047 3 266 285 3 nfet_01v8 L=1.5e-07 W=7.6e-07 $X=151020 $Y=137210 $dt=15
M2048 3 267 286 3 nfet_01v8 L=1.5e-07 W=7.6e-07 $X=151020 $Y=145490 $dt=15
M2049 3 268 287 3 nfet_01v8 L=1.5e-07 W=7.6e-07 $X=151020 $Y=153770 $dt=15
M2050 3 269 288 3 nfet_01v8 L=1.5e-07 W=7.6e-07 $X=151020 $Y=162050 $dt=15
M2051 289 118 3 3 nfet_01v8 L=1.5e-07 W=7.6e-07 $X=151390 $Y=11070 $dt=15
M2052 290 119 3 3 nfet_01v8 L=1.5e-07 W=7.6e-07 $X=151390 $Y=19350 $dt=15
M2053 291 120 3 3 nfet_01v8 L=1.5e-07 W=7.6e-07 $X=151390 $Y=27630 $dt=15
M2054 292 121 3 3 nfet_01v8 L=1.5e-07 W=7.6e-07 $X=151390 $Y=35910 $dt=15
M2055 293 122 3 3 nfet_01v8 L=1.5e-07 W=7.6e-07 $X=151390 $Y=44190 $dt=15
M2056 294 123 3 3 nfet_01v8 L=1.5e-07 W=7.6e-07 $X=151390 $Y=52470 $dt=15
M2057 295 124 3 3 nfet_01v8 L=1.5e-07 W=7.6e-07 $X=151390 $Y=60750 $dt=15
M2058 296 125 3 3 nfet_01v8 L=1.5e-07 W=7.6e-07 $X=151390 $Y=69030 $dt=15
M2059 297 126 3 3 nfet_01v8 L=1.5e-07 W=7.6e-07 $X=151390 $Y=77310 $dt=15
M2060 298 127 3 3 nfet_01v8 L=1.5e-07 W=7.6e-07 $X=151390 $Y=85590 $dt=15
M2061 299 128 3 3 nfet_01v8 L=1.5e-07 W=7.6e-07 $X=151390 $Y=93870 $dt=15
M2062 300 129 3 3 nfet_01v8 L=1.5e-07 W=7.6e-07 $X=151390 $Y=102150 $dt=15
M2063 301 130 3 3 nfet_01v8 L=1.5e-07 W=7.6e-07 $X=151390 $Y=110430 $dt=15
M2064 302 131 3 3 nfet_01v8 L=1.5e-07 W=7.6e-07 $X=151390 $Y=118710 $dt=15
M2065 303 132 3 3 nfet_01v8 L=1.5e-07 W=7.6e-07 $X=151390 $Y=126990 $dt=15
M2066 304 133 3 3 nfet_01v8 L=1.5e-07 W=7.6e-07 $X=151390 $Y=135270 $dt=15
M2067 305 134 3 3 nfet_01v8 L=1.5e-07 W=7.6e-07 $X=151390 $Y=143550 $dt=15
M2068 306 135 3 3 nfet_01v8 L=1.5e-07 W=7.6e-07 $X=151390 $Y=151830 $dt=15
M2069 307 136 3 3 nfet_01v8 L=1.5e-07 W=7.6e-07 $X=151390 $Y=160110 $dt=15
M2070 270 251 3 3 nfet_01v8 L=1.5e-07 W=7.6e-07 $X=151450 $Y=13010 $dt=15
M2071 271 252 3 3 nfet_01v8 L=1.5e-07 W=7.6e-07 $X=151450 $Y=21290 $dt=15
M2072 272 253 3 3 nfet_01v8 L=1.5e-07 W=7.6e-07 $X=151450 $Y=29570 $dt=15
M2073 273 254 3 3 nfet_01v8 L=1.5e-07 W=7.6e-07 $X=151450 $Y=37850 $dt=15
M2074 274 255 3 3 nfet_01v8 L=1.5e-07 W=7.6e-07 $X=151450 $Y=46130 $dt=15
M2075 275 256 3 3 nfet_01v8 L=1.5e-07 W=7.6e-07 $X=151450 $Y=54410 $dt=15
M2076 276 257 3 3 nfet_01v8 L=1.5e-07 W=7.6e-07 $X=151450 $Y=62690 $dt=15
M2077 277 258 3 3 nfet_01v8 L=1.5e-07 W=7.6e-07 $X=151450 $Y=70970 $dt=15
M2078 278 259 3 3 nfet_01v8 L=1.5e-07 W=7.6e-07 $X=151450 $Y=79250 $dt=15
M2079 279 260 3 3 nfet_01v8 L=1.5e-07 W=7.6e-07 $X=151450 $Y=87530 $dt=15
M2080 280 261 3 3 nfet_01v8 L=1.5e-07 W=7.6e-07 $X=151450 $Y=95810 $dt=15
M2081 281 262 3 3 nfet_01v8 L=1.5e-07 W=7.6e-07 $X=151450 $Y=104090 $dt=15
M2082 282 263 3 3 nfet_01v8 L=1.5e-07 W=7.6e-07 $X=151450 $Y=112370 $dt=15
M2083 283 264 3 3 nfet_01v8 L=1.5e-07 W=7.6e-07 $X=151450 $Y=120650 $dt=15
M2084 284 265 3 3 nfet_01v8 L=1.5e-07 W=7.6e-07 $X=151450 $Y=128930 $dt=15
M2085 285 266 3 3 nfet_01v8 L=1.5e-07 W=7.6e-07 $X=151450 $Y=137210 $dt=15
M2086 286 267 3 3 nfet_01v8 L=1.5e-07 W=7.6e-07 $X=151450 $Y=145490 $dt=15
M2087 287 268 3 3 nfet_01v8 L=1.5e-07 W=7.6e-07 $X=151450 $Y=153770 $dt=15
M2088 288 269 3 3 nfet_01v8 L=1.5e-07 W=7.6e-07 $X=151450 $Y=162050 $dt=15
M2089 3 118 289 3 nfet_01v8 L=1.5e-07 W=7.6e-07 $X=151820 $Y=11070 $dt=15
M2090 3 119 290 3 nfet_01v8 L=1.5e-07 W=7.6e-07 $X=151820 $Y=19350 $dt=15
M2091 3 120 291 3 nfet_01v8 L=1.5e-07 W=7.6e-07 $X=151820 $Y=27630 $dt=15
M2092 3 121 292 3 nfet_01v8 L=1.5e-07 W=7.6e-07 $X=151820 $Y=35910 $dt=15
M2093 3 122 293 3 nfet_01v8 L=1.5e-07 W=7.6e-07 $X=151820 $Y=44190 $dt=15
M2094 3 123 294 3 nfet_01v8 L=1.5e-07 W=7.6e-07 $X=151820 $Y=52470 $dt=15
M2095 3 124 295 3 nfet_01v8 L=1.5e-07 W=7.6e-07 $X=151820 $Y=60750 $dt=15
M2096 3 125 296 3 nfet_01v8 L=1.5e-07 W=7.6e-07 $X=151820 $Y=69030 $dt=15
M2097 3 126 297 3 nfet_01v8 L=1.5e-07 W=7.6e-07 $X=151820 $Y=77310 $dt=15
M2098 3 127 298 3 nfet_01v8 L=1.5e-07 W=7.6e-07 $X=151820 $Y=85590 $dt=15
M2099 3 128 299 3 nfet_01v8 L=1.5e-07 W=7.6e-07 $X=151820 $Y=93870 $dt=15
M2100 3 129 300 3 nfet_01v8 L=1.5e-07 W=7.6e-07 $X=151820 $Y=102150 $dt=15
M2101 3 130 301 3 nfet_01v8 L=1.5e-07 W=7.6e-07 $X=151820 $Y=110430 $dt=15
M2102 3 131 302 3 nfet_01v8 L=1.5e-07 W=7.6e-07 $X=151820 $Y=118710 $dt=15
M2103 3 132 303 3 nfet_01v8 L=1.5e-07 W=7.6e-07 $X=151820 $Y=126990 $dt=15
M2104 3 133 304 3 nfet_01v8 L=1.5e-07 W=7.6e-07 $X=151820 $Y=135270 $dt=15
M2105 3 134 305 3 nfet_01v8 L=1.5e-07 W=7.6e-07 $X=151820 $Y=143550 $dt=15
M2106 3 135 306 3 nfet_01v8 L=1.5e-07 W=7.6e-07 $X=151820 $Y=151830 $dt=15
M2107 3 136 307 3 nfet_01v8 L=1.5e-07 W=7.6e-07 $X=151820 $Y=160110 $dt=15
M2108 3 251 270 3 nfet_01v8 L=1.5e-07 W=7.6e-07 $X=151880 $Y=13010 $dt=15
M2109 3 252 271 3 nfet_01v8 L=1.5e-07 W=7.6e-07 $X=151880 $Y=21290 $dt=15
M2110 3 253 272 3 nfet_01v8 L=1.5e-07 W=7.6e-07 $X=151880 $Y=29570 $dt=15
M2111 3 254 273 3 nfet_01v8 L=1.5e-07 W=7.6e-07 $X=151880 $Y=37850 $dt=15
M2112 3 255 274 3 nfet_01v8 L=1.5e-07 W=7.6e-07 $X=151880 $Y=46130 $dt=15
M2113 3 256 275 3 nfet_01v8 L=1.5e-07 W=7.6e-07 $X=151880 $Y=54410 $dt=15
M2114 3 257 276 3 nfet_01v8 L=1.5e-07 W=7.6e-07 $X=151880 $Y=62690 $dt=15
M2115 3 258 277 3 nfet_01v8 L=1.5e-07 W=7.6e-07 $X=151880 $Y=70970 $dt=15
M2116 3 259 278 3 nfet_01v8 L=1.5e-07 W=7.6e-07 $X=151880 $Y=79250 $dt=15
M2117 3 260 279 3 nfet_01v8 L=1.5e-07 W=7.6e-07 $X=151880 $Y=87530 $dt=15
M2118 3 261 280 3 nfet_01v8 L=1.5e-07 W=7.6e-07 $X=151880 $Y=95810 $dt=15
M2119 3 262 281 3 nfet_01v8 L=1.5e-07 W=7.6e-07 $X=151880 $Y=104090 $dt=15
M2120 3 263 282 3 nfet_01v8 L=1.5e-07 W=7.6e-07 $X=151880 $Y=112370 $dt=15
M2121 3 264 283 3 nfet_01v8 L=1.5e-07 W=7.6e-07 $X=151880 $Y=120650 $dt=15
M2122 3 265 284 3 nfet_01v8 L=1.5e-07 W=7.6e-07 $X=151880 $Y=128930 $dt=15
M2123 3 266 285 3 nfet_01v8 L=1.5e-07 W=7.6e-07 $X=151880 $Y=137210 $dt=15
M2124 3 267 286 3 nfet_01v8 L=1.5e-07 W=7.6e-07 $X=151880 $Y=145490 $dt=15
M2125 3 268 287 3 nfet_01v8 L=1.5e-07 W=7.6e-07 $X=151880 $Y=153770 $dt=15
M2126 3 269 288 3 nfet_01v8 L=1.5e-07 W=7.6e-07 $X=151880 $Y=162050 $dt=15
M2127 289 118 3 3 nfet_01v8 L=1.5e-07 W=7.6e-07 $X=152250 $Y=11070 $dt=15
M2128 290 119 3 3 nfet_01v8 L=1.5e-07 W=7.6e-07 $X=152250 $Y=19350 $dt=15
M2129 291 120 3 3 nfet_01v8 L=1.5e-07 W=7.6e-07 $X=152250 $Y=27630 $dt=15
M2130 292 121 3 3 nfet_01v8 L=1.5e-07 W=7.6e-07 $X=152250 $Y=35910 $dt=15
M2131 293 122 3 3 nfet_01v8 L=1.5e-07 W=7.6e-07 $X=152250 $Y=44190 $dt=15
M2132 294 123 3 3 nfet_01v8 L=1.5e-07 W=7.6e-07 $X=152250 $Y=52470 $dt=15
M2133 295 124 3 3 nfet_01v8 L=1.5e-07 W=7.6e-07 $X=152250 $Y=60750 $dt=15
M2134 296 125 3 3 nfet_01v8 L=1.5e-07 W=7.6e-07 $X=152250 $Y=69030 $dt=15
M2135 297 126 3 3 nfet_01v8 L=1.5e-07 W=7.6e-07 $X=152250 $Y=77310 $dt=15
M2136 298 127 3 3 nfet_01v8 L=1.5e-07 W=7.6e-07 $X=152250 $Y=85590 $dt=15
M2137 299 128 3 3 nfet_01v8 L=1.5e-07 W=7.6e-07 $X=152250 $Y=93870 $dt=15
M2138 300 129 3 3 nfet_01v8 L=1.5e-07 W=7.6e-07 $X=152250 $Y=102150 $dt=15
M2139 301 130 3 3 nfet_01v8 L=1.5e-07 W=7.6e-07 $X=152250 $Y=110430 $dt=15
M2140 302 131 3 3 nfet_01v8 L=1.5e-07 W=7.6e-07 $X=152250 $Y=118710 $dt=15
M2141 303 132 3 3 nfet_01v8 L=1.5e-07 W=7.6e-07 $X=152250 $Y=126990 $dt=15
M2142 304 133 3 3 nfet_01v8 L=1.5e-07 W=7.6e-07 $X=152250 $Y=135270 $dt=15
M2143 305 134 3 3 nfet_01v8 L=1.5e-07 W=7.6e-07 $X=152250 $Y=143550 $dt=15
M2144 306 135 3 3 nfet_01v8 L=1.5e-07 W=7.6e-07 $X=152250 $Y=151830 $dt=15
M2145 307 136 3 3 nfet_01v8 L=1.5e-07 W=7.6e-07 $X=152250 $Y=160110 $dt=15
M2146 270 251 3 3 nfet_01v8 L=1.5e-07 W=7.6e-07 $X=152310 $Y=13010 $dt=15
M2147 271 252 3 3 nfet_01v8 L=1.5e-07 W=7.6e-07 $X=152310 $Y=21290 $dt=15
M2148 272 253 3 3 nfet_01v8 L=1.5e-07 W=7.6e-07 $X=152310 $Y=29570 $dt=15
M2149 273 254 3 3 nfet_01v8 L=1.5e-07 W=7.6e-07 $X=152310 $Y=37850 $dt=15
M2150 274 255 3 3 nfet_01v8 L=1.5e-07 W=7.6e-07 $X=152310 $Y=46130 $dt=15
M2151 275 256 3 3 nfet_01v8 L=1.5e-07 W=7.6e-07 $X=152310 $Y=54410 $dt=15
M2152 276 257 3 3 nfet_01v8 L=1.5e-07 W=7.6e-07 $X=152310 $Y=62690 $dt=15
M2153 277 258 3 3 nfet_01v8 L=1.5e-07 W=7.6e-07 $X=152310 $Y=70970 $dt=15
M2154 278 259 3 3 nfet_01v8 L=1.5e-07 W=7.6e-07 $X=152310 $Y=79250 $dt=15
M2155 279 260 3 3 nfet_01v8 L=1.5e-07 W=7.6e-07 $X=152310 $Y=87530 $dt=15
M2156 280 261 3 3 nfet_01v8 L=1.5e-07 W=7.6e-07 $X=152310 $Y=95810 $dt=15
M2157 281 262 3 3 nfet_01v8 L=1.5e-07 W=7.6e-07 $X=152310 $Y=104090 $dt=15
M2158 282 263 3 3 nfet_01v8 L=1.5e-07 W=7.6e-07 $X=152310 $Y=112370 $dt=15
M2159 283 264 3 3 nfet_01v8 L=1.5e-07 W=7.6e-07 $X=152310 $Y=120650 $dt=15
M2160 284 265 3 3 nfet_01v8 L=1.5e-07 W=7.6e-07 $X=152310 $Y=128930 $dt=15
M2161 285 266 3 3 nfet_01v8 L=1.5e-07 W=7.6e-07 $X=152310 $Y=137210 $dt=15
M2162 286 267 3 3 nfet_01v8 L=1.5e-07 W=7.6e-07 $X=152310 $Y=145490 $dt=15
M2163 287 268 3 3 nfet_01v8 L=1.5e-07 W=7.6e-07 $X=152310 $Y=153770 $dt=15
M2164 288 269 3 3 nfet_01v8 L=1.5e-07 W=7.6e-07 $X=152310 $Y=162050 $dt=15
M2165 3 118 289 3 nfet_01v8 L=1.5e-07 W=7.6e-07 $X=152680 $Y=11070 $dt=15
M2166 3 119 290 3 nfet_01v8 L=1.5e-07 W=7.6e-07 $X=152680 $Y=19350 $dt=15
M2167 3 120 291 3 nfet_01v8 L=1.5e-07 W=7.6e-07 $X=152680 $Y=27630 $dt=15
M2168 3 121 292 3 nfet_01v8 L=1.5e-07 W=7.6e-07 $X=152680 $Y=35910 $dt=15
M2169 3 122 293 3 nfet_01v8 L=1.5e-07 W=7.6e-07 $X=152680 $Y=44190 $dt=15
M2170 3 123 294 3 nfet_01v8 L=1.5e-07 W=7.6e-07 $X=152680 $Y=52470 $dt=15
M2171 3 124 295 3 nfet_01v8 L=1.5e-07 W=7.6e-07 $X=152680 $Y=60750 $dt=15
M2172 3 125 296 3 nfet_01v8 L=1.5e-07 W=7.6e-07 $X=152680 $Y=69030 $dt=15
M2173 3 126 297 3 nfet_01v8 L=1.5e-07 W=7.6e-07 $X=152680 $Y=77310 $dt=15
M2174 3 127 298 3 nfet_01v8 L=1.5e-07 W=7.6e-07 $X=152680 $Y=85590 $dt=15
M2175 3 128 299 3 nfet_01v8 L=1.5e-07 W=7.6e-07 $X=152680 $Y=93870 $dt=15
M2176 3 129 300 3 nfet_01v8 L=1.5e-07 W=7.6e-07 $X=152680 $Y=102150 $dt=15
M2177 3 130 301 3 nfet_01v8 L=1.5e-07 W=7.6e-07 $X=152680 $Y=110430 $dt=15
M2178 3 131 302 3 nfet_01v8 L=1.5e-07 W=7.6e-07 $X=152680 $Y=118710 $dt=15
M2179 3 132 303 3 nfet_01v8 L=1.5e-07 W=7.6e-07 $X=152680 $Y=126990 $dt=15
M2180 3 133 304 3 nfet_01v8 L=1.5e-07 W=7.6e-07 $X=152680 $Y=135270 $dt=15
M2181 3 134 305 3 nfet_01v8 L=1.5e-07 W=7.6e-07 $X=152680 $Y=143550 $dt=15
M2182 3 135 306 3 nfet_01v8 L=1.5e-07 W=7.6e-07 $X=152680 $Y=151830 $dt=15
M2183 3 136 307 3 nfet_01v8 L=1.5e-07 W=7.6e-07 $X=152680 $Y=160110 $dt=15
M2184 3 251 270 3 nfet_01v8 L=1.5e-07 W=7.6e-07 $X=152740 $Y=13010 $dt=15
M2185 3 252 271 3 nfet_01v8 L=1.5e-07 W=7.6e-07 $X=152740 $Y=21290 $dt=15
M2186 3 253 272 3 nfet_01v8 L=1.5e-07 W=7.6e-07 $X=152740 $Y=29570 $dt=15
M2187 3 254 273 3 nfet_01v8 L=1.5e-07 W=7.6e-07 $X=152740 $Y=37850 $dt=15
M2188 3 255 274 3 nfet_01v8 L=1.5e-07 W=7.6e-07 $X=152740 $Y=46130 $dt=15
M2189 3 256 275 3 nfet_01v8 L=1.5e-07 W=7.6e-07 $X=152740 $Y=54410 $dt=15
M2190 3 257 276 3 nfet_01v8 L=1.5e-07 W=7.6e-07 $X=152740 $Y=62690 $dt=15
M2191 3 258 277 3 nfet_01v8 L=1.5e-07 W=7.6e-07 $X=152740 $Y=70970 $dt=15
M2192 3 259 278 3 nfet_01v8 L=1.5e-07 W=7.6e-07 $X=152740 $Y=79250 $dt=15
M2193 3 260 279 3 nfet_01v8 L=1.5e-07 W=7.6e-07 $X=152740 $Y=87530 $dt=15
M2194 3 261 280 3 nfet_01v8 L=1.5e-07 W=7.6e-07 $X=152740 $Y=95810 $dt=15
M2195 3 262 281 3 nfet_01v8 L=1.5e-07 W=7.6e-07 $X=152740 $Y=104090 $dt=15
M2196 3 263 282 3 nfet_01v8 L=1.5e-07 W=7.6e-07 $X=152740 $Y=112370 $dt=15
M2197 3 264 283 3 nfet_01v8 L=1.5e-07 W=7.6e-07 $X=152740 $Y=120650 $dt=15
M2198 3 265 284 3 nfet_01v8 L=1.5e-07 W=7.6e-07 $X=152740 $Y=128930 $dt=15
M2199 3 266 285 3 nfet_01v8 L=1.5e-07 W=7.6e-07 $X=152740 $Y=137210 $dt=15
M2200 3 267 286 3 nfet_01v8 L=1.5e-07 W=7.6e-07 $X=152740 $Y=145490 $dt=15
M2201 3 268 287 3 nfet_01v8 L=1.5e-07 W=7.6e-07 $X=152740 $Y=153770 $dt=15
M2202 3 269 288 3 nfet_01v8 L=1.5e-07 W=7.6e-07 $X=152740 $Y=162050 $dt=15
M2203 289 118 3 3 nfet_01v8 L=1.5e-07 W=7.6e-07 $X=153110 $Y=11070 $dt=15
M2204 290 119 3 3 nfet_01v8 L=1.5e-07 W=7.6e-07 $X=153110 $Y=19350 $dt=15
M2205 291 120 3 3 nfet_01v8 L=1.5e-07 W=7.6e-07 $X=153110 $Y=27630 $dt=15
M2206 292 121 3 3 nfet_01v8 L=1.5e-07 W=7.6e-07 $X=153110 $Y=35910 $dt=15
M2207 293 122 3 3 nfet_01v8 L=1.5e-07 W=7.6e-07 $X=153110 $Y=44190 $dt=15
M2208 294 123 3 3 nfet_01v8 L=1.5e-07 W=7.6e-07 $X=153110 $Y=52470 $dt=15
M2209 295 124 3 3 nfet_01v8 L=1.5e-07 W=7.6e-07 $X=153110 $Y=60750 $dt=15
M2210 296 125 3 3 nfet_01v8 L=1.5e-07 W=7.6e-07 $X=153110 $Y=69030 $dt=15
M2211 297 126 3 3 nfet_01v8 L=1.5e-07 W=7.6e-07 $X=153110 $Y=77310 $dt=15
M2212 298 127 3 3 nfet_01v8 L=1.5e-07 W=7.6e-07 $X=153110 $Y=85590 $dt=15
M2213 299 128 3 3 nfet_01v8 L=1.5e-07 W=7.6e-07 $X=153110 $Y=93870 $dt=15
M2214 300 129 3 3 nfet_01v8 L=1.5e-07 W=7.6e-07 $X=153110 $Y=102150 $dt=15
M2215 301 130 3 3 nfet_01v8 L=1.5e-07 W=7.6e-07 $X=153110 $Y=110430 $dt=15
M2216 302 131 3 3 nfet_01v8 L=1.5e-07 W=7.6e-07 $X=153110 $Y=118710 $dt=15
M2217 303 132 3 3 nfet_01v8 L=1.5e-07 W=7.6e-07 $X=153110 $Y=126990 $dt=15
M2218 304 133 3 3 nfet_01v8 L=1.5e-07 W=7.6e-07 $X=153110 $Y=135270 $dt=15
M2219 305 134 3 3 nfet_01v8 L=1.5e-07 W=7.6e-07 $X=153110 $Y=143550 $dt=15
M2220 306 135 3 3 nfet_01v8 L=1.5e-07 W=7.6e-07 $X=153110 $Y=151830 $dt=15
M2221 307 136 3 3 nfet_01v8 L=1.5e-07 W=7.6e-07 $X=153110 $Y=160110 $dt=15
M2222 270 251 3 3 nfet_01v8 L=1.5e-07 W=7.6e-07 $X=153170 $Y=13010 $dt=15
M2223 271 252 3 3 nfet_01v8 L=1.5e-07 W=7.6e-07 $X=153170 $Y=21290 $dt=15
M2224 272 253 3 3 nfet_01v8 L=1.5e-07 W=7.6e-07 $X=153170 $Y=29570 $dt=15
M2225 273 254 3 3 nfet_01v8 L=1.5e-07 W=7.6e-07 $X=153170 $Y=37850 $dt=15
M2226 274 255 3 3 nfet_01v8 L=1.5e-07 W=7.6e-07 $X=153170 $Y=46130 $dt=15
M2227 275 256 3 3 nfet_01v8 L=1.5e-07 W=7.6e-07 $X=153170 $Y=54410 $dt=15
M2228 276 257 3 3 nfet_01v8 L=1.5e-07 W=7.6e-07 $X=153170 $Y=62690 $dt=15
M2229 277 258 3 3 nfet_01v8 L=1.5e-07 W=7.6e-07 $X=153170 $Y=70970 $dt=15
M2230 278 259 3 3 nfet_01v8 L=1.5e-07 W=7.6e-07 $X=153170 $Y=79250 $dt=15
M2231 279 260 3 3 nfet_01v8 L=1.5e-07 W=7.6e-07 $X=153170 $Y=87530 $dt=15
M2232 280 261 3 3 nfet_01v8 L=1.5e-07 W=7.6e-07 $X=153170 $Y=95810 $dt=15
M2233 281 262 3 3 nfet_01v8 L=1.5e-07 W=7.6e-07 $X=153170 $Y=104090 $dt=15
M2234 282 263 3 3 nfet_01v8 L=1.5e-07 W=7.6e-07 $X=153170 $Y=112370 $dt=15
M2235 283 264 3 3 nfet_01v8 L=1.5e-07 W=7.6e-07 $X=153170 $Y=120650 $dt=15
M2236 284 265 3 3 nfet_01v8 L=1.5e-07 W=7.6e-07 $X=153170 $Y=128930 $dt=15
M2237 285 266 3 3 nfet_01v8 L=1.5e-07 W=7.6e-07 $X=153170 $Y=137210 $dt=15
M2238 286 267 3 3 nfet_01v8 L=1.5e-07 W=7.6e-07 $X=153170 $Y=145490 $dt=15
M2239 287 268 3 3 nfet_01v8 L=1.5e-07 W=7.6e-07 $X=153170 $Y=153770 $dt=15
M2240 288 269 3 3 nfet_01v8 L=1.5e-07 W=7.6e-07 $X=153170 $Y=162050 $dt=15
M2241 3 118 289 3 nfet_01v8 L=1.5e-07 W=7.6e-07 $X=153540 $Y=11070 $dt=15
M2242 3 119 290 3 nfet_01v8 L=1.5e-07 W=7.6e-07 $X=153540 $Y=19350 $dt=15
M2243 3 120 291 3 nfet_01v8 L=1.5e-07 W=7.6e-07 $X=153540 $Y=27630 $dt=15
M2244 3 121 292 3 nfet_01v8 L=1.5e-07 W=7.6e-07 $X=153540 $Y=35910 $dt=15
M2245 3 122 293 3 nfet_01v8 L=1.5e-07 W=7.6e-07 $X=153540 $Y=44190 $dt=15
M2246 3 123 294 3 nfet_01v8 L=1.5e-07 W=7.6e-07 $X=153540 $Y=52470 $dt=15
M2247 3 124 295 3 nfet_01v8 L=1.5e-07 W=7.6e-07 $X=153540 $Y=60750 $dt=15
M2248 3 125 296 3 nfet_01v8 L=1.5e-07 W=7.6e-07 $X=153540 $Y=69030 $dt=15
M2249 3 126 297 3 nfet_01v8 L=1.5e-07 W=7.6e-07 $X=153540 $Y=77310 $dt=15
M2250 3 127 298 3 nfet_01v8 L=1.5e-07 W=7.6e-07 $X=153540 $Y=85590 $dt=15
M2251 3 128 299 3 nfet_01v8 L=1.5e-07 W=7.6e-07 $X=153540 $Y=93870 $dt=15
M2252 3 129 300 3 nfet_01v8 L=1.5e-07 W=7.6e-07 $X=153540 $Y=102150 $dt=15
M2253 3 130 301 3 nfet_01v8 L=1.5e-07 W=7.6e-07 $X=153540 $Y=110430 $dt=15
M2254 3 131 302 3 nfet_01v8 L=1.5e-07 W=7.6e-07 $X=153540 $Y=118710 $dt=15
M2255 3 132 303 3 nfet_01v8 L=1.5e-07 W=7.6e-07 $X=153540 $Y=126990 $dt=15
M2256 3 133 304 3 nfet_01v8 L=1.5e-07 W=7.6e-07 $X=153540 $Y=135270 $dt=15
M2257 3 134 305 3 nfet_01v8 L=1.5e-07 W=7.6e-07 $X=153540 $Y=143550 $dt=15
M2258 3 135 306 3 nfet_01v8 L=1.5e-07 W=7.6e-07 $X=153540 $Y=151830 $dt=15
M2259 3 136 307 3 nfet_01v8 L=1.5e-07 W=7.6e-07 $X=153540 $Y=160110 $dt=15
M2260 3 251 270 3 nfet_01v8 L=1.5e-07 W=7.6e-07 $X=153600 $Y=13010 $dt=15
M2261 3 252 271 3 nfet_01v8 L=1.5e-07 W=7.6e-07 $X=153600 $Y=21290 $dt=15
M2262 3 253 272 3 nfet_01v8 L=1.5e-07 W=7.6e-07 $X=153600 $Y=29570 $dt=15
M2263 3 254 273 3 nfet_01v8 L=1.5e-07 W=7.6e-07 $X=153600 $Y=37850 $dt=15
M2264 3 255 274 3 nfet_01v8 L=1.5e-07 W=7.6e-07 $X=153600 $Y=46130 $dt=15
M2265 3 256 275 3 nfet_01v8 L=1.5e-07 W=7.6e-07 $X=153600 $Y=54410 $dt=15
M2266 3 257 276 3 nfet_01v8 L=1.5e-07 W=7.6e-07 $X=153600 $Y=62690 $dt=15
M2267 3 258 277 3 nfet_01v8 L=1.5e-07 W=7.6e-07 $X=153600 $Y=70970 $dt=15
M2268 3 259 278 3 nfet_01v8 L=1.5e-07 W=7.6e-07 $X=153600 $Y=79250 $dt=15
M2269 3 260 279 3 nfet_01v8 L=1.5e-07 W=7.6e-07 $X=153600 $Y=87530 $dt=15
M2270 3 261 280 3 nfet_01v8 L=1.5e-07 W=7.6e-07 $X=153600 $Y=95810 $dt=15
M2271 3 262 281 3 nfet_01v8 L=1.5e-07 W=7.6e-07 $X=153600 $Y=104090 $dt=15
M2272 3 263 282 3 nfet_01v8 L=1.5e-07 W=7.6e-07 $X=153600 $Y=112370 $dt=15
M2273 3 264 283 3 nfet_01v8 L=1.5e-07 W=7.6e-07 $X=153600 $Y=120650 $dt=15
M2274 3 265 284 3 nfet_01v8 L=1.5e-07 W=7.6e-07 $X=153600 $Y=128930 $dt=15
M2275 3 266 285 3 nfet_01v8 L=1.5e-07 W=7.6e-07 $X=153600 $Y=137210 $dt=15
M2276 3 267 286 3 nfet_01v8 L=1.5e-07 W=7.6e-07 $X=153600 $Y=145490 $dt=15
M2277 3 268 287 3 nfet_01v8 L=1.5e-07 W=7.6e-07 $X=153600 $Y=153770 $dt=15
M2278 3 269 288 3 nfet_01v8 L=1.5e-07 W=7.6e-07 $X=153600 $Y=162050 $dt=15
M2279 251 118 3 3 nfet_01v8 L=1.5e-07 W=7.6e-07 $X=154030 $Y=13010 $dt=15
M2280 252 119 3 3 nfet_01v8 L=1.5e-07 W=7.6e-07 $X=154030 $Y=21290 $dt=15
M2281 253 120 3 3 nfet_01v8 L=1.5e-07 W=7.6e-07 $X=154030 $Y=29570 $dt=15
M2282 254 121 3 3 nfet_01v8 L=1.5e-07 W=7.6e-07 $X=154030 $Y=37850 $dt=15
M2283 255 122 3 3 nfet_01v8 L=1.5e-07 W=7.6e-07 $X=154030 $Y=46130 $dt=15
M2284 256 123 3 3 nfet_01v8 L=1.5e-07 W=7.6e-07 $X=154030 $Y=54410 $dt=15
M2285 257 124 3 3 nfet_01v8 L=1.5e-07 W=7.6e-07 $X=154030 $Y=62690 $dt=15
M2286 258 125 3 3 nfet_01v8 L=1.5e-07 W=7.6e-07 $X=154030 $Y=70970 $dt=15
M2287 259 126 3 3 nfet_01v8 L=1.5e-07 W=7.6e-07 $X=154030 $Y=79250 $dt=15
M2288 260 127 3 3 nfet_01v8 L=1.5e-07 W=7.6e-07 $X=154030 $Y=87530 $dt=15
M2289 261 128 3 3 nfet_01v8 L=1.5e-07 W=7.6e-07 $X=154030 $Y=95810 $dt=15
M2290 262 129 3 3 nfet_01v8 L=1.5e-07 W=7.6e-07 $X=154030 $Y=104090 $dt=15
M2291 263 130 3 3 nfet_01v8 L=1.5e-07 W=7.6e-07 $X=154030 $Y=112370 $dt=15
M2292 264 131 3 3 nfet_01v8 L=1.5e-07 W=7.6e-07 $X=154030 $Y=120650 $dt=15
M2293 265 132 3 3 nfet_01v8 L=1.5e-07 W=7.6e-07 $X=154030 $Y=128930 $dt=15
M2294 266 133 3 3 nfet_01v8 L=1.5e-07 W=7.6e-07 $X=154030 $Y=137210 $dt=15
M2295 267 134 3 3 nfet_01v8 L=1.5e-07 W=7.6e-07 $X=154030 $Y=145490 $dt=15
M2296 268 135 3 3 nfet_01v8 L=1.5e-07 W=7.6e-07 $X=154030 $Y=153770 $dt=15
M2297 269 136 3 3 nfet_01v8 L=1.5e-07 W=7.6e-07 $X=154030 $Y=162050 $dt=15
M2298 3 118 251 3 nfet_01v8 L=1.5e-07 W=7.6e-07 $X=154460 $Y=13010 $dt=15
M2299 3 119 252 3 nfet_01v8 L=1.5e-07 W=7.6e-07 $X=154460 $Y=21290 $dt=15
M2300 3 120 253 3 nfet_01v8 L=1.5e-07 W=7.6e-07 $X=154460 $Y=29570 $dt=15
M2301 3 121 254 3 nfet_01v8 L=1.5e-07 W=7.6e-07 $X=154460 $Y=37850 $dt=15
M2302 3 122 255 3 nfet_01v8 L=1.5e-07 W=7.6e-07 $X=154460 $Y=46130 $dt=15
M2303 3 123 256 3 nfet_01v8 L=1.5e-07 W=7.6e-07 $X=154460 $Y=54410 $dt=15
M2304 3 124 257 3 nfet_01v8 L=1.5e-07 W=7.6e-07 $X=154460 $Y=62690 $dt=15
M2305 3 125 258 3 nfet_01v8 L=1.5e-07 W=7.6e-07 $X=154460 $Y=70970 $dt=15
M2306 3 126 259 3 nfet_01v8 L=1.5e-07 W=7.6e-07 $X=154460 $Y=79250 $dt=15
M2307 3 127 260 3 nfet_01v8 L=1.5e-07 W=7.6e-07 $X=154460 $Y=87530 $dt=15
M2308 3 128 261 3 nfet_01v8 L=1.5e-07 W=7.6e-07 $X=154460 $Y=95810 $dt=15
M2309 3 129 262 3 nfet_01v8 L=1.5e-07 W=7.6e-07 $X=154460 $Y=104090 $dt=15
M2310 3 130 263 3 nfet_01v8 L=1.5e-07 W=7.6e-07 $X=154460 $Y=112370 $dt=15
M2311 3 131 264 3 nfet_01v8 L=1.5e-07 W=7.6e-07 $X=154460 $Y=120650 $dt=15
M2312 3 132 265 3 nfet_01v8 L=1.5e-07 W=7.6e-07 $X=154460 $Y=128930 $dt=15
M2313 3 133 266 3 nfet_01v8 L=1.5e-07 W=7.6e-07 $X=154460 $Y=137210 $dt=15
M2314 3 134 267 3 nfet_01v8 L=1.5e-07 W=7.6e-07 $X=154460 $Y=145490 $dt=15
M2315 3 135 268 3 nfet_01v8 L=1.5e-07 W=7.6e-07 $X=154460 $Y=153770 $dt=15
M2316 3 136 269 3 nfet_01v8 L=1.5e-07 W=7.6e-07 $X=154460 $Y=162050 $dt=15
M2317 232 194 3 3 nfet_01v8 L=1.5e-07 W=7.6e-07 $X=155500 $Y=13010 $dt=15
M2318 233 195 3 3 nfet_01v8 L=1.5e-07 W=7.6e-07 $X=155500 $Y=21290 $dt=15
M2319 234 196 3 3 nfet_01v8 L=1.5e-07 W=7.6e-07 $X=155500 $Y=29570 $dt=15
M2320 235 197 3 3 nfet_01v8 L=1.5e-07 W=7.6e-07 $X=155500 $Y=37850 $dt=15
M2321 236 198 3 3 nfet_01v8 L=1.5e-07 W=7.6e-07 $X=155500 $Y=46130 $dt=15
M2322 237 199 3 3 nfet_01v8 L=1.5e-07 W=7.6e-07 $X=155500 $Y=54410 $dt=15
M2323 238 200 3 3 nfet_01v8 L=1.5e-07 W=7.6e-07 $X=155500 $Y=62690 $dt=15
M2324 239 201 3 3 nfet_01v8 L=1.5e-07 W=7.6e-07 $X=155500 $Y=70970 $dt=15
M2325 240 202 3 3 nfet_01v8 L=1.5e-07 W=7.6e-07 $X=155500 $Y=79250 $dt=15
M2326 241 203 3 3 nfet_01v8 L=1.5e-07 W=7.6e-07 $X=155500 $Y=87530 $dt=15
M2327 242 204 3 3 nfet_01v8 L=1.5e-07 W=7.6e-07 $X=155500 $Y=95810 $dt=15
M2328 243 205 3 3 nfet_01v8 L=1.5e-07 W=7.6e-07 $X=155500 $Y=104090 $dt=15
M2329 244 206 3 3 nfet_01v8 L=1.5e-07 W=7.6e-07 $X=155500 $Y=112370 $dt=15
M2330 245 207 3 3 nfet_01v8 L=1.5e-07 W=7.6e-07 $X=155500 $Y=120650 $dt=15
M2331 246 208 3 3 nfet_01v8 L=1.5e-07 W=7.6e-07 $X=155500 $Y=128930 $dt=15
M2332 247 209 3 3 nfet_01v8 L=1.5e-07 W=7.6e-07 $X=155500 $Y=137210 $dt=15
M2333 248 210 3 3 nfet_01v8 L=1.5e-07 W=7.6e-07 $X=155500 $Y=145490 $dt=15
M2334 249 211 3 3 nfet_01v8 L=1.5e-07 W=7.6e-07 $X=155500 $Y=153770 $dt=15
M2335 250 212 3 3 nfet_01v8 L=1.5e-07 W=7.6e-07 $X=155500 $Y=162050 $dt=15
M2336 213 99 3 3 nfet_01v8 L=1.5e-07 W=7.6e-07 $X=155930 $Y=11070 $dt=15
M2337 3 194 232 3 nfet_01v8 L=1.5e-07 W=7.6e-07 $X=155930 $Y=13010 $dt=15
M2338 214 100 3 3 nfet_01v8 L=1.5e-07 W=7.6e-07 $X=155930 $Y=19350 $dt=15
M2339 3 195 233 3 nfet_01v8 L=1.5e-07 W=7.6e-07 $X=155930 $Y=21290 $dt=15
M2340 215 101 3 3 nfet_01v8 L=1.5e-07 W=7.6e-07 $X=155930 $Y=27630 $dt=15
M2341 3 196 234 3 nfet_01v8 L=1.5e-07 W=7.6e-07 $X=155930 $Y=29570 $dt=15
M2342 216 102 3 3 nfet_01v8 L=1.5e-07 W=7.6e-07 $X=155930 $Y=35910 $dt=15
M2343 3 197 235 3 nfet_01v8 L=1.5e-07 W=7.6e-07 $X=155930 $Y=37850 $dt=15
M2344 217 103 3 3 nfet_01v8 L=1.5e-07 W=7.6e-07 $X=155930 $Y=44190 $dt=15
M2345 3 198 236 3 nfet_01v8 L=1.5e-07 W=7.6e-07 $X=155930 $Y=46130 $dt=15
M2346 218 104 3 3 nfet_01v8 L=1.5e-07 W=7.6e-07 $X=155930 $Y=52470 $dt=15
M2347 3 199 237 3 nfet_01v8 L=1.5e-07 W=7.6e-07 $X=155930 $Y=54410 $dt=15
M2348 219 105 3 3 nfet_01v8 L=1.5e-07 W=7.6e-07 $X=155930 $Y=60750 $dt=15
M2349 3 200 238 3 nfet_01v8 L=1.5e-07 W=7.6e-07 $X=155930 $Y=62690 $dt=15
M2350 220 106 3 3 nfet_01v8 L=1.5e-07 W=7.6e-07 $X=155930 $Y=69030 $dt=15
M2351 3 201 239 3 nfet_01v8 L=1.5e-07 W=7.6e-07 $X=155930 $Y=70970 $dt=15
M2352 221 107 3 3 nfet_01v8 L=1.5e-07 W=7.6e-07 $X=155930 $Y=77310 $dt=15
M2353 3 202 240 3 nfet_01v8 L=1.5e-07 W=7.6e-07 $X=155930 $Y=79250 $dt=15
M2354 222 108 3 3 nfet_01v8 L=1.5e-07 W=7.6e-07 $X=155930 $Y=85590 $dt=15
M2355 3 203 241 3 nfet_01v8 L=1.5e-07 W=7.6e-07 $X=155930 $Y=87530 $dt=15
M2356 223 109 3 3 nfet_01v8 L=1.5e-07 W=7.6e-07 $X=155930 $Y=93870 $dt=15
M2357 3 204 242 3 nfet_01v8 L=1.5e-07 W=7.6e-07 $X=155930 $Y=95810 $dt=15
M2358 224 110 3 3 nfet_01v8 L=1.5e-07 W=7.6e-07 $X=155930 $Y=102150 $dt=15
M2359 3 205 243 3 nfet_01v8 L=1.5e-07 W=7.6e-07 $X=155930 $Y=104090 $dt=15
M2360 225 111 3 3 nfet_01v8 L=1.5e-07 W=7.6e-07 $X=155930 $Y=110430 $dt=15
M2361 3 206 244 3 nfet_01v8 L=1.5e-07 W=7.6e-07 $X=155930 $Y=112370 $dt=15
M2362 226 112 3 3 nfet_01v8 L=1.5e-07 W=7.6e-07 $X=155930 $Y=118710 $dt=15
M2363 3 207 245 3 nfet_01v8 L=1.5e-07 W=7.6e-07 $X=155930 $Y=120650 $dt=15
M2364 227 113 3 3 nfet_01v8 L=1.5e-07 W=7.6e-07 $X=155930 $Y=126990 $dt=15
M2365 3 208 246 3 nfet_01v8 L=1.5e-07 W=7.6e-07 $X=155930 $Y=128930 $dt=15
M2366 228 114 3 3 nfet_01v8 L=1.5e-07 W=7.6e-07 $X=155930 $Y=135270 $dt=15
M2367 3 209 247 3 nfet_01v8 L=1.5e-07 W=7.6e-07 $X=155930 $Y=137210 $dt=15
M2368 229 115 3 3 nfet_01v8 L=1.5e-07 W=7.6e-07 $X=155930 $Y=143550 $dt=15
M2369 3 210 248 3 nfet_01v8 L=1.5e-07 W=7.6e-07 $X=155930 $Y=145490 $dt=15
M2370 230 116 3 3 nfet_01v8 L=1.5e-07 W=7.6e-07 $X=155930 $Y=151830 $dt=15
M2371 3 211 249 3 nfet_01v8 L=1.5e-07 W=7.6e-07 $X=155930 $Y=153770 $dt=15
M2372 231 117 3 3 nfet_01v8 L=1.5e-07 W=7.6e-07 $X=155930 $Y=160110 $dt=15
M2373 3 212 250 3 nfet_01v8 L=1.5e-07 W=7.6e-07 $X=155930 $Y=162050 $dt=15
M2374 3 99 213 3 nfet_01v8 L=1.5e-07 W=7.6e-07 $X=156360 $Y=11070 $dt=15
M2375 232 194 3 3 nfet_01v8 L=1.5e-07 W=7.6e-07 $X=156360 $Y=13010 $dt=15
M2376 3 100 214 3 nfet_01v8 L=1.5e-07 W=7.6e-07 $X=156360 $Y=19350 $dt=15
M2377 233 195 3 3 nfet_01v8 L=1.5e-07 W=7.6e-07 $X=156360 $Y=21290 $dt=15
M2378 3 101 215 3 nfet_01v8 L=1.5e-07 W=7.6e-07 $X=156360 $Y=27630 $dt=15
M2379 234 196 3 3 nfet_01v8 L=1.5e-07 W=7.6e-07 $X=156360 $Y=29570 $dt=15
M2380 3 102 216 3 nfet_01v8 L=1.5e-07 W=7.6e-07 $X=156360 $Y=35910 $dt=15
M2381 235 197 3 3 nfet_01v8 L=1.5e-07 W=7.6e-07 $X=156360 $Y=37850 $dt=15
M2382 3 103 217 3 nfet_01v8 L=1.5e-07 W=7.6e-07 $X=156360 $Y=44190 $dt=15
M2383 236 198 3 3 nfet_01v8 L=1.5e-07 W=7.6e-07 $X=156360 $Y=46130 $dt=15
M2384 3 104 218 3 nfet_01v8 L=1.5e-07 W=7.6e-07 $X=156360 $Y=52470 $dt=15
M2385 237 199 3 3 nfet_01v8 L=1.5e-07 W=7.6e-07 $X=156360 $Y=54410 $dt=15
M2386 3 105 219 3 nfet_01v8 L=1.5e-07 W=7.6e-07 $X=156360 $Y=60750 $dt=15
M2387 238 200 3 3 nfet_01v8 L=1.5e-07 W=7.6e-07 $X=156360 $Y=62690 $dt=15
M2388 3 106 220 3 nfet_01v8 L=1.5e-07 W=7.6e-07 $X=156360 $Y=69030 $dt=15
M2389 239 201 3 3 nfet_01v8 L=1.5e-07 W=7.6e-07 $X=156360 $Y=70970 $dt=15
M2390 3 107 221 3 nfet_01v8 L=1.5e-07 W=7.6e-07 $X=156360 $Y=77310 $dt=15
M2391 240 202 3 3 nfet_01v8 L=1.5e-07 W=7.6e-07 $X=156360 $Y=79250 $dt=15
M2392 3 108 222 3 nfet_01v8 L=1.5e-07 W=7.6e-07 $X=156360 $Y=85590 $dt=15
M2393 241 203 3 3 nfet_01v8 L=1.5e-07 W=7.6e-07 $X=156360 $Y=87530 $dt=15
M2394 3 109 223 3 nfet_01v8 L=1.5e-07 W=7.6e-07 $X=156360 $Y=93870 $dt=15
M2395 242 204 3 3 nfet_01v8 L=1.5e-07 W=7.6e-07 $X=156360 $Y=95810 $dt=15
M2396 3 110 224 3 nfet_01v8 L=1.5e-07 W=7.6e-07 $X=156360 $Y=102150 $dt=15
M2397 243 205 3 3 nfet_01v8 L=1.5e-07 W=7.6e-07 $X=156360 $Y=104090 $dt=15
M2398 3 111 225 3 nfet_01v8 L=1.5e-07 W=7.6e-07 $X=156360 $Y=110430 $dt=15
M2399 244 206 3 3 nfet_01v8 L=1.5e-07 W=7.6e-07 $X=156360 $Y=112370 $dt=15
M2400 3 112 226 3 nfet_01v8 L=1.5e-07 W=7.6e-07 $X=156360 $Y=118710 $dt=15
M2401 245 207 3 3 nfet_01v8 L=1.5e-07 W=7.6e-07 $X=156360 $Y=120650 $dt=15
M2402 3 113 227 3 nfet_01v8 L=1.5e-07 W=7.6e-07 $X=156360 $Y=126990 $dt=15
M2403 246 208 3 3 nfet_01v8 L=1.5e-07 W=7.6e-07 $X=156360 $Y=128930 $dt=15
M2404 3 114 228 3 nfet_01v8 L=1.5e-07 W=7.6e-07 $X=156360 $Y=135270 $dt=15
M2405 247 209 3 3 nfet_01v8 L=1.5e-07 W=7.6e-07 $X=156360 $Y=137210 $dt=15
M2406 3 115 229 3 nfet_01v8 L=1.5e-07 W=7.6e-07 $X=156360 $Y=143550 $dt=15
M2407 248 210 3 3 nfet_01v8 L=1.5e-07 W=7.6e-07 $X=156360 $Y=145490 $dt=15
M2408 3 116 230 3 nfet_01v8 L=1.5e-07 W=7.6e-07 $X=156360 $Y=151830 $dt=15
M2409 249 211 3 3 nfet_01v8 L=1.5e-07 W=7.6e-07 $X=156360 $Y=153770 $dt=15
M2410 3 117 231 3 nfet_01v8 L=1.5e-07 W=7.6e-07 $X=156360 $Y=160110 $dt=15
M2411 250 212 3 3 nfet_01v8 L=1.5e-07 W=7.6e-07 $X=156360 $Y=162050 $dt=15
M2412 213 99 3 3 nfet_01v8 L=1.5e-07 W=7.6e-07 $X=156790 $Y=11070 $dt=15
M2413 3 194 232 3 nfet_01v8 L=1.5e-07 W=7.6e-07 $X=156790 $Y=13010 $dt=15
M2414 214 100 3 3 nfet_01v8 L=1.5e-07 W=7.6e-07 $X=156790 $Y=19350 $dt=15
M2415 3 195 233 3 nfet_01v8 L=1.5e-07 W=7.6e-07 $X=156790 $Y=21290 $dt=15
M2416 215 101 3 3 nfet_01v8 L=1.5e-07 W=7.6e-07 $X=156790 $Y=27630 $dt=15
M2417 3 196 234 3 nfet_01v8 L=1.5e-07 W=7.6e-07 $X=156790 $Y=29570 $dt=15
M2418 216 102 3 3 nfet_01v8 L=1.5e-07 W=7.6e-07 $X=156790 $Y=35910 $dt=15
M2419 3 197 235 3 nfet_01v8 L=1.5e-07 W=7.6e-07 $X=156790 $Y=37850 $dt=15
M2420 217 103 3 3 nfet_01v8 L=1.5e-07 W=7.6e-07 $X=156790 $Y=44190 $dt=15
M2421 3 198 236 3 nfet_01v8 L=1.5e-07 W=7.6e-07 $X=156790 $Y=46130 $dt=15
M2422 218 104 3 3 nfet_01v8 L=1.5e-07 W=7.6e-07 $X=156790 $Y=52470 $dt=15
M2423 3 199 237 3 nfet_01v8 L=1.5e-07 W=7.6e-07 $X=156790 $Y=54410 $dt=15
M2424 219 105 3 3 nfet_01v8 L=1.5e-07 W=7.6e-07 $X=156790 $Y=60750 $dt=15
M2425 3 200 238 3 nfet_01v8 L=1.5e-07 W=7.6e-07 $X=156790 $Y=62690 $dt=15
M2426 220 106 3 3 nfet_01v8 L=1.5e-07 W=7.6e-07 $X=156790 $Y=69030 $dt=15
M2427 3 201 239 3 nfet_01v8 L=1.5e-07 W=7.6e-07 $X=156790 $Y=70970 $dt=15
M2428 221 107 3 3 nfet_01v8 L=1.5e-07 W=7.6e-07 $X=156790 $Y=77310 $dt=15
M2429 3 202 240 3 nfet_01v8 L=1.5e-07 W=7.6e-07 $X=156790 $Y=79250 $dt=15
M2430 222 108 3 3 nfet_01v8 L=1.5e-07 W=7.6e-07 $X=156790 $Y=85590 $dt=15
M2431 3 203 241 3 nfet_01v8 L=1.5e-07 W=7.6e-07 $X=156790 $Y=87530 $dt=15
M2432 223 109 3 3 nfet_01v8 L=1.5e-07 W=7.6e-07 $X=156790 $Y=93870 $dt=15
M2433 3 204 242 3 nfet_01v8 L=1.5e-07 W=7.6e-07 $X=156790 $Y=95810 $dt=15
M2434 224 110 3 3 nfet_01v8 L=1.5e-07 W=7.6e-07 $X=156790 $Y=102150 $dt=15
M2435 3 205 243 3 nfet_01v8 L=1.5e-07 W=7.6e-07 $X=156790 $Y=104090 $dt=15
M2436 225 111 3 3 nfet_01v8 L=1.5e-07 W=7.6e-07 $X=156790 $Y=110430 $dt=15
M2437 3 206 244 3 nfet_01v8 L=1.5e-07 W=7.6e-07 $X=156790 $Y=112370 $dt=15
M2438 226 112 3 3 nfet_01v8 L=1.5e-07 W=7.6e-07 $X=156790 $Y=118710 $dt=15
M2439 3 207 245 3 nfet_01v8 L=1.5e-07 W=7.6e-07 $X=156790 $Y=120650 $dt=15
M2440 227 113 3 3 nfet_01v8 L=1.5e-07 W=7.6e-07 $X=156790 $Y=126990 $dt=15
M2441 3 208 246 3 nfet_01v8 L=1.5e-07 W=7.6e-07 $X=156790 $Y=128930 $dt=15
M2442 228 114 3 3 nfet_01v8 L=1.5e-07 W=7.6e-07 $X=156790 $Y=135270 $dt=15
M2443 3 209 247 3 nfet_01v8 L=1.5e-07 W=7.6e-07 $X=156790 $Y=137210 $dt=15
M2444 229 115 3 3 nfet_01v8 L=1.5e-07 W=7.6e-07 $X=156790 $Y=143550 $dt=15
M2445 3 210 248 3 nfet_01v8 L=1.5e-07 W=7.6e-07 $X=156790 $Y=145490 $dt=15
M2446 230 116 3 3 nfet_01v8 L=1.5e-07 W=7.6e-07 $X=156790 $Y=151830 $dt=15
M2447 3 211 249 3 nfet_01v8 L=1.5e-07 W=7.6e-07 $X=156790 $Y=153770 $dt=15
M2448 231 117 3 3 nfet_01v8 L=1.5e-07 W=7.6e-07 $X=156790 $Y=160110 $dt=15
M2449 3 212 250 3 nfet_01v8 L=1.5e-07 W=7.6e-07 $X=156790 $Y=162050 $dt=15
M2450 3 99 213 3 nfet_01v8 L=1.5e-07 W=7.6e-07 $X=157220 $Y=11070 $dt=15
M2451 194 23 3 3 nfet_01v8 L=1.5e-07 W=7.6e-07 $X=157220 $Y=13010 $dt=15
M2452 3 100 214 3 nfet_01v8 L=1.5e-07 W=7.6e-07 $X=157220 $Y=19350 $dt=15
M2453 195 24 3 3 nfet_01v8 L=1.5e-07 W=7.6e-07 $X=157220 $Y=21290 $dt=15
M2454 3 101 215 3 nfet_01v8 L=1.5e-07 W=7.6e-07 $X=157220 $Y=27630 $dt=15
M2455 196 25 3 3 nfet_01v8 L=1.5e-07 W=7.6e-07 $X=157220 $Y=29570 $dt=15
M2456 3 102 216 3 nfet_01v8 L=1.5e-07 W=7.6e-07 $X=157220 $Y=35910 $dt=15
M2457 197 26 3 3 nfet_01v8 L=1.5e-07 W=7.6e-07 $X=157220 $Y=37850 $dt=15
M2458 3 103 217 3 nfet_01v8 L=1.5e-07 W=7.6e-07 $X=157220 $Y=44190 $dt=15
M2459 198 27 3 3 nfet_01v8 L=1.5e-07 W=7.6e-07 $X=157220 $Y=46130 $dt=15
M2460 3 104 218 3 nfet_01v8 L=1.5e-07 W=7.6e-07 $X=157220 $Y=52470 $dt=15
M2461 199 28 3 3 nfet_01v8 L=1.5e-07 W=7.6e-07 $X=157220 $Y=54410 $dt=15
M2462 3 105 219 3 nfet_01v8 L=1.5e-07 W=7.6e-07 $X=157220 $Y=60750 $dt=15
M2463 200 29 3 3 nfet_01v8 L=1.5e-07 W=7.6e-07 $X=157220 $Y=62690 $dt=15
M2464 3 106 220 3 nfet_01v8 L=1.5e-07 W=7.6e-07 $X=157220 $Y=69030 $dt=15
M2465 201 30 3 3 nfet_01v8 L=1.5e-07 W=7.6e-07 $X=157220 $Y=70970 $dt=15
M2466 3 107 221 3 nfet_01v8 L=1.5e-07 W=7.6e-07 $X=157220 $Y=77310 $dt=15
M2467 202 31 3 3 nfet_01v8 L=1.5e-07 W=7.6e-07 $X=157220 $Y=79250 $dt=15
M2468 3 108 222 3 nfet_01v8 L=1.5e-07 W=7.6e-07 $X=157220 $Y=85590 $dt=15
M2469 203 32 3 3 nfet_01v8 L=1.5e-07 W=7.6e-07 $X=157220 $Y=87530 $dt=15
M2470 3 109 223 3 nfet_01v8 L=1.5e-07 W=7.6e-07 $X=157220 $Y=93870 $dt=15
M2471 204 33 3 3 nfet_01v8 L=1.5e-07 W=7.6e-07 $X=157220 $Y=95810 $dt=15
M2472 3 110 224 3 nfet_01v8 L=1.5e-07 W=7.6e-07 $X=157220 $Y=102150 $dt=15
M2473 205 34 3 3 nfet_01v8 L=1.5e-07 W=7.6e-07 $X=157220 $Y=104090 $dt=15
M2474 3 111 225 3 nfet_01v8 L=1.5e-07 W=7.6e-07 $X=157220 $Y=110430 $dt=15
M2475 206 35 3 3 nfet_01v8 L=1.5e-07 W=7.6e-07 $X=157220 $Y=112370 $dt=15
M2476 3 112 226 3 nfet_01v8 L=1.5e-07 W=7.6e-07 $X=157220 $Y=118710 $dt=15
M2477 207 36 3 3 nfet_01v8 L=1.5e-07 W=7.6e-07 $X=157220 $Y=120650 $dt=15
M2478 3 113 227 3 nfet_01v8 L=1.5e-07 W=7.6e-07 $X=157220 $Y=126990 $dt=15
M2479 208 37 3 3 nfet_01v8 L=1.5e-07 W=7.6e-07 $X=157220 $Y=128930 $dt=15
M2480 3 114 228 3 nfet_01v8 L=1.5e-07 W=7.6e-07 $X=157220 $Y=135270 $dt=15
M2481 209 38 3 3 nfet_01v8 L=1.5e-07 W=7.6e-07 $X=157220 $Y=137210 $dt=15
M2482 3 115 229 3 nfet_01v8 L=1.5e-07 W=7.6e-07 $X=157220 $Y=143550 $dt=15
M2483 210 39 3 3 nfet_01v8 L=1.5e-07 W=7.6e-07 $X=157220 $Y=145490 $dt=15
M2484 3 116 230 3 nfet_01v8 L=1.5e-07 W=7.6e-07 $X=157220 $Y=151830 $dt=15
M2485 211 40 3 3 nfet_01v8 L=1.5e-07 W=7.6e-07 $X=157220 $Y=153770 $dt=15
M2486 3 117 231 3 nfet_01v8 L=1.5e-07 W=7.6e-07 $X=157220 $Y=160110 $dt=15
M2487 212 41 3 3 nfet_01v8 L=1.5e-07 W=7.6e-07 $X=157220 $Y=162050 $dt=15
M2488 175 23 3 3 nfet_01v8 L=1.5e-07 W=7.6e-07 $X=158230 $Y=11070 $dt=15
M2489 176 24 3 3 nfet_01v8 L=1.5e-07 W=7.6e-07 $X=158230 $Y=19350 $dt=15
M2490 177 25 3 3 nfet_01v8 L=1.5e-07 W=7.6e-07 $X=158230 $Y=27630 $dt=15
M2491 178 26 3 3 nfet_01v8 L=1.5e-07 W=7.6e-07 $X=158230 $Y=35910 $dt=15
M2492 179 27 3 3 nfet_01v8 L=1.5e-07 W=7.6e-07 $X=158230 $Y=44190 $dt=15
M2493 180 28 3 3 nfet_01v8 L=1.5e-07 W=7.6e-07 $X=158230 $Y=52470 $dt=15
M2494 181 29 3 3 nfet_01v8 L=1.5e-07 W=7.6e-07 $X=158230 $Y=60750 $dt=15
M2495 182 30 3 3 nfet_01v8 L=1.5e-07 W=7.6e-07 $X=158230 $Y=69030 $dt=15
M2496 183 31 3 3 nfet_01v8 L=1.5e-07 W=7.6e-07 $X=158230 $Y=77310 $dt=15
M2497 184 32 3 3 nfet_01v8 L=1.5e-07 W=7.6e-07 $X=158230 $Y=85590 $dt=15
M2498 185 33 3 3 nfet_01v8 L=1.5e-07 W=7.6e-07 $X=158230 $Y=93870 $dt=15
M2499 186 34 3 3 nfet_01v8 L=1.5e-07 W=7.6e-07 $X=158230 $Y=102150 $dt=15
M2500 187 35 3 3 nfet_01v8 L=1.5e-07 W=7.6e-07 $X=158230 $Y=110430 $dt=15
M2501 188 36 3 3 nfet_01v8 L=1.5e-07 W=7.6e-07 $X=158230 $Y=118710 $dt=15
M2502 189 37 3 3 nfet_01v8 L=1.5e-07 W=7.6e-07 $X=158230 $Y=126990 $dt=15
M2503 190 38 3 3 nfet_01v8 L=1.5e-07 W=7.6e-07 $X=158230 $Y=135270 $dt=15
M2504 191 39 3 3 nfet_01v8 L=1.5e-07 W=7.6e-07 $X=158230 $Y=143550 $dt=15
M2505 192 40 3 3 nfet_01v8 L=1.5e-07 W=7.6e-07 $X=158230 $Y=151830 $dt=15
M2506 193 41 3 3 nfet_01v8 L=1.5e-07 W=7.6e-07 $X=158230 $Y=160110 $dt=15
M2507 156 137 3 3 nfet_01v8 L=1.5e-07 W=7.6e-07 $X=158260 $Y=13010 $dt=15
M2508 157 138 3 3 nfet_01v8 L=1.5e-07 W=7.6e-07 $X=158260 $Y=21290 $dt=15
M2509 158 139 3 3 nfet_01v8 L=1.5e-07 W=7.6e-07 $X=158260 $Y=29570 $dt=15
M2510 159 140 3 3 nfet_01v8 L=1.5e-07 W=7.6e-07 $X=158260 $Y=37850 $dt=15
M2511 160 141 3 3 nfet_01v8 L=1.5e-07 W=7.6e-07 $X=158260 $Y=46130 $dt=15
M2512 161 142 3 3 nfet_01v8 L=1.5e-07 W=7.6e-07 $X=158260 $Y=54410 $dt=15
M2513 162 143 3 3 nfet_01v8 L=1.5e-07 W=7.6e-07 $X=158260 $Y=62690 $dt=15
M2514 163 144 3 3 nfet_01v8 L=1.5e-07 W=7.6e-07 $X=158260 $Y=70970 $dt=15
M2515 164 145 3 3 nfet_01v8 L=1.5e-07 W=7.6e-07 $X=158260 $Y=79250 $dt=15
M2516 165 146 3 3 nfet_01v8 L=1.5e-07 W=7.6e-07 $X=158260 $Y=87530 $dt=15
M2517 166 147 3 3 nfet_01v8 L=1.5e-07 W=7.6e-07 $X=158260 $Y=95810 $dt=15
M2518 167 148 3 3 nfet_01v8 L=1.5e-07 W=7.6e-07 $X=158260 $Y=104090 $dt=15
M2519 168 149 3 3 nfet_01v8 L=1.5e-07 W=7.6e-07 $X=158260 $Y=112370 $dt=15
M2520 169 150 3 3 nfet_01v8 L=1.5e-07 W=7.6e-07 $X=158260 $Y=120650 $dt=15
M2521 170 151 3 3 nfet_01v8 L=1.5e-07 W=7.6e-07 $X=158260 $Y=128930 $dt=15
M2522 171 152 3 3 nfet_01v8 L=1.5e-07 W=7.6e-07 $X=158260 $Y=137210 $dt=15
M2523 172 153 3 3 nfet_01v8 L=1.5e-07 W=7.6e-07 $X=158260 $Y=145490 $dt=15
M2524 173 154 3 3 nfet_01v8 L=1.5e-07 W=7.6e-07 $X=158260 $Y=153770 $dt=15
M2525 174 155 3 3 nfet_01v8 L=1.5e-07 W=7.6e-07 $X=158260 $Y=162050 $dt=15
M2526 3 23 175 3 nfet_01v8 L=1.5e-07 W=7.6e-07 $X=158660 $Y=11070 $dt=15
M2527 3 24 176 3 nfet_01v8 L=1.5e-07 W=7.6e-07 $X=158660 $Y=19350 $dt=15
M2528 3 25 177 3 nfet_01v8 L=1.5e-07 W=7.6e-07 $X=158660 $Y=27630 $dt=15
M2529 3 26 178 3 nfet_01v8 L=1.5e-07 W=7.6e-07 $X=158660 $Y=35910 $dt=15
M2530 3 27 179 3 nfet_01v8 L=1.5e-07 W=7.6e-07 $X=158660 $Y=44190 $dt=15
M2531 3 28 180 3 nfet_01v8 L=1.5e-07 W=7.6e-07 $X=158660 $Y=52470 $dt=15
M2532 3 29 181 3 nfet_01v8 L=1.5e-07 W=7.6e-07 $X=158660 $Y=60750 $dt=15
M2533 3 30 182 3 nfet_01v8 L=1.5e-07 W=7.6e-07 $X=158660 $Y=69030 $dt=15
M2534 3 31 183 3 nfet_01v8 L=1.5e-07 W=7.6e-07 $X=158660 $Y=77310 $dt=15
M2535 3 32 184 3 nfet_01v8 L=1.5e-07 W=7.6e-07 $X=158660 $Y=85590 $dt=15
M2536 3 33 185 3 nfet_01v8 L=1.5e-07 W=7.6e-07 $X=158660 $Y=93870 $dt=15
M2537 3 34 186 3 nfet_01v8 L=1.5e-07 W=7.6e-07 $X=158660 $Y=102150 $dt=15
M2538 3 35 187 3 nfet_01v8 L=1.5e-07 W=7.6e-07 $X=158660 $Y=110430 $dt=15
M2539 3 36 188 3 nfet_01v8 L=1.5e-07 W=7.6e-07 $X=158660 $Y=118710 $dt=15
M2540 3 37 189 3 nfet_01v8 L=1.5e-07 W=7.6e-07 $X=158660 $Y=126990 $dt=15
M2541 3 38 190 3 nfet_01v8 L=1.5e-07 W=7.6e-07 $X=158660 $Y=135270 $dt=15
M2542 3 39 191 3 nfet_01v8 L=1.5e-07 W=7.6e-07 $X=158660 $Y=143550 $dt=15
M2543 3 40 192 3 nfet_01v8 L=1.5e-07 W=7.6e-07 $X=158660 $Y=151830 $dt=15
M2544 3 41 193 3 nfet_01v8 L=1.5e-07 W=7.6e-07 $X=158660 $Y=160110 $dt=15
M2545 3 137 156 3 nfet_01v8 L=1.5e-07 W=7.6e-07 $X=158690 $Y=13010 $dt=15
M2546 3 138 157 3 nfet_01v8 L=1.5e-07 W=7.6e-07 $X=158690 $Y=21290 $dt=15
M2547 3 139 158 3 nfet_01v8 L=1.5e-07 W=7.6e-07 $X=158690 $Y=29570 $dt=15
M2548 3 140 159 3 nfet_01v8 L=1.5e-07 W=7.6e-07 $X=158690 $Y=37850 $dt=15
M2549 3 141 160 3 nfet_01v8 L=1.5e-07 W=7.6e-07 $X=158690 $Y=46130 $dt=15
M2550 3 142 161 3 nfet_01v8 L=1.5e-07 W=7.6e-07 $X=158690 $Y=54410 $dt=15
M2551 3 143 162 3 nfet_01v8 L=1.5e-07 W=7.6e-07 $X=158690 $Y=62690 $dt=15
M2552 3 144 163 3 nfet_01v8 L=1.5e-07 W=7.6e-07 $X=158690 $Y=70970 $dt=15
M2553 3 145 164 3 nfet_01v8 L=1.5e-07 W=7.6e-07 $X=158690 $Y=79250 $dt=15
M2554 3 146 165 3 nfet_01v8 L=1.5e-07 W=7.6e-07 $X=158690 $Y=87530 $dt=15
M2555 3 147 166 3 nfet_01v8 L=1.5e-07 W=7.6e-07 $X=158690 $Y=95810 $dt=15
M2556 3 148 167 3 nfet_01v8 L=1.5e-07 W=7.6e-07 $X=158690 $Y=104090 $dt=15
M2557 3 149 168 3 nfet_01v8 L=1.5e-07 W=7.6e-07 $X=158690 $Y=112370 $dt=15
M2558 3 150 169 3 nfet_01v8 L=1.5e-07 W=7.6e-07 $X=158690 $Y=120650 $dt=15
M2559 3 151 170 3 nfet_01v8 L=1.5e-07 W=7.6e-07 $X=158690 $Y=128930 $dt=15
M2560 3 152 171 3 nfet_01v8 L=1.5e-07 W=7.6e-07 $X=158690 $Y=137210 $dt=15
M2561 3 153 172 3 nfet_01v8 L=1.5e-07 W=7.6e-07 $X=158690 $Y=145490 $dt=15
M2562 3 154 173 3 nfet_01v8 L=1.5e-07 W=7.6e-07 $X=158690 $Y=153770 $dt=15
M2563 3 155 174 3 nfet_01v8 L=1.5e-07 W=7.6e-07 $X=158690 $Y=162050 $dt=15
M2564 175 23 3 3 nfet_01v8 L=1.5e-07 W=7.6e-07 $X=159090 $Y=11070 $dt=15
M2565 176 24 3 3 nfet_01v8 L=1.5e-07 W=7.6e-07 $X=159090 $Y=19350 $dt=15
M2566 177 25 3 3 nfet_01v8 L=1.5e-07 W=7.6e-07 $X=159090 $Y=27630 $dt=15
M2567 178 26 3 3 nfet_01v8 L=1.5e-07 W=7.6e-07 $X=159090 $Y=35910 $dt=15
M2568 179 27 3 3 nfet_01v8 L=1.5e-07 W=7.6e-07 $X=159090 $Y=44190 $dt=15
M2569 180 28 3 3 nfet_01v8 L=1.5e-07 W=7.6e-07 $X=159090 $Y=52470 $dt=15
M2570 181 29 3 3 nfet_01v8 L=1.5e-07 W=7.6e-07 $X=159090 $Y=60750 $dt=15
M2571 182 30 3 3 nfet_01v8 L=1.5e-07 W=7.6e-07 $X=159090 $Y=69030 $dt=15
M2572 183 31 3 3 nfet_01v8 L=1.5e-07 W=7.6e-07 $X=159090 $Y=77310 $dt=15
M2573 184 32 3 3 nfet_01v8 L=1.5e-07 W=7.6e-07 $X=159090 $Y=85590 $dt=15
M2574 185 33 3 3 nfet_01v8 L=1.5e-07 W=7.6e-07 $X=159090 $Y=93870 $dt=15
M2575 186 34 3 3 nfet_01v8 L=1.5e-07 W=7.6e-07 $X=159090 $Y=102150 $dt=15
M2576 187 35 3 3 nfet_01v8 L=1.5e-07 W=7.6e-07 $X=159090 $Y=110430 $dt=15
M2577 188 36 3 3 nfet_01v8 L=1.5e-07 W=7.6e-07 $X=159090 $Y=118710 $dt=15
M2578 189 37 3 3 nfet_01v8 L=1.5e-07 W=7.6e-07 $X=159090 $Y=126990 $dt=15
M2579 190 38 3 3 nfet_01v8 L=1.5e-07 W=7.6e-07 $X=159090 $Y=135270 $dt=15
M2580 191 39 3 3 nfet_01v8 L=1.5e-07 W=7.6e-07 $X=159090 $Y=143550 $dt=15
M2581 192 40 3 3 nfet_01v8 L=1.5e-07 W=7.6e-07 $X=159090 $Y=151830 $dt=15
M2582 193 41 3 3 nfet_01v8 L=1.5e-07 W=7.6e-07 $X=159090 $Y=160110 $dt=15
M2583 156 137 3 3 nfet_01v8 L=1.5e-07 W=7.6e-07 $X=159120 $Y=13010 $dt=15
M2584 157 138 3 3 nfet_01v8 L=1.5e-07 W=7.6e-07 $X=159120 $Y=21290 $dt=15
M2585 158 139 3 3 nfet_01v8 L=1.5e-07 W=7.6e-07 $X=159120 $Y=29570 $dt=15
M2586 159 140 3 3 nfet_01v8 L=1.5e-07 W=7.6e-07 $X=159120 $Y=37850 $dt=15
M2587 160 141 3 3 nfet_01v8 L=1.5e-07 W=7.6e-07 $X=159120 $Y=46130 $dt=15
M2588 161 142 3 3 nfet_01v8 L=1.5e-07 W=7.6e-07 $X=159120 $Y=54410 $dt=15
M2589 162 143 3 3 nfet_01v8 L=1.5e-07 W=7.6e-07 $X=159120 $Y=62690 $dt=15
M2590 163 144 3 3 nfet_01v8 L=1.5e-07 W=7.6e-07 $X=159120 $Y=70970 $dt=15
M2591 164 145 3 3 nfet_01v8 L=1.5e-07 W=7.6e-07 $X=159120 $Y=79250 $dt=15
M2592 165 146 3 3 nfet_01v8 L=1.5e-07 W=7.6e-07 $X=159120 $Y=87530 $dt=15
M2593 166 147 3 3 nfet_01v8 L=1.5e-07 W=7.6e-07 $X=159120 $Y=95810 $dt=15
M2594 167 148 3 3 nfet_01v8 L=1.5e-07 W=7.6e-07 $X=159120 $Y=104090 $dt=15
M2595 168 149 3 3 nfet_01v8 L=1.5e-07 W=7.6e-07 $X=159120 $Y=112370 $dt=15
M2596 169 150 3 3 nfet_01v8 L=1.5e-07 W=7.6e-07 $X=159120 $Y=120650 $dt=15
M2597 170 151 3 3 nfet_01v8 L=1.5e-07 W=7.6e-07 $X=159120 $Y=128930 $dt=15
M2598 171 152 3 3 nfet_01v8 L=1.5e-07 W=7.6e-07 $X=159120 $Y=137210 $dt=15
M2599 172 153 3 3 nfet_01v8 L=1.5e-07 W=7.6e-07 $X=159120 $Y=145490 $dt=15
M2600 173 154 3 3 nfet_01v8 L=1.5e-07 W=7.6e-07 $X=159120 $Y=153770 $dt=15
M2601 174 155 3 3 nfet_01v8 L=1.5e-07 W=7.6e-07 $X=159120 $Y=162050 $dt=15
M2602 3 23 175 3 nfet_01v8 L=1.5e-07 W=7.6e-07 $X=159520 $Y=11070 $dt=15
M2603 3 24 176 3 nfet_01v8 L=1.5e-07 W=7.6e-07 $X=159520 $Y=19350 $dt=15
M2604 3 25 177 3 nfet_01v8 L=1.5e-07 W=7.6e-07 $X=159520 $Y=27630 $dt=15
M2605 3 26 178 3 nfet_01v8 L=1.5e-07 W=7.6e-07 $X=159520 $Y=35910 $dt=15
M2606 3 27 179 3 nfet_01v8 L=1.5e-07 W=7.6e-07 $X=159520 $Y=44190 $dt=15
M2607 3 28 180 3 nfet_01v8 L=1.5e-07 W=7.6e-07 $X=159520 $Y=52470 $dt=15
M2608 3 29 181 3 nfet_01v8 L=1.5e-07 W=7.6e-07 $X=159520 $Y=60750 $dt=15
M2609 3 30 182 3 nfet_01v8 L=1.5e-07 W=7.6e-07 $X=159520 $Y=69030 $dt=15
M2610 3 31 183 3 nfet_01v8 L=1.5e-07 W=7.6e-07 $X=159520 $Y=77310 $dt=15
M2611 3 32 184 3 nfet_01v8 L=1.5e-07 W=7.6e-07 $X=159520 $Y=85590 $dt=15
M2612 3 33 185 3 nfet_01v8 L=1.5e-07 W=7.6e-07 $X=159520 $Y=93870 $dt=15
M2613 3 34 186 3 nfet_01v8 L=1.5e-07 W=7.6e-07 $X=159520 $Y=102150 $dt=15
M2614 3 35 187 3 nfet_01v8 L=1.5e-07 W=7.6e-07 $X=159520 $Y=110430 $dt=15
M2615 3 36 188 3 nfet_01v8 L=1.5e-07 W=7.6e-07 $X=159520 $Y=118710 $dt=15
M2616 3 37 189 3 nfet_01v8 L=1.5e-07 W=7.6e-07 $X=159520 $Y=126990 $dt=15
M2617 3 38 190 3 nfet_01v8 L=1.5e-07 W=7.6e-07 $X=159520 $Y=135270 $dt=15
M2618 3 39 191 3 nfet_01v8 L=1.5e-07 W=7.6e-07 $X=159520 $Y=143550 $dt=15
M2619 3 40 192 3 nfet_01v8 L=1.5e-07 W=7.6e-07 $X=159520 $Y=151830 $dt=15
M2620 3 41 193 3 nfet_01v8 L=1.5e-07 W=7.6e-07 $X=159520 $Y=160110 $dt=15
M2621 3 137 156 3 nfet_01v8 L=1.5e-07 W=7.6e-07 $X=159550 $Y=13010 $dt=15
M2622 3 138 157 3 nfet_01v8 L=1.5e-07 W=7.6e-07 $X=159550 $Y=21290 $dt=15
M2623 3 139 158 3 nfet_01v8 L=1.5e-07 W=7.6e-07 $X=159550 $Y=29570 $dt=15
M2624 3 140 159 3 nfet_01v8 L=1.5e-07 W=7.6e-07 $X=159550 $Y=37850 $dt=15
M2625 3 141 160 3 nfet_01v8 L=1.5e-07 W=7.6e-07 $X=159550 $Y=46130 $dt=15
M2626 3 142 161 3 nfet_01v8 L=1.5e-07 W=7.6e-07 $X=159550 $Y=54410 $dt=15
M2627 3 143 162 3 nfet_01v8 L=1.5e-07 W=7.6e-07 $X=159550 $Y=62690 $dt=15
M2628 3 144 163 3 nfet_01v8 L=1.5e-07 W=7.6e-07 $X=159550 $Y=70970 $dt=15
M2629 3 145 164 3 nfet_01v8 L=1.5e-07 W=7.6e-07 $X=159550 $Y=79250 $dt=15
M2630 3 146 165 3 nfet_01v8 L=1.5e-07 W=7.6e-07 $X=159550 $Y=87530 $dt=15
M2631 3 147 166 3 nfet_01v8 L=1.5e-07 W=7.6e-07 $X=159550 $Y=95810 $dt=15
M2632 3 148 167 3 nfet_01v8 L=1.5e-07 W=7.6e-07 $X=159550 $Y=104090 $dt=15
M2633 3 149 168 3 nfet_01v8 L=1.5e-07 W=7.6e-07 $X=159550 $Y=112370 $dt=15
M2634 3 150 169 3 nfet_01v8 L=1.5e-07 W=7.6e-07 $X=159550 $Y=120650 $dt=15
M2635 3 151 170 3 nfet_01v8 L=1.5e-07 W=7.6e-07 $X=159550 $Y=128930 $dt=15
M2636 3 152 171 3 nfet_01v8 L=1.5e-07 W=7.6e-07 $X=159550 $Y=137210 $dt=15
M2637 3 153 172 3 nfet_01v8 L=1.5e-07 W=7.6e-07 $X=159550 $Y=145490 $dt=15
M2638 3 154 173 3 nfet_01v8 L=1.5e-07 W=7.6e-07 $X=159550 $Y=153770 $dt=15
M2639 3 155 174 3 nfet_01v8 L=1.5e-07 W=7.6e-07 $X=159550 $Y=162050 $dt=15
M2640 137 99 3 3 nfet_01v8 L=1.5e-07 W=7.6e-07 $X=159980 $Y=13010 $dt=15
M2641 138 100 3 3 nfet_01v8 L=1.5e-07 W=7.6e-07 $X=159980 $Y=21290 $dt=15
M2642 139 101 3 3 nfet_01v8 L=1.5e-07 W=7.6e-07 $X=159980 $Y=29570 $dt=15
M2643 140 102 3 3 nfet_01v8 L=1.5e-07 W=7.6e-07 $X=159980 $Y=37850 $dt=15
M2644 141 103 3 3 nfet_01v8 L=1.5e-07 W=7.6e-07 $X=159980 $Y=46130 $dt=15
M2645 142 104 3 3 nfet_01v8 L=1.5e-07 W=7.6e-07 $X=159980 $Y=54410 $dt=15
M2646 143 105 3 3 nfet_01v8 L=1.5e-07 W=7.6e-07 $X=159980 $Y=62690 $dt=15
M2647 144 106 3 3 nfet_01v8 L=1.5e-07 W=7.6e-07 $X=159980 $Y=70970 $dt=15
M2648 145 107 3 3 nfet_01v8 L=1.5e-07 W=7.6e-07 $X=159980 $Y=79250 $dt=15
M2649 146 108 3 3 nfet_01v8 L=1.5e-07 W=7.6e-07 $X=159980 $Y=87530 $dt=15
M2650 147 109 3 3 nfet_01v8 L=1.5e-07 W=7.6e-07 $X=159980 $Y=95810 $dt=15
M2651 148 110 3 3 nfet_01v8 L=1.5e-07 W=7.6e-07 $X=159980 $Y=104090 $dt=15
M2652 149 111 3 3 nfet_01v8 L=1.5e-07 W=7.6e-07 $X=159980 $Y=112370 $dt=15
M2653 150 112 3 3 nfet_01v8 L=1.5e-07 W=7.6e-07 $X=159980 $Y=120650 $dt=15
M2654 151 113 3 3 nfet_01v8 L=1.5e-07 W=7.6e-07 $X=159980 $Y=128930 $dt=15
M2655 152 114 3 3 nfet_01v8 L=1.5e-07 W=7.6e-07 $X=159980 $Y=137210 $dt=15
M2656 153 115 3 3 nfet_01v8 L=1.5e-07 W=7.6e-07 $X=159980 $Y=145490 $dt=15
M2657 154 116 3 3 nfet_01v8 L=1.5e-07 W=7.6e-07 $X=159980 $Y=153770 $dt=15
M2658 155 117 3 3 nfet_01v8 L=1.5e-07 W=7.6e-07 $X=159980 $Y=162050 $dt=15
M2659 3 80 118 3 nfet_01v8 L=1.5e-07 W=7.6e-07 $X=160900 $Y=11070 $dt=15
M2660 3 81 119 3 nfet_01v8 L=1.5e-07 W=7.6e-07 $X=160900 $Y=19350 $dt=15
M2661 3 82 120 3 nfet_01v8 L=1.5e-07 W=7.6e-07 $X=160900 $Y=27630 $dt=15
M2662 3 83 121 3 nfet_01v8 L=1.5e-07 W=7.6e-07 $X=160900 $Y=35910 $dt=15
M2663 3 84 122 3 nfet_01v8 L=1.5e-07 W=7.6e-07 $X=160900 $Y=44190 $dt=15
M2664 3 85 123 3 nfet_01v8 L=1.5e-07 W=7.6e-07 $X=160900 $Y=52470 $dt=15
M2665 3 86 124 3 nfet_01v8 L=1.5e-07 W=7.6e-07 $X=160900 $Y=60750 $dt=15
M2666 3 87 125 3 nfet_01v8 L=1.5e-07 W=7.6e-07 $X=160900 $Y=69030 $dt=15
M2667 3 88 126 3 nfet_01v8 L=1.5e-07 W=7.6e-07 $X=160900 $Y=77310 $dt=15
M2668 3 89 127 3 nfet_01v8 L=1.5e-07 W=7.6e-07 $X=160900 $Y=85590 $dt=15
M2669 3 90 128 3 nfet_01v8 L=1.5e-07 W=7.6e-07 $X=160900 $Y=93870 $dt=15
M2670 3 91 129 3 nfet_01v8 L=1.5e-07 W=7.6e-07 $X=160900 $Y=102150 $dt=15
M2671 3 92 130 3 nfet_01v8 L=1.5e-07 W=7.6e-07 $X=160900 $Y=110430 $dt=15
M2672 3 93 131 3 nfet_01v8 L=1.5e-07 W=7.6e-07 $X=160900 $Y=118710 $dt=15
M2673 3 94 132 3 nfet_01v8 L=1.5e-07 W=7.6e-07 $X=160900 $Y=126990 $dt=15
M2674 3 95 133 3 nfet_01v8 L=1.5e-07 W=7.6e-07 $X=160900 $Y=135270 $dt=15
M2675 3 96 134 3 nfet_01v8 L=1.5e-07 W=7.6e-07 $X=160900 $Y=143550 $dt=15
M2676 3 97 135 3 nfet_01v8 L=1.5e-07 W=7.6e-07 $X=160900 $Y=151830 $dt=15
M2677 3 98 136 3 nfet_01v8 L=1.5e-07 W=7.6e-07 $X=160900 $Y=160110 $dt=15
M2678 3 61 99 3 nfet_01v8 L=1.5e-07 W=7.6e-07 $X=161360 $Y=13010 $dt=15
M2679 3 62 100 3 nfet_01v8 L=1.5e-07 W=7.6e-07 $X=161360 $Y=21290 $dt=15
M2680 3 63 101 3 nfet_01v8 L=1.5e-07 W=7.6e-07 $X=161360 $Y=29570 $dt=15
M2681 3 64 102 3 nfet_01v8 L=1.5e-07 W=7.6e-07 $X=161360 $Y=37850 $dt=15
M2682 3 65 103 3 nfet_01v8 L=1.5e-07 W=7.6e-07 $X=161360 $Y=46130 $dt=15
M2683 3 66 104 3 nfet_01v8 L=1.5e-07 W=7.6e-07 $X=161360 $Y=54410 $dt=15
M2684 3 67 105 3 nfet_01v8 L=1.5e-07 W=7.6e-07 $X=161360 $Y=62690 $dt=15
M2685 3 68 106 3 nfet_01v8 L=1.5e-07 W=7.6e-07 $X=161360 $Y=70970 $dt=15
M2686 3 69 107 3 nfet_01v8 L=1.5e-07 W=7.6e-07 $X=161360 $Y=79250 $dt=15
M2687 3 70 108 3 nfet_01v8 L=1.5e-07 W=7.6e-07 $X=161360 $Y=87530 $dt=15
M2688 3 71 109 3 nfet_01v8 L=1.5e-07 W=7.6e-07 $X=161360 $Y=95810 $dt=15
M2689 3 72 110 3 nfet_01v8 L=1.5e-07 W=7.6e-07 $X=161360 $Y=104090 $dt=15
M2690 3 73 111 3 nfet_01v8 L=1.5e-07 W=7.6e-07 $X=161360 $Y=112370 $dt=15
M2691 3 74 112 3 nfet_01v8 L=1.5e-07 W=7.6e-07 $X=161360 $Y=120650 $dt=15
M2692 3 75 113 3 nfet_01v8 L=1.5e-07 W=7.6e-07 $X=161360 $Y=128930 $dt=15
M2693 3 76 114 3 nfet_01v8 L=1.5e-07 W=7.6e-07 $X=161360 $Y=137210 $dt=15
M2694 3 77 115 3 nfet_01v8 L=1.5e-07 W=7.6e-07 $X=161360 $Y=145490 $dt=15
M2695 3 78 116 3 nfet_01v8 L=1.5e-07 W=7.6e-07 $X=161360 $Y=153770 $dt=15
M2696 3 79 117 3 nfet_01v8 L=1.5e-07 W=7.6e-07 $X=161360 $Y=162050 $dt=15
M2697 910 42 3 3 nfet_01v8 L=1.5e-07 W=4.25e-07 $X=161390 $Y=11405 $dt=15
M2698 911 43 3 3 nfet_01v8 L=1.5e-07 W=4.25e-07 $X=161390 $Y=19685 $dt=15
M2699 912 44 3 3 nfet_01v8 L=1.5e-07 W=4.25e-07 $X=161390 $Y=27965 $dt=15
M2700 913 45 3 3 nfet_01v8 L=1.5e-07 W=4.25e-07 $X=161390 $Y=36245 $dt=15
M2701 914 46 3 3 nfet_01v8 L=1.5e-07 W=4.25e-07 $X=161390 $Y=44525 $dt=15
M2702 915 47 3 3 nfet_01v8 L=1.5e-07 W=4.25e-07 $X=161390 $Y=52805 $dt=15
M2703 916 48 3 3 nfet_01v8 L=1.5e-07 W=4.25e-07 $X=161390 $Y=61085 $dt=15
M2704 917 49 3 3 nfet_01v8 L=1.5e-07 W=4.25e-07 $X=161390 $Y=69365 $dt=15
M2705 918 50 3 3 nfet_01v8 L=1.5e-07 W=4.25e-07 $X=161390 $Y=77645 $dt=15
M2706 919 51 3 3 nfet_01v8 L=1.5e-07 W=4.25e-07 $X=161390 $Y=85925 $dt=15
M2707 920 52 3 3 nfet_01v8 L=1.5e-07 W=4.25e-07 $X=161390 $Y=94205 $dt=15
M2708 921 53 3 3 nfet_01v8 L=1.5e-07 W=4.25e-07 $X=161390 $Y=102485 $dt=15
M2709 922 54 3 3 nfet_01v8 L=1.5e-07 W=4.25e-07 $X=161390 $Y=110765 $dt=15
M2710 923 55 3 3 nfet_01v8 L=1.5e-07 W=4.25e-07 $X=161390 $Y=119045 $dt=15
M2711 924 56 3 3 nfet_01v8 L=1.5e-07 W=4.25e-07 $X=161390 $Y=127325 $dt=15
M2712 925 57 3 3 nfet_01v8 L=1.5e-07 W=4.25e-07 $X=161390 $Y=135605 $dt=15
M2713 926 58 3 3 nfet_01v8 L=1.5e-07 W=4.25e-07 $X=161390 $Y=143885 $dt=15
M2714 927 59 3 3 nfet_01v8 L=1.5e-07 W=4.25e-07 $X=161390 $Y=152165 $dt=15
M2715 928 60 3 3 nfet_01v8 L=1.5e-07 W=4.25e-07 $X=161390 $Y=160445 $dt=15
M2716 80 2 910 3 nfet_01v8 L=1.5e-07 W=4.25e-07 $X=161820 $Y=11405 $dt=15
M2717 81 2 911 3 nfet_01v8 L=1.5e-07 W=4.25e-07 $X=161820 $Y=19685 $dt=15
M2718 82 2 912 3 nfet_01v8 L=1.5e-07 W=4.25e-07 $X=161820 $Y=27965 $dt=15
M2719 83 2 913 3 nfet_01v8 L=1.5e-07 W=4.25e-07 $X=161820 $Y=36245 $dt=15
M2720 84 2 914 3 nfet_01v8 L=1.5e-07 W=4.25e-07 $X=161820 $Y=44525 $dt=15
M2721 85 2 915 3 nfet_01v8 L=1.5e-07 W=4.25e-07 $X=161820 $Y=52805 $dt=15
M2722 86 2 916 3 nfet_01v8 L=1.5e-07 W=4.25e-07 $X=161820 $Y=61085 $dt=15
M2723 87 2 917 3 nfet_01v8 L=1.5e-07 W=4.25e-07 $X=161820 $Y=69365 $dt=15
M2724 88 2 918 3 nfet_01v8 L=1.5e-07 W=4.25e-07 $X=161820 $Y=77645 $dt=15
M2725 89 2 919 3 nfet_01v8 L=1.5e-07 W=4.25e-07 $X=161820 $Y=85925 $dt=15
M2726 90 2 920 3 nfet_01v8 L=1.5e-07 W=4.25e-07 $X=161820 $Y=94205 $dt=15
M2727 91 2 921 3 nfet_01v8 L=1.5e-07 W=4.25e-07 $X=161820 $Y=102485 $dt=15
M2728 92 2 922 3 nfet_01v8 L=1.5e-07 W=4.25e-07 $X=161820 $Y=110765 $dt=15
M2729 93 2 923 3 nfet_01v8 L=1.5e-07 W=4.25e-07 $X=161820 $Y=119045 $dt=15
M2730 94 2 924 3 nfet_01v8 L=1.5e-07 W=4.25e-07 $X=161820 $Y=127325 $dt=15
M2731 95 2 925 3 nfet_01v8 L=1.5e-07 W=4.25e-07 $X=161820 $Y=135605 $dt=15
M2732 96 2 926 3 nfet_01v8 L=1.5e-07 W=4.25e-07 $X=161820 $Y=143885 $dt=15
M2733 97 2 927 3 nfet_01v8 L=1.5e-07 W=4.25e-07 $X=161820 $Y=152165 $dt=15
M2734 98 2 928 3 nfet_01v8 L=1.5e-07 W=4.25e-07 $X=161820 $Y=160445 $dt=15
M2735 891 42 3 3 nfet_01v8 L=1.5e-07 W=4.25e-07 $X=161850 $Y=13010 $dt=15
M2736 892 43 3 3 nfet_01v8 L=1.5e-07 W=4.25e-07 $X=161850 $Y=21290 $dt=15
M2737 893 44 3 3 nfet_01v8 L=1.5e-07 W=4.25e-07 $X=161850 $Y=29570 $dt=15
M2738 894 45 3 3 nfet_01v8 L=1.5e-07 W=4.25e-07 $X=161850 $Y=37850 $dt=15
M2739 895 46 3 3 nfet_01v8 L=1.5e-07 W=4.25e-07 $X=161850 $Y=46130 $dt=15
M2740 896 47 3 3 nfet_01v8 L=1.5e-07 W=4.25e-07 $X=161850 $Y=54410 $dt=15
M2741 897 48 3 3 nfet_01v8 L=1.5e-07 W=4.25e-07 $X=161850 $Y=62690 $dt=15
M2742 898 49 3 3 nfet_01v8 L=1.5e-07 W=4.25e-07 $X=161850 $Y=70970 $dt=15
M2743 899 50 3 3 nfet_01v8 L=1.5e-07 W=4.25e-07 $X=161850 $Y=79250 $dt=15
M2744 900 51 3 3 nfet_01v8 L=1.5e-07 W=4.25e-07 $X=161850 $Y=87530 $dt=15
M2745 901 52 3 3 nfet_01v8 L=1.5e-07 W=4.25e-07 $X=161850 $Y=95810 $dt=15
M2746 902 53 3 3 nfet_01v8 L=1.5e-07 W=4.25e-07 $X=161850 $Y=104090 $dt=15
M2747 903 54 3 3 nfet_01v8 L=1.5e-07 W=4.25e-07 $X=161850 $Y=112370 $dt=15
M2748 904 55 3 3 nfet_01v8 L=1.5e-07 W=4.25e-07 $X=161850 $Y=120650 $dt=15
M2749 905 56 3 3 nfet_01v8 L=1.5e-07 W=4.25e-07 $X=161850 $Y=128930 $dt=15
M2750 906 57 3 3 nfet_01v8 L=1.5e-07 W=4.25e-07 $X=161850 $Y=137210 $dt=15
M2751 907 58 3 3 nfet_01v8 L=1.5e-07 W=4.25e-07 $X=161850 $Y=145490 $dt=15
M2752 908 59 3 3 nfet_01v8 L=1.5e-07 W=4.25e-07 $X=161850 $Y=153770 $dt=15
M2753 909 60 3 3 nfet_01v8 L=1.5e-07 W=4.25e-07 $X=161850 $Y=162050 $dt=15
M2754 61 4 891 3 nfet_01v8 L=1.5e-07 W=4.25e-07 $X=162280 $Y=13010 $dt=15
M2755 62 5 892 3 nfet_01v8 L=1.5e-07 W=4.25e-07 $X=162280 $Y=21290 $dt=15
M2756 63 6 893 3 nfet_01v8 L=1.5e-07 W=4.25e-07 $X=162280 $Y=29570 $dt=15
M2757 64 7 894 3 nfet_01v8 L=1.5e-07 W=4.25e-07 $X=162280 $Y=37850 $dt=15
M2758 65 8 895 3 nfet_01v8 L=1.5e-07 W=4.25e-07 $X=162280 $Y=46130 $dt=15
M2759 66 9 896 3 nfet_01v8 L=1.5e-07 W=4.25e-07 $X=162280 $Y=54410 $dt=15
M2760 67 10 897 3 nfet_01v8 L=1.5e-07 W=4.25e-07 $X=162280 $Y=62690 $dt=15
M2761 68 11 898 3 nfet_01v8 L=1.5e-07 W=4.25e-07 $X=162280 $Y=70970 $dt=15
M2762 69 12 899 3 nfet_01v8 L=1.5e-07 W=4.25e-07 $X=162280 $Y=79250 $dt=15
M2763 70 13 900 3 nfet_01v8 L=1.5e-07 W=4.25e-07 $X=162280 $Y=87530 $dt=15
M2764 71 14 901 3 nfet_01v8 L=1.5e-07 W=4.25e-07 $X=162280 $Y=95810 $dt=15
M2765 72 15 902 3 nfet_01v8 L=1.5e-07 W=4.25e-07 $X=162280 $Y=104090 $dt=15
M2766 73 16 903 3 nfet_01v8 L=1.5e-07 W=4.25e-07 $X=162280 $Y=112370 $dt=15
M2767 74 17 904 3 nfet_01v8 L=1.5e-07 W=4.25e-07 $X=162280 $Y=120650 $dt=15
M2768 75 18 905 3 nfet_01v8 L=1.5e-07 W=4.25e-07 $X=162280 $Y=128930 $dt=15
M2769 76 19 906 3 nfet_01v8 L=1.5e-07 W=4.25e-07 $X=162280 $Y=137210 $dt=15
M2770 77 20 907 3 nfet_01v8 L=1.5e-07 W=4.25e-07 $X=162280 $Y=145490 $dt=15
M2771 78 21 908 3 nfet_01v8 L=1.5e-07 W=4.25e-07 $X=162280 $Y=153770 $dt=15
M2772 79 22 909 3 nfet_01v8 L=1.5e-07 W=4.25e-07 $X=162280 $Y=162050 $dt=15
M2773 23 42 3 3 nfet_01v8 L=1.5e-07 W=7.6e-07 $X=163150 $Y=11070 $dt=15
M2774 24 43 3 3 nfet_01v8 L=1.5e-07 W=7.6e-07 $X=163150 $Y=19350 $dt=15
M2775 25 44 3 3 nfet_01v8 L=1.5e-07 W=7.6e-07 $X=163150 $Y=27630 $dt=15
M2776 26 45 3 3 nfet_01v8 L=1.5e-07 W=7.6e-07 $X=163150 $Y=35910 $dt=15
M2777 27 46 3 3 nfet_01v8 L=1.5e-07 W=7.6e-07 $X=163150 $Y=44190 $dt=15
M2778 28 47 3 3 nfet_01v8 L=1.5e-07 W=7.6e-07 $X=163150 $Y=52470 $dt=15
M2779 29 48 3 3 nfet_01v8 L=1.5e-07 W=7.6e-07 $X=163150 $Y=60750 $dt=15
M2780 30 49 3 3 nfet_01v8 L=1.5e-07 W=7.6e-07 $X=163150 $Y=69030 $dt=15
M2781 31 50 3 3 nfet_01v8 L=1.5e-07 W=7.6e-07 $X=163150 $Y=77310 $dt=15
M2782 32 51 3 3 nfet_01v8 L=1.5e-07 W=7.6e-07 $X=163150 $Y=85590 $dt=15
M2783 33 52 3 3 nfet_01v8 L=1.5e-07 W=7.6e-07 $X=163150 $Y=93870 $dt=15
M2784 34 53 3 3 nfet_01v8 L=1.5e-07 W=7.6e-07 $X=163150 $Y=102150 $dt=15
M2785 35 54 3 3 nfet_01v8 L=1.5e-07 W=7.6e-07 $X=163150 $Y=110430 $dt=15
M2786 36 55 3 3 nfet_01v8 L=1.5e-07 W=7.6e-07 $X=163150 $Y=118710 $dt=15
M2787 37 56 3 3 nfet_01v8 L=1.5e-07 W=7.6e-07 $X=163150 $Y=126990 $dt=15
M2788 38 57 3 3 nfet_01v8 L=1.5e-07 W=7.6e-07 $X=163150 $Y=135270 $dt=15
M2789 39 58 3 3 nfet_01v8 L=1.5e-07 W=7.6e-07 $X=163150 $Y=143550 $dt=15
M2790 40 59 3 3 nfet_01v8 L=1.5e-07 W=7.6e-07 $X=163150 $Y=151830 $dt=15
M2791 41 60 3 3 nfet_01v8 L=1.5e-07 W=7.6e-07 $X=163150 $Y=160110 $dt=15
M2792 3 2 23 3 nfet_01v8 L=1.5e-07 W=7.6e-07 $X=163620 $Y=11070 $dt=15
M2793 3 2 24 3 nfet_01v8 L=1.5e-07 W=7.6e-07 $X=163620 $Y=19350 $dt=15
M2794 3 2 25 3 nfet_01v8 L=1.5e-07 W=7.6e-07 $X=163620 $Y=27630 $dt=15
M2795 3 2 26 3 nfet_01v8 L=1.5e-07 W=7.6e-07 $X=163620 $Y=35910 $dt=15
M2796 3 2 27 3 nfet_01v8 L=1.5e-07 W=7.6e-07 $X=163620 $Y=44190 $dt=15
M2797 3 2 28 3 nfet_01v8 L=1.5e-07 W=7.6e-07 $X=163620 $Y=52470 $dt=15
M2798 3 2 29 3 nfet_01v8 L=1.5e-07 W=7.6e-07 $X=163620 $Y=60750 $dt=15
M2799 3 2 30 3 nfet_01v8 L=1.5e-07 W=7.6e-07 $X=163620 $Y=69030 $dt=15
M2800 3 2 31 3 nfet_01v8 L=1.5e-07 W=7.6e-07 $X=163620 $Y=77310 $dt=15
M2801 3 2 32 3 nfet_01v8 L=1.5e-07 W=7.6e-07 $X=163620 $Y=85590 $dt=15
M2802 3 2 33 3 nfet_01v8 L=1.5e-07 W=7.6e-07 $X=163620 $Y=93870 $dt=15
M2803 3 2 34 3 nfet_01v8 L=1.5e-07 W=7.6e-07 $X=163620 $Y=102150 $dt=15
M2804 3 2 35 3 nfet_01v8 L=1.5e-07 W=7.6e-07 $X=163620 $Y=110430 $dt=15
M2805 3 2 36 3 nfet_01v8 L=1.5e-07 W=7.6e-07 $X=163620 $Y=118710 $dt=15
M2806 3 2 37 3 nfet_01v8 L=1.5e-07 W=7.6e-07 $X=163620 $Y=126990 $dt=15
M2807 3 2 38 3 nfet_01v8 L=1.5e-07 W=7.6e-07 $X=163620 $Y=135270 $dt=15
M2808 3 2 39 3 nfet_01v8 L=1.5e-07 W=7.6e-07 $X=163620 $Y=143550 $dt=15
M2809 3 2 40 3 nfet_01v8 L=1.5e-07 W=7.6e-07 $X=163620 $Y=151830 $dt=15
M2810 3 2 41 3 nfet_01v8 L=1.5e-07 W=7.6e-07 $X=163620 $Y=160110 $dt=15
M2811 3 2 4 3 nfet_01v8 L=1.5e-07 W=7.6e-07 $X=163660 $Y=13010 $dt=15
M2812 3 2 5 3 nfet_01v8 L=1.5e-07 W=7.6e-07 $X=163660 $Y=21290 $dt=15
M2813 3 2 6 3 nfet_01v8 L=1.5e-07 W=7.6e-07 $X=163660 $Y=29570 $dt=15
M2814 3 2 7 3 nfet_01v8 L=1.5e-07 W=7.6e-07 $X=163660 $Y=37850 $dt=15
M2815 3 2 8 3 nfet_01v8 L=1.5e-07 W=7.6e-07 $X=163660 $Y=46130 $dt=15
M2816 3 2 9 3 nfet_01v8 L=1.5e-07 W=7.6e-07 $X=163660 $Y=54410 $dt=15
M2817 3 2 10 3 nfet_01v8 L=1.5e-07 W=7.6e-07 $X=163660 $Y=62690 $dt=15
M2818 3 2 11 3 nfet_01v8 L=1.5e-07 W=7.6e-07 $X=163660 $Y=70970 $dt=15
M2819 3 2 12 3 nfet_01v8 L=1.5e-07 W=7.6e-07 $X=163660 $Y=79250 $dt=15
M2820 3 2 13 3 nfet_01v8 L=1.5e-07 W=7.6e-07 $X=163660 $Y=87530 $dt=15
M2821 3 2 14 3 nfet_01v8 L=1.5e-07 W=7.6e-07 $X=163660 $Y=95810 $dt=15
M2822 3 2 15 3 nfet_01v8 L=1.5e-07 W=7.6e-07 $X=163660 $Y=104090 $dt=15
M2823 3 2 16 3 nfet_01v8 L=1.5e-07 W=7.6e-07 $X=163660 $Y=112370 $dt=15
M2824 3 2 17 3 nfet_01v8 L=1.5e-07 W=7.6e-07 $X=163660 $Y=120650 $dt=15
M2825 3 2 18 3 nfet_01v8 L=1.5e-07 W=7.6e-07 $X=163660 $Y=128930 $dt=15
M2826 3 2 19 3 nfet_01v8 L=1.5e-07 W=7.6e-07 $X=163660 $Y=137210 $dt=15
M2827 3 2 20 3 nfet_01v8 L=1.5e-07 W=7.6e-07 $X=163660 $Y=145490 $dt=15
M2828 3 2 21 3 nfet_01v8 L=1.5e-07 W=7.6e-07 $X=163660 $Y=153770 $dt=15
M2829 3 2 22 3 nfet_01v8 L=1.5e-07 W=7.6e-07 $X=163660 $Y=162050 $dt=15
M2830 852 2 1 1 pfet_01v8 L=1.5e-07 W=1.13e-06 $X=2360 $Y=14840 $dt=16
M2831 853 2 1 1 pfet_01v8 L=1.5e-07 W=1.13e-06 $X=2360 $Y=23120 $dt=16
M2832 854 2 1 1 pfet_01v8 L=1.5e-07 W=1.13e-06 $X=2360 $Y=31400 $dt=16
M2833 855 2 1 1 pfet_01v8 L=1.5e-07 W=1.13e-06 $X=2360 $Y=39680 $dt=16
M2834 856 2 1 1 pfet_01v8 L=1.5e-07 W=1.13e-06 $X=2360 $Y=47960 $dt=16
M2835 857 2 1 1 pfet_01v8 L=1.5e-07 W=1.13e-06 $X=2360 $Y=56240 $dt=16
M2836 858 2 1 1 pfet_01v8 L=1.5e-07 W=1.13e-06 $X=2360 $Y=64520 $dt=16
M2837 859 2 1 1 pfet_01v8 L=1.5e-07 W=1.13e-06 $X=2360 $Y=72800 $dt=16
M2838 860 2 1 1 pfet_01v8 L=1.5e-07 W=1.13e-06 $X=2360 $Y=81080 $dt=16
M2839 861 2 1 1 pfet_01v8 L=1.5e-07 W=1.13e-06 $X=2360 $Y=89360 $dt=16
M2840 862 2 1 1 pfet_01v8 L=1.5e-07 W=1.13e-06 $X=2360 $Y=97640 $dt=16
M2841 863 2 1 1 pfet_01v8 L=1.5e-07 W=1.13e-06 $X=2360 $Y=105920 $dt=16
M2842 864 2 1 1 pfet_01v8 L=1.5e-07 W=1.13e-06 $X=2360 $Y=114200 $dt=16
M2843 865 2 1 1 pfet_01v8 L=1.5e-07 W=1.13e-06 $X=2360 $Y=122480 $dt=16
M2844 866 2 1 1 pfet_01v8 L=1.5e-07 W=1.13e-06 $X=2360 $Y=130760 $dt=16
M2845 867 2 1 1 pfet_01v8 L=1.5e-07 W=1.13e-06 $X=2360 $Y=139040 $dt=16
M2846 868 2 1 1 pfet_01v8 L=1.5e-07 W=1.13e-06 $X=2360 $Y=147320 $dt=16
M2847 869 2 1 1 pfet_01v8 L=1.5e-07 W=1.13e-06 $X=2360 $Y=155600 $dt=16
M2848 870 2 1 1 pfet_01v8 L=1.5e-07 W=1.13e-06 $X=2360 $Y=163880 $dt=16
M2849 967 2 1 1 pfet_01v8 L=1.5e-07 W=1.13e-06 $X=2400 $Y=8870 $dt=16
M2850 968 2 1 1 pfet_01v8 L=1.5e-07 W=1.13e-06 $X=2400 $Y=17150 $dt=16
M2851 969 2 1 1 pfet_01v8 L=1.5e-07 W=1.13e-06 $X=2400 $Y=25430 $dt=16
M2852 970 2 1 1 pfet_01v8 L=1.5e-07 W=1.13e-06 $X=2400 $Y=33710 $dt=16
M2853 971 2 1 1 pfet_01v8 L=1.5e-07 W=1.13e-06 $X=2400 $Y=41990 $dt=16
M2854 972 2 1 1 pfet_01v8 L=1.5e-07 W=1.13e-06 $X=2400 $Y=50270 $dt=16
M2855 973 2 1 1 pfet_01v8 L=1.5e-07 W=1.13e-06 $X=2400 $Y=58550 $dt=16
M2856 974 2 1 1 pfet_01v8 L=1.5e-07 W=1.13e-06 $X=2400 $Y=66830 $dt=16
M2857 975 2 1 1 pfet_01v8 L=1.5e-07 W=1.13e-06 $X=2400 $Y=75110 $dt=16
M2858 976 2 1 1 pfet_01v8 L=1.5e-07 W=1.13e-06 $X=2400 $Y=83390 $dt=16
M2859 977 2 1 1 pfet_01v8 L=1.5e-07 W=1.13e-06 $X=2400 $Y=91670 $dt=16
M2860 978 2 1 1 pfet_01v8 L=1.5e-07 W=1.13e-06 $X=2400 $Y=99950 $dt=16
M2861 979 2 1 1 pfet_01v8 L=1.5e-07 W=1.13e-06 $X=2400 $Y=108230 $dt=16
M2862 980 2 1 1 pfet_01v8 L=1.5e-07 W=1.13e-06 $X=2400 $Y=116510 $dt=16
M2863 981 2 1 1 pfet_01v8 L=1.5e-07 W=1.13e-06 $X=2400 $Y=124790 $dt=16
M2864 982 2 1 1 pfet_01v8 L=1.5e-07 W=1.13e-06 $X=2400 $Y=133070 $dt=16
M2865 983 2 1 1 pfet_01v8 L=1.5e-07 W=1.13e-06 $X=2400 $Y=141350 $dt=16
M2866 984 2 1 1 pfet_01v8 L=1.5e-07 W=1.13e-06 $X=2400 $Y=149630 $dt=16
M2867 985 2 1 1 pfet_01v8 L=1.5e-07 W=1.13e-06 $X=2400 $Y=157910 $dt=16
M2868 720 795 967 1 pfet_01v8 L=1.5e-07 W=1.13e-06 $X=2870 $Y=8870 $dt=16
M2869 722 796 968 1 pfet_01v8 L=1.5e-07 W=1.13e-06 $X=2870 $Y=17150 $dt=16
M2870 724 797 969 1 pfet_01v8 L=1.5e-07 W=1.13e-06 $X=2870 $Y=25430 $dt=16
M2871 726 798 970 1 pfet_01v8 L=1.5e-07 W=1.13e-06 $X=2870 $Y=33710 $dt=16
M2872 728 799 971 1 pfet_01v8 L=1.5e-07 W=1.13e-06 $X=2870 $Y=41990 $dt=16
M2873 730 800 972 1 pfet_01v8 L=1.5e-07 W=1.13e-06 $X=2870 $Y=50270 $dt=16
M2874 732 801 973 1 pfet_01v8 L=1.5e-07 W=1.13e-06 $X=2870 $Y=58550 $dt=16
M2875 734 802 974 1 pfet_01v8 L=1.5e-07 W=1.13e-06 $X=2870 $Y=66830 $dt=16
M2876 736 803 975 1 pfet_01v8 L=1.5e-07 W=1.13e-06 $X=2870 $Y=75110 $dt=16
M2877 738 804 976 1 pfet_01v8 L=1.5e-07 W=1.13e-06 $X=2870 $Y=83390 $dt=16
M2878 740 805 977 1 pfet_01v8 L=1.5e-07 W=1.13e-06 $X=2870 $Y=91670 $dt=16
M2879 742 806 978 1 pfet_01v8 L=1.5e-07 W=1.13e-06 $X=2870 $Y=99950 $dt=16
M2880 744 807 979 1 pfet_01v8 L=1.5e-07 W=1.13e-06 $X=2870 $Y=108230 $dt=16
M2881 746 808 980 1 pfet_01v8 L=1.5e-07 W=1.13e-06 $X=2870 $Y=116510 $dt=16
M2882 748 809 981 1 pfet_01v8 L=1.5e-07 W=1.13e-06 $X=2870 $Y=124790 $dt=16
M2883 750 810 982 1 pfet_01v8 L=1.5e-07 W=1.13e-06 $X=2870 $Y=133070 $dt=16
M2884 752 811 983 1 pfet_01v8 L=1.5e-07 W=1.13e-06 $X=2870 $Y=141350 $dt=16
M2885 754 812 984 1 pfet_01v8 L=1.5e-07 W=1.13e-06 $X=2870 $Y=149630 $dt=16
M2886 756 813 985 1 pfet_01v8 L=1.5e-07 W=1.13e-06 $X=2870 $Y=157910 $dt=16
M2887 833 852 1 1 pfet_01v8 L=1.5e-07 W=6.25e-07 $X=3740 $Y=15345 $dt=16
M2888 834 853 1 1 pfet_01v8 L=1.5e-07 W=6.25e-07 $X=3740 $Y=23625 $dt=16
M2889 835 854 1 1 pfet_01v8 L=1.5e-07 W=6.25e-07 $X=3740 $Y=31905 $dt=16
M2890 836 855 1 1 pfet_01v8 L=1.5e-07 W=6.25e-07 $X=3740 $Y=40185 $dt=16
M2891 837 856 1 1 pfet_01v8 L=1.5e-07 W=6.25e-07 $X=3740 $Y=48465 $dt=16
M2892 838 857 1 1 pfet_01v8 L=1.5e-07 W=6.25e-07 $X=3740 $Y=56745 $dt=16
M2893 839 858 1 1 pfet_01v8 L=1.5e-07 W=6.25e-07 $X=3740 $Y=65025 $dt=16
M2894 840 859 1 1 pfet_01v8 L=1.5e-07 W=6.25e-07 $X=3740 $Y=73305 $dt=16
M2895 841 860 1 1 pfet_01v8 L=1.5e-07 W=6.25e-07 $X=3740 $Y=81585 $dt=16
M2896 842 861 1 1 pfet_01v8 L=1.5e-07 W=6.25e-07 $X=3740 $Y=89865 $dt=16
M2897 843 862 1 1 pfet_01v8 L=1.5e-07 W=6.25e-07 $X=3740 $Y=98145 $dt=16
M2898 844 863 1 1 pfet_01v8 L=1.5e-07 W=6.25e-07 $X=3740 $Y=106425 $dt=16
M2899 845 864 1 1 pfet_01v8 L=1.5e-07 W=6.25e-07 $X=3740 $Y=114705 $dt=16
M2900 846 865 1 1 pfet_01v8 L=1.5e-07 W=6.25e-07 $X=3740 $Y=122985 $dt=16
M2901 847 866 1 1 pfet_01v8 L=1.5e-07 W=6.25e-07 $X=3740 $Y=131265 $dt=16
M2902 848 867 1 1 pfet_01v8 L=1.5e-07 W=6.25e-07 $X=3740 $Y=139545 $dt=16
M2903 849 868 1 1 pfet_01v8 L=1.5e-07 W=6.25e-07 $X=3740 $Y=147825 $dt=16
M2904 850 869 1 1 pfet_01v8 L=1.5e-07 W=6.25e-07 $X=3740 $Y=156105 $dt=16
M2905 851 870 1 1 pfet_01v8 L=1.5e-07 W=6.25e-07 $X=3740 $Y=164385 $dt=16
M2906 1 795 833 1 pfet_01v8 L=1.5e-07 W=6.25e-07 $X=4170 $Y=15345 $dt=16
M2907 1 796 834 1 pfet_01v8 L=1.5e-07 W=6.25e-07 $X=4170 $Y=23625 $dt=16
M2908 1 797 835 1 pfet_01v8 L=1.5e-07 W=6.25e-07 $X=4170 $Y=31905 $dt=16
M2909 1 798 836 1 pfet_01v8 L=1.5e-07 W=6.25e-07 $X=4170 $Y=40185 $dt=16
M2910 1 799 837 1 pfet_01v8 L=1.5e-07 W=6.25e-07 $X=4170 $Y=48465 $dt=16
M2911 1 800 838 1 pfet_01v8 L=1.5e-07 W=6.25e-07 $X=4170 $Y=56745 $dt=16
M2912 1 801 839 1 pfet_01v8 L=1.5e-07 W=6.25e-07 $X=4170 $Y=65025 $dt=16
M2913 1 802 840 1 pfet_01v8 L=1.5e-07 W=6.25e-07 $X=4170 $Y=73305 $dt=16
M2914 1 803 841 1 pfet_01v8 L=1.5e-07 W=6.25e-07 $X=4170 $Y=81585 $dt=16
M2915 1 804 842 1 pfet_01v8 L=1.5e-07 W=6.25e-07 $X=4170 $Y=89865 $dt=16
M2916 1 805 843 1 pfet_01v8 L=1.5e-07 W=6.25e-07 $X=4170 $Y=98145 $dt=16
M2917 1 806 844 1 pfet_01v8 L=1.5e-07 W=6.25e-07 $X=4170 $Y=106425 $dt=16
M2918 1 807 845 1 pfet_01v8 L=1.5e-07 W=6.25e-07 $X=4170 $Y=114705 $dt=16
M2919 1 808 846 1 pfet_01v8 L=1.5e-07 W=6.25e-07 $X=4170 $Y=122985 $dt=16
M2920 1 809 847 1 pfet_01v8 L=1.5e-07 W=6.25e-07 $X=4170 $Y=131265 $dt=16
M2921 1 810 848 1 pfet_01v8 L=1.5e-07 W=6.25e-07 $X=4170 $Y=139545 $dt=16
M2922 1 811 849 1 pfet_01v8 L=1.5e-07 W=6.25e-07 $X=4170 $Y=147825 $dt=16
M2923 1 812 850 1 pfet_01v8 L=1.5e-07 W=6.25e-07 $X=4170 $Y=156105 $dt=16
M2924 1 813 851 1 pfet_01v8 L=1.5e-07 W=6.25e-07 $X=4170 $Y=164385 $dt=16
M2925 814 2 1 1 pfet_01v8 L=1.5e-07 W=6.25e-07 $X=4200 $Y=8870 $dt=16
M2926 815 2 1 1 pfet_01v8 L=1.5e-07 W=6.25e-07 $X=4200 $Y=17150 $dt=16
M2927 816 2 1 1 pfet_01v8 L=1.5e-07 W=6.25e-07 $X=4200 $Y=25430 $dt=16
M2928 817 2 1 1 pfet_01v8 L=1.5e-07 W=6.25e-07 $X=4200 $Y=33710 $dt=16
M2929 818 2 1 1 pfet_01v8 L=1.5e-07 W=6.25e-07 $X=4200 $Y=41990 $dt=16
M2930 819 2 1 1 pfet_01v8 L=1.5e-07 W=6.25e-07 $X=4200 $Y=50270 $dt=16
M2931 820 2 1 1 pfet_01v8 L=1.5e-07 W=6.25e-07 $X=4200 $Y=58550 $dt=16
M2932 821 2 1 1 pfet_01v8 L=1.5e-07 W=6.25e-07 $X=4200 $Y=66830 $dt=16
M2933 822 2 1 1 pfet_01v8 L=1.5e-07 W=6.25e-07 $X=4200 $Y=75110 $dt=16
M2934 823 2 1 1 pfet_01v8 L=1.5e-07 W=6.25e-07 $X=4200 $Y=83390 $dt=16
M2935 824 2 1 1 pfet_01v8 L=1.5e-07 W=6.25e-07 $X=4200 $Y=91670 $dt=16
M2936 825 2 1 1 pfet_01v8 L=1.5e-07 W=6.25e-07 $X=4200 $Y=99950 $dt=16
M2937 826 2 1 1 pfet_01v8 L=1.5e-07 W=6.25e-07 $X=4200 $Y=108230 $dt=16
M2938 827 2 1 1 pfet_01v8 L=1.5e-07 W=6.25e-07 $X=4200 $Y=116510 $dt=16
M2939 828 2 1 1 pfet_01v8 L=1.5e-07 W=6.25e-07 $X=4200 $Y=124790 $dt=16
M2940 829 2 1 1 pfet_01v8 L=1.5e-07 W=6.25e-07 $X=4200 $Y=133070 $dt=16
M2941 830 2 1 1 pfet_01v8 L=1.5e-07 W=6.25e-07 $X=4200 $Y=141350 $dt=16
M2942 831 2 1 1 pfet_01v8 L=1.5e-07 W=6.25e-07 $X=4200 $Y=149630 $dt=16
M2943 832 2 1 1 pfet_01v8 L=1.5e-07 W=6.25e-07 $X=4200 $Y=157910 $dt=16
M2944 1 795 814 1 pfet_01v8 L=1.5e-07 W=6.25e-07 $X=4630 $Y=8870 $dt=16
M2945 1 796 815 1 pfet_01v8 L=1.5e-07 W=6.25e-07 $X=4630 $Y=17150 $dt=16
M2946 1 797 816 1 pfet_01v8 L=1.5e-07 W=6.25e-07 $X=4630 $Y=25430 $dt=16
M2947 1 798 817 1 pfet_01v8 L=1.5e-07 W=6.25e-07 $X=4630 $Y=33710 $dt=16
M2948 1 799 818 1 pfet_01v8 L=1.5e-07 W=6.25e-07 $X=4630 $Y=41990 $dt=16
M2949 1 800 819 1 pfet_01v8 L=1.5e-07 W=6.25e-07 $X=4630 $Y=50270 $dt=16
M2950 1 801 820 1 pfet_01v8 L=1.5e-07 W=6.25e-07 $X=4630 $Y=58550 $dt=16
M2951 1 802 821 1 pfet_01v8 L=1.5e-07 W=6.25e-07 $X=4630 $Y=66830 $dt=16
M2952 1 803 822 1 pfet_01v8 L=1.5e-07 W=6.25e-07 $X=4630 $Y=75110 $dt=16
M2953 1 804 823 1 pfet_01v8 L=1.5e-07 W=6.25e-07 $X=4630 $Y=83390 $dt=16
M2954 1 805 824 1 pfet_01v8 L=1.5e-07 W=6.25e-07 $X=4630 $Y=91670 $dt=16
M2955 1 806 825 1 pfet_01v8 L=1.5e-07 W=6.25e-07 $X=4630 $Y=99950 $dt=16
M2956 1 807 826 1 pfet_01v8 L=1.5e-07 W=6.25e-07 $X=4630 $Y=108230 $dt=16
M2957 1 808 827 1 pfet_01v8 L=1.5e-07 W=6.25e-07 $X=4630 $Y=116510 $dt=16
M2958 1 809 828 1 pfet_01v8 L=1.5e-07 W=6.25e-07 $X=4630 $Y=124790 $dt=16
M2959 1 810 829 1 pfet_01v8 L=1.5e-07 W=6.25e-07 $X=4630 $Y=133070 $dt=16
M2960 1 811 830 1 pfet_01v8 L=1.5e-07 W=6.25e-07 $X=4630 $Y=141350 $dt=16
M2961 1 812 831 1 pfet_01v8 L=1.5e-07 W=6.25e-07 $X=4630 $Y=149630 $dt=16
M2962 1 813 832 1 pfet_01v8 L=1.5e-07 W=6.25e-07 $X=4630 $Y=157910 $dt=16
M2963 719 833 1 1 pfet_01v8 L=1.5e-07 W=1.13e-06 $X=4660 $Y=14840 $dt=16
M2964 721 834 1 1 pfet_01v8 L=1.5e-07 W=1.13e-06 $X=4660 $Y=23120 $dt=16
M2965 723 835 1 1 pfet_01v8 L=1.5e-07 W=1.13e-06 $X=4660 $Y=31400 $dt=16
M2966 725 836 1 1 pfet_01v8 L=1.5e-07 W=1.13e-06 $X=4660 $Y=39680 $dt=16
M2967 727 837 1 1 pfet_01v8 L=1.5e-07 W=1.13e-06 $X=4660 $Y=47960 $dt=16
M2968 729 838 1 1 pfet_01v8 L=1.5e-07 W=1.13e-06 $X=4660 $Y=56240 $dt=16
M2969 731 839 1 1 pfet_01v8 L=1.5e-07 W=1.13e-06 $X=4660 $Y=64520 $dt=16
M2970 733 840 1 1 pfet_01v8 L=1.5e-07 W=1.13e-06 $X=4660 $Y=72800 $dt=16
M2971 735 841 1 1 pfet_01v8 L=1.5e-07 W=1.13e-06 $X=4660 $Y=81080 $dt=16
M2972 737 842 1 1 pfet_01v8 L=1.5e-07 W=1.13e-06 $X=4660 $Y=89360 $dt=16
M2973 739 843 1 1 pfet_01v8 L=1.5e-07 W=1.13e-06 $X=4660 $Y=97640 $dt=16
M2974 741 844 1 1 pfet_01v8 L=1.5e-07 W=1.13e-06 $X=4660 $Y=105920 $dt=16
M2975 743 845 1 1 pfet_01v8 L=1.5e-07 W=1.13e-06 $X=4660 $Y=114200 $dt=16
M2976 745 846 1 1 pfet_01v8 L=1.5e-07 W=1.13e-06 $X=4660 $Y=122480 $dt=16
M2977 747 847 1 1 pfet_01v8 L=1.5e-07 W=1.13e-06 $X=4660 $Y=130760 $dt=16
M2978 749 848 1 1 pfet_01v8 L=1.5e-07 W=1.13e-06 $X=4660 $Y=139040 $dt=16
M2979 751 849 1 1 pfet_01v8 L=1.5e-07 W=1.13e-06 $X=4660 $Y=147320 $dt=16
M2980 753 850 1 1 pfet_01v8 L=1.5e-07 W=1.13e-06 $X=4660 $Y=155600 $dt=16
M2981 755 851 1 1 pfet_01v8 L=1.5e-07 W=1.13e-06 $X=4660 $Y=163880 $dt=16
M2982 681 814 1 1 pfet_01v8 L=1.5e-07 W=1.13e-06 $X=5120 $Y=8870 $dt=16
M2983 682 815 1 1 pfet_01v8 L=1.5e-07 W=1.13e-06 $X=5120 $Y=17150 $dt=16
M2984 683 816 1 1 pfet_01v8 L=1.5e-07 W=1.13e-06 $X=5120 $Y=25430 $dt=16
M2985 684 817 1 1 pfet_01v8 L=1.5e-07 W=1.13e-06 $X=5120 $Y=33710 $dt=16
M2986 685 818 1 1 pfet_01v8 L=1.5e-07 W=1.13e-06 $X=5120 $Y=41990 $dt=16
M2987 686 819 1 1 pfet_01v8 L=1.5e-07 W=1.13e-06 $X=5120 $Y=50270 $dt=16
M2988 687 820 1 1 pfet_01v8 L=1.5e-07 W=1.13e-06 $X=5120 $Y=58550 $dt=16
M2989 688 821 1 1 pfet_01v8 L=1.5e-07 W=1.13e-06 $X=5120 $Y=66830 $dt=16
M2990 689 822 1 1 pfet_01v8 L=1.5e-07 W=1.13e-06 $X=5120 $Y=75110 $dt=16
M2991 690 823 1 1 pfet_01v8 L=1.5e-07 W=1.13e-06 $X=5120 $Y=83390 $dt=16
M2992 691 824 1 1 pfet_01v8 L=1.5e-07 W=1.13e-06 $X=5120 $Y=91670 $dt=16
M2993 692 825 1 1 pfet_01v8 L=1.5e-07 W=1.13e-06 $X=5120 $Y=99950 $dt=16
M2994 693 826 1 1 pfet_01v8 L=1.5e-07 W=1.13e-06 $X=5120 $Y=108230 $dt=16
M2995 694 827 1 1 pfet_01v8 L=1.5e-07 W=1.13e-06 $X=5120 $Y=116510 $dt=16
M2996 695 828 1 1 pfet_01v8 L=1.5e-07 W=1.13e-06 $X=5120 $Y=124790 $dt=16
M2997 696 829 1 1 pfet_01v8 L=1.5e-07 W=1.13e-06 $X=5120 $Y=133070 $dt=16
M2998 697 830 1 1 pfet_01v8 L=1.5e-07 W=1.13e-06 $X=5120 $Y=141350 $dt=16
M2999 698 831 1 1 pfet_01v8 L=1.5e-07 W=1.13e-06 $X=5120 $Y=149630 $dt=16
M3000 699 832 1 1 pfet_01v8 L=1.5e-07 W=1.13e-06 $X=5120 $Y=157910 $dt=16
M3001 1 719 776 1 pfet_01v8 L=1.5e-07 W=1.13e-06 $X=6040 $Y=14840 $dt=16
M3002 1 721 777 1 pfet_01v8 L=1.5e-07 W=1.13e-06 $X=6040 $Y=23120 $dt=16
M3003 1 723 778 1 pfet_01v8 L=1.5e-07 W=1.13e-06 $X=6040 $Y=31400 $dt=16
M3004 1 725 779 1 pfet_01v8 L=1.5e-07 W=1.13e-06 $X=6040 $Y=39680 $dt=16
M3005 1 727 780 1 pfet_01v8 L=1.5e-07 W=1.13e-06 $X=6040 $Y=47960 $dt=16
M3006 1 729 781 1 pfet_01v8 L=1.5e-07 W=1.13e-06 $X=6040 $Y=56240 $dt=16
M3007 1 731 782 1 pfet_01v8 L=1.5e-07 W=1.13e-06 $X=6040 $Y=64520 $dt=16
M3008 1 733 783 1 pfet_01v8 L=1.5e-07 W=1.13e-06 $X=6040 $Y=72800 $dt=16
M3009 1 735 784 1 pfet_01v8 L=1.5e-07 W=1.13e-06 $X=6040 $Y=81080 $dt=16
M3010 1 737 785 1 pfet_01v8 L=1.5e-07 W=1.13e-06 $X=6040 $Y=89360 $dt=16
M3011 1 739 786 1 pfet_01v8 L=1.5e-07 W=1.13e-06 $X=6040 $Y=97640 $dt=16
M3012 1 741 787 1 pfet_01v8 L=1.5e-07 W=1.13e-06 $X=6040 $Y=105920 $dt=16
M3013 1 743 788 1 pfet_01v8 L=1.5e-07 W=1.13e-06 $X=6040 $Y=114200 $dt=16
M3014 1 745 789 1 pfet_01v8 L=1.5e-07 W=1.13e-06 $X=6040 $Y=122480 $dt=16
M3015 1 747 790 1 pfet_01v8 L=1.5e-07 W=1.13e-06 $X=6040 $Y=130760 $dt=16
M3016 1 749 791 1 pfet_01v8 L=1.5e-07 W=1.13e-06 $X=6040 $Y=139040 $dt=16
M3017 1 751 792 1 pfet_01v8 L=1.5e-07 W=1.13e-06 $X=6040 $Y=147320 $dt=16
M3018 1 753 793 1 pfet_01v8 L=1.5e-07 W=1.13e-06 $X=6040 $Y=155600 $dt=16
M3019 1 755 794 1 pfet_01v8 L=1.5e-07 W=1.13e-06 $X=6040 $Y=163880 $dt=16
M3020 534 776 1 1 pfet_01v8 L=1.5e-07 W=1.13e-06 $X=6470 $Y=14840 $dt=16
M3021 536 777 1 1 pfet_01v8 L=1.5e-07 W=1.13e-06 $X=6470 $Y=23120 $dt=16
M3022 538 778 1 1 pfet_01v8 L=1.5e-07 W=1.13e-06 $X=6470 $Y=31400 $dt=16
M3023 540 779 1 1 pfet_01v8 L=1.5e-07 W=1.13e-06 $X=6470 $Y=39680 $dt=16
M3024 542 780 1 1 pfet_01v8 L=1.5e-07 W=1.13e-06 $X=6470 $Y=47960 $dt=16
M3025 544 781 1 1 pfet_01v8 L=1.5e-07 W=1.13e-06 $X=6470 $Y=56240 $dt=16
M3026 546 782 1 1 pfet_01v8 L=1.5e-07 W=1.13e-06 $X=6470 $Y=64520 $dt=16
M3027 548 783 1 1 pfet_01v8 L=1.5e-07 W=1.13e-06 $X=6470 $Y=72800 $dt=16
M3028 550 784 1 1 pfet_01v8 L=1.5e-07 W=1.13e-06 $X=6470 $Y=81080 $dt=16
M3029 552 785 1 1 pfet_01v8 L=1.5e-07 W=1.13e-06 $X=6470 $Y=89360 $dt=16
M3030 554 786 1 1 pfet_01v8 L=1.5e-07 W=1.13e-06 $X=6470 $Y=97640 $dt=16
M3031 556 787 1 1 pfet_01v8 L=1.5e-07 W=1.13e-06 $X=6470 $Y=105920 $dt=16
M3032 558 788 1 1 pfet_01v8 L=1.5e-07 W=1.13e-06 $X=6470 $Y=114200 $dt=16
M3033 560 789 1 1 pfet_01v8 L=1.5e-07 W=1.13e-06 $X=6470 $Y=122480 $dt=16
M3034 562 790 1 1 pfet_01v8 L=1.5e-07 W=1.13e-06 $X=6470 $Y=130760 $dt=16
M3035 564 791 1 1 pfet_01v8 L=1.5e-07 W=1.13e-06 $X=6470 $Y=139040 $dt=16
M3036 566 792 1 1 pfet_01v8 L=1.5e-07 W=1.13e-06 $X=6470 $Y=147320 $dt=16
M3037 568 793 1 1 pfet_01v8 L=1.5e-07 W=1.13e-06 $X=6470 $Y=155600 $dt=16
M3038 570 794 1 1 pfet_01v8 L=1.5e-07 W=1.13e-06 $X=6470 $Y=163880 $dt=16
M3039 457 720 1 1 pfet_01v8 L=1.5e-07 W=1.13e-06 $X=6500 $Y=8870 $dt=16
M3040 459 722 1 1 pfet_01v8 L=1.5e-07 W=1.13e-06 $X=6500 $Y=17150 $dt=16
M3041 461 724 1 1 pfet_01v8 L=1.5e-07 W=1.13e-06 $X=6500 $Y=25430 $dt=16
M3042 463 726 1 1 pfet_01v8 L=1.5e-07 W=1.13e-06 $X=6500 $Y=33710 $dt=16
M3043 465 728 1 1 pfet_01v8 L=1.5e-07 W=1.13e-06 $X=6500 $Y=41990 $dt=16
M3044 467 730 1 1 pfet_01v8 L=1.5e-07 W=1.13e-06 $X=6500 $Y=50270 $dt=16
M3045 469 732 1 1 pfet_01v8 L=1.5e-07 W=1.13e-06 $X=6500 $Y=58550 $dt=16
M3046 471 734 1 1 pfet_01v8 L=1.5e-07 W=1.13e-06 $X=6500 $Y=66830 $dt=16
M3047 473 736 1 1 pfet_01v8 L=1.5e-07 W=1.13e-06 $X=6500 $Y=75110 $dt=16
M3048 475 738 1 1 pfet_01v8 L=1.5e-07 W=1.13e-06 $X=6500 $Y=83390 $dt=16
M3049 477 740 1 1 pfet_01v8 L=1.5e-07 W=1.13e-06 $X=6500 $Y=91670 $dt=16
M3050 479 742 1 1 pfet_01v8 L=1.5e-07 W=1.13e-06 $X=6500 $Y=99950 $dt=16
M3051 481 744 1 1 pfet_01v8 L=1.5e-07 W=1.13e-06 $X=6500 $Y=108230 $dt=16
M3052 483 746 1 1 pfet_01v8 L=1.5e-07 W=1.13e-06 $X=6500 $Y=116510 $dt=16
M3053 485 748 1 1 pfet_01v8 L=1.5e-07 W=1.13e-06 $X=6500 $Y=124790 $dt=16
M3054 487 750 1 1 pfet_01v8 L=1.5e-07 W=1.13e-06 $X=6500 $Y=133070 $dt=16
M3055 489 752 1 1 pfet_01v8 L=1.5e-07 W=1.13e-06 $X=6500 $Y=141350 $dt=16
M3056 491 754 1 1 pfet_01v8 L=1.5e-07 W=1.13e-06 $X=6500 $Y=149630 $dt=16
M3057 493 756 1 1 pfet_01v8 L=1.5e-07 W=1.13e-06 $X=6500 $Y=157910 $dt=16
M3058 1 776 534 1 pfet_01v8 L=1.5e-07 W=1.13e-06 $X=6900 $Y=14840 $dt=16
M3059 1 777 536 1 pfet_01v8 L=1.5e-07 W=1.13e-06 $X=6900 $Y=23120 $dt=16
M3060 1 778 538 1 pfet_01v8 L=1.5e-07 W=1.13e-06 $X=6900 $Y=31400 $dt=16
M3061 1 779 540 1 pfet_01v8 L=1.5e-07 W=1.13e-06 $X=6900 $Y=39680 $dt=16
M3062 1 780 542 1 pfet_01v8 L=1.5e-07 W=1.13e-06 $X=6900 $Y=47960 $dt=16
M3063 1 781 544 1 pfet_01v8 L=1.5e-07 W=1.13e-06 $X=6900 $Y=56240 $dt=16
M3064 1 782 546 1 pfet_01v8 L=1.5e-07 W=1.13e-06 $X=6900 $Y=64520 $dt=16
M3065 1 783 548 1 pfet_01v8 L=1.5e-07 W=1.13e-06 $X=6900 $Y=72800 $dt=16
M3066 1 784 550 1 pfet_01v8 L=1.5e-07 W=1.13e-06 $X=6900 $Y=81080 $dt=16
M3067 1 785 552 1 pfet_01v8 L=1.5e-07 W=1.13e-06 $X=6900 $Y=89360 $dt=16
M3068 1 786 554 1 pfet_01v8 L=1.5e-07 W=1.13e-06 $X=6900 $Y=97640 $dt=16
M3069 1 787 556 1 pfet_01v8 L=1.5e-07 W=1.13e-06 $X=6900 $Y=105920 $dt=16
M3070 1 788 558 1 pfet_01v8 L=1.5e-07 W=1.13e-06 $X=6900 $Y=114200 $dt=16
M3071 1 789 560 1 pfet_01v8 L=1.5e-07 W=1.13e-06 $X=6900 $Y=122480 $dt=16
M3072 1 790 562 1 pfet_01v8 L=1.5e-07 W=1.13e-06 $X=6900 $Y=130760 $dt=16
M3073 1 791 564 1 pfet_01v8 L=1.5e-07 W=1.13e-06 $X=6900 $Y=139040 $dt=16
M3074 1 792 566 1 pfet_01v8 L=1.5e-07 W=1.13e-06 $X=6900 $Y=147320 $dt=16
M3075 1 793 568 1 pfet_01v8 L=1.5e-07 W=1.13e-06 $X=6900 $Y=155600 $dt=16
M3076 1 794 570 1 pfet_01v8 L=1.5e-07 W=1.13e-06 $X=6900 $Y=163880 $dt=16
M3077 1 720 457 1 pfet_01v8 L=1.5e-07 W=1.13e-06 $X=6930 $Y=8870 $dt=16
M3078 1 722 459 1 pfet_01v8 L=1.5e-07 W=1.13e-06 $X=6930 $Y=17150 $dt=16
M3079 1 724 461 1 pfet_01v8 L=1.5e-07 W=1.13e-06 $X=6930 $Y=25430 $dt=16
M3080 1 726 463 1 pfet_01v8 L=1.5e-07 W=1.13e-06 $X=6930 $Y=33710 $dt=16
M3081 1 728 465 1 pfet_01v8 L=1.5e-07 W=1.13e-06 $X=6930 $Y=41990 $dt=16
M3082 1 730 467 1 pfet_01v8 L=1.5e-07 W=1.13e-06 $X=6930 $Y=50270 $dt=16
M3083 1 732 469 1 pfet_01v8 L=1.5e-07 W=1.13e-06 $X=6930 $Y=58550 $dt=16
M3084 1 734 471 1 pfet_01v8 L=1.5e-07 W=1.13e-06 $X=6930 $Y=66830 $dt=16
M3085 1 736 473 1 pfet_01v8 L=1.5e-07 W=1.13e-06 $X=6930 $Y=75110 $dt=16
M3086 1 738 475 1 pfet_01v8 L=1.5e-07 W=1.13e-06 $X=6930 $Y=83390 $dt=16
M3087 1 740 477 1 pfet_01v8 L=1.5e-07 W=1.13e-06 $X=6930 $Y=91670 $dt=16
M3088 1 742 479 1 pfet_01v8 L=1.5e-07 W=1.13e-06 $X=6930 $Y=99950 $dt=16
M3089 1 744 481 1 pfet_01v8 L=1.5e-07 W=1.13e-06 $X=6930 $Y=108230 $dt=16
M3090 1 746 483 1 pfet_01v8 L=1.5e-07 W=1.13e-06 $X=6930 $Y=116510 $dt=16
M3091 1 748 485 1 pfet_01v8 L=1.5e-07 W=1.13e-06 $X=6930 $Y=124790 $dt=16
M3092 1 750 487 1 pfet_01v8 L=1.5e-07 W=1.13e-06 $X=6930 $Y=133070 $dt=16
M3093 1 752 489 1 pfet_01v8 L=1.5e-07 W=1.13e-06 $X=6930 $Y=141350 $dt=16
M3094 1 754 491 1 pfet_01v8 L=1.5e-07 W=1.13e-06 $X=6930 $Y=149630 $dt=16
M3095 1 756 493 1 pfet_01v8 L=1.5e-07 W=1.13e-06 $X=6930 $Y=157910 $dt=16
M3096 534 776 1 1 pfet_01v8 L=1.5e-07 W=1.13e-06 $X=7330 $Y=14840 $dt=16
M3097 536 777 1 1 pfet_01v8 L=1.5e-07 W=1.13e-06 $X=7330 $Y=23120 $dt=16
M3098 538 778 1 1 pfet_01v8 L=1.5e-07 W=1.13e-06 $X=7330 $Y=31400 $dt=16
M3099 540 779 1 1 pfet_01v8 L=1.5e-07 W=1.13e-06 $X=7330 $Y=39680 $dt=16
M3100 542 780 1 1 pfet_01v8 L=1.5e-07 W=1.13e-06 $X=7330 $Y=47960 $dt=16
M3101 544 781 1 1 pfet_01v8 L=1.5e-07 W=1.13e-06 $X=7330 $Y=56240 $dt=16
M3102 546 782 1 1 pfet_01v8 L=1.5e-07 W=1.13e-06 $X=7330 $Y=64520 $dt=16
M3103 548 783 1 1 pfet_01v8 L=1.5e-07 W=1.13e-06 $X=7330 $Y=72800 $dt=16
M3104 550 784 1 1 pfet_01v8 L=1.5e-07 W=1.13e-06 $X=7330 $Y=81080 $dt=16
M3105 552 785 1 1 pfet_01v8 L=1.5e-07 W=1.13e-06 $X=7330 $Y=89360 $dt=16
M3106 554 786 1 1 pfet_01v8 L=1.5e-07 W=1.13e-06 $X=7330 $Y=97640 $dt=16
M3107 556 787 1 1 pfet_01v8 L=1.5e-07 W=1.13e-06 $X=7330 $Y=105920 $dt=16
M3108 558 788 1 1 pfet_01v8 L=1.5e-07 W=1.13e-06 $X=7330 $Y=114200 $dt=16
M3109 560 789 1 1 pfet_01v8 L=1.5e-07 W=1.13e-06 $X=7330 $Y=122480 $dt=16
M3110 562 790 1 1 pfet_01v8 L=1.5e-07 W=1.13e-06 $X=7330 $Y=130760 $dt=16
M3111 564 791 1 1 pfet_01v8 L=1.5e-07 W=1.13e-06 $X=7330 $Y=139040 $dt=16
M3112 566 792 1 1 pfet_01v8 L=1.5e-07 W=1.13e-06 $X=7330 $Y=147320 $dt=16
M3113 568 793 1 1 pfet_01v8 L=1.5e-07 W=1.13e-06 $X=7330 $Y=155600 $dt=16
M3114 570 794 1 1 pfet_01v8 L=1.5e-07 W=1.13e-06 $X=7330 $Y=163880 $dt=16
M3115 457 720 1 1 pfet_01v8 L=1.5e-07 W=1.13e-06 $X=7360 $Y=8870 $dt=16
M3116 459 722 1 1 pfet_01v8 L=1.5e-07 W=1.13e-06 $X=7360 $Y=17150 $dt=16
M3117 461 724 1 1 pfet_01v8 L=1.5e-07 W=1.13e-06 $X=7360 $Y=25430 $dt=16
M3118 463 726 1 1 pfet_01v8 L=1.5e-07 W=1.13e-06 $X=7360 $Y=33710 $dt=16
M3119 465 728 1 1 pfet_01v8 L=1.5e-07 W=1.13e-06 $X=7360 $Y=41990 $dt=16
M3120 467 730 1 1 pfet_01v8 L=1.5e-07 W=1.13e-06 $X=7360 $Y=50270 $dt=16
M3121 469 732 1 1 pfet_01v8 L=1.5e-07 W=1.13e-06 $X=7360 $Y=58550 $dt=16
M3122 471 734 1 1 pfet_01v8 L=1.5e-07 W=1.13e-06 $X=7360 $Y=66830 $dt=16
M3123 473 736 1 1 pfet_01v8 L=1.5e-07 W=1.13e-06 $X=7360 $Y=75110 $dt=16
M3124 475 738 1 1 pfet_01v8 L=1.5e-07 W=1.13e-06 $X=7360 $Y=83390 $dt=16
M3125 477 740 1 1 pfet_01v8 L=1.5e-07 W=1.13e-06 $X=7360 $Y=91670 $dt=16
M3126 479 742 1 1 pfet_01v8 L=1.5e-07 W=1.13e-06 $X=7360 $Y=99950 $dt=16
M3127 481 744 1 1 pfet_01v8 L=1.5e-07 W=1.13e-06 $X=7360 $Y=108230 $dt=16
M3128 483 746 1 1 pfet_01v8 L=1.5e-07 W=1.13e-06 $X=7360 $Y=116510 $dt=16
M3129 485 748 1 1 pfet_01v8 L=1.5e-07 W=1.13e-06 $X=7360 $Y=124790 $dt=16
M3130 487 750 1 1 pfet_01v8 L=1.5e-07 W=1.13e-06 $X=7360 $Y=133070 $dt=16
M3131 489 752 1 1 pfet_01v8 L=1.5e-07 W=1.13e-06 $X=7360 $Y=141350 $dt=16
M3132 491 754 1 1 pfet_01v8 L=1.5e-07 W=1.13e-06 $X=7360 $Y=149630 $dt=16
M3133 493 756 1 1 pfet_01v8 L=1.5e-07 W=1.13e-06 $X=7360 $Y=157910 $dt=16
M3134 1 776 534 1 pfet_01v8 L=1.5e-07 W=1.13e-06 $X=7760 $Y=14840 $dt=16
M3135 1 777 536 1 pfet_01v8 L=1.5e-07 W=1.13e-06 $X=7760 $Y=23120 $dt=16
M3136 1 778 538 1 pfet_01v8 L=1.5e-07 W=1.13e-06 $X=7760 $Y=31400 $dt=16
M3137 1 779 540 1 pfet_01v8 L=1.5e-07 W=1.13e-06 $X=7760 $Y=39680 $dt=16
M3138 1 780 542 1 pfet_01v8 L=1.5e-07 W=1.13e-06 $X=7760 $Y=47960 $dt=16
M3139 1 781 544 1 pfet_01v8 L=1.5e-07 W=1.13e-06 $X=7760 $Y=56240 $dt=16
M3140 1 782 546 1 pfet_01v8 L=1.5e-07 W=1.13e-06 $X=7760 $Y=64520 $dt=16
M3141 1 783 548 1 pfet_01v8 L=1.5e-07 W=1.13e-06 $X=7760 $Y=72800 $dt=16
M3142 1 784 550 1 pfet_01v8 L=1.5e-07 W=1.13e-06 $X=7760 $Y=81080 $dt=16
M3143 1 785 552 1 pfet_01v8 L=1.5e-07 W=1.13e-06 $X=7760 $Y=89360 $dt=16
M3144 1 786 554 1 pfet_01v8 L=1.5e-07 W=1.13e-06 $X=7760 $Y=97640 $dt=16
M3145 1 787 556 1 pfet_01v8 L=1.5e-07 W=1.13e-06 $X=7760 $Y=105920 $dt=16
M3146 1 788 558 1 pfet_01v8 L=1.5e-07 W=1.13e-06 $X=7760 $Y=114200 $dt=16
M3147 1 789 560 1 pfet_01v8 L=1.5e-07 W=1.13e-06 $X=7760 $Y=122480 $dt=16
M3148 1 790 562 1 pfet_01v8 L=1.5e-07 W=1.13e-06 $X=7760 $Y=130760 $dt=16
M3149 1 791 564 1 pfet_01v8 L=1.5e-07 W=1.13e-06 $X=7760 $Y=139040 $dt=16
M3150 1 792 566 1 pfet_01v8 L=1.5e-07 W=1.13e-06 $X=7760 $Y=147320 $dt=16
M3151 1 793 568 1 pfet_01v8 L=1.5e-07 W=1.13e-06 $X=7760 $Y=155600 $dt=16
M3152 1 794 570 1 pfet_01v8 L=1.5e-07 W=1.13e-06 $X=7760 $Y=163880 $dt=16
M3153 1 720 457 1 pfet_01v8 L=1.5e-07 W=1.13e-06 $X=7790 $Y=8870 $dt=16
M3154 1 722 459 1 pfet_01v8 L=1.5e-07 W=1.13e-06 $X=7790 $Y=17150 $dt=16
M3155 1 724 461 1 pfet_01v8 L=1.5e-07 W=1.13e-06 $X=7790 $Y=25430 $dt=16
M3156 1 726 463 1 pfet_01v8 L=1.5e-07 W=1.13e-06 $X=7790 $Y=33710 $dt=16
M3157 1 728 465 1 pfet_01v8 L=1.5e-07 W=1.13e-06 $X=7790 $Y=41990 $dt=16
M3158 1 730 467 1 pfet_01v8 L=1.5e-07 W=1.13e-06 $X=7790 $Y=50270 $dt=16
M3159 1 732 469 1 pfet_01v8 L=1.5e-07 W=1.13e-06 $X=7790 $Y=58550 $dt=16
M3160 1 734 471 1 pfet_01v8 L=1.5e-07 W=1.13e-06 $X=7790 $Y=66830 $dt=16
M3161 1 736 473 1 pfet_01v8 L=1.5e-07 W=1.13e-06 $X=7790 $Y=75110 $dt=16
M3162 1 738 475 1 pfet_01v8 L=1.5e-07 W=1.13e-06 $X=7790 $Y=83390 $dt=16
M3163 1 740 477 1 pfet_01v8 L=1.5e-07 W=1.13e-06 $X=7790 $Y=91670 $dt=16
M3164 1 742 479 1 pfet_01v8 L=1.5e-07 W=1.13e-06 $X=7790 $Y=99950 $dt=16
M3165 1 744 481 1 pfet_01v8 L=1.5e-07 W=1.13e-06 $X=7790 $Y=108230 $dt=16
M3166 1 746 483 1 pfet_01v8 L=1.5e-07 W=1.13e-06 $X=7790 $Y=116510 $dt=16
M3167 1 748 485 1 pfet_01v8 L=1.5e-07 W=1.13e-06 $X=7790 $Y=124790 $dt=16
M3168 1 750 487 1 pfet_01v8 L=1.5e-07 W=1.13e-06 $X=7790 $Y=133070 $dt=16
M3169 1 752 489 1 pfet_01v8 L=1.5e-07 W=1.13e-06 $X=7790 $Y=141350 $dt=16
M3170 1 754 491 1 pfet_01v8 L=1.5e-07 W=1.13e-06 $X=7790 $Y=149630 $dt=16
M3171 1 756 493 1 pfet_01v8 L=1.5e-07 W=1.13e-06 $X=7790 $Y=157910 $dt=16
M3172 533 719 1 1 pfet_01v8 L=1.5e-07 W=1.13e-06 $X=8800 $Y=8870 $dt=16
M3173 1 720 757 1 pfet_01v8 L=1.5e-07 W=1.13e-06 $X=8800 $Y=14840 $dt=16
M3174 535 721 1 1 pfet_01v8 L=1.5e-07 W=1.13e-06 $X=8800 $Y=17150 $dt=16
M3175 1 722 758 1 pfet_01v8 L=1.5e-07 W=1.13e-06 $X=8800 $Y=23120 $dt=16
M3176 537 723 1 1 pfet_01v8 L=1.5e-07 W=1.13e-06 $X=8800 $Y=25430 $dt=16
M3177 1 724 759 1 pfet_01v8 L=1.5e-07 W=1.13e-06 $X=8800 $Y=31400 $dt=16
M3178 539 725 1 1 pfet_01v8 L=1.5e-07 W=1.13e-06 $X=8800 $Y=33710 $dt=16
M3179 1 726 760 1 pfet_01v8 L=1.5e-07 W=1.13e-06 $X=8800 $Y=39680 $dt=16
M3180 541 727 1 1 pfet_01v8 L=1.5e-07 W=1.13e-06 $X=8800 $Y=41990 $dt=16
M3181 1 728 761 1 pfet_01v8 L=1.5e-07 W=1.13e-06 $X=8800 $Y=47960 $dt=16
M3182 543 729 1 1 pfet_01v8 L=1.5e-07 W=1.13e-06 $X=8800 $Y=50270 $dt=16
M3183 1 730 762 1 pfet_01v8 L=1.5e-07 W=1.13e-06 $X=8800 $Y=56240 $dt=16
M3184 545 731 1 1 pfet_01v8 L=1.5e-07 W=1.13e-06 $X=8800 $Y=58550 $dt=16
M3185 1 732 763 1 pfet_01v8 L=1.5e-07 W=1.13e-06 $X=8800 $Y=64520 $dt=16
M3186 547 733 1 1 pfet_01v8 L=1.5e-07 W=1.13e-06 $X=8800 $Y=66830 $dt=16
M3187 1 734 764 1 pfet_01v8 L=1.5e-07 W=1.13e-06 $X=8800 $Y=72800 $dt=16
M3188 549 735 1 1 pfet_01v8 L=1.5e-07 W=1.13e-06 $X=8800 $Y=75110 $dt=16
M3189 1 736 765 1 pfet_01v8 L=1.5e-07 W=1.13e-06 $X=8800 $Y=81080 $dt=16
M3190 551 737 1 1 pfet_01v8 L=1.5e-07 W=1.13e-06 $X=8800 $Y=83390 $dt=16
M3191 1 738 766 1 pfet_01v8 L=1.5e-07 W=1.13e-06 $X=8800 $Y=89360 $dt=16
M3192 553 739 1 1 pfet_01v8 L=1.5e-07 W=1.13e-06 $X=8800 $Y=91670 $dt=16
M3193 1 740 767 1 pfet_01v8 L=1.5e-07 W=1.13e-06 $X=8800 $Y=97640 $dt=16
M3194 555 741 1 1 pfet_01v8 L=1.5e-07 W=1.13e-06 $X=8800 $Y=99950 $dt=16
M3195 1 742 768 1 pfet_01v8 L=1.5e-07 W=1.13e-06 $X=8800 $Y=105920 $dt=16
M3196 557 743 1 1 pfet_01v8 L=1.5e-07 W=1.13e-06 $X=8800 $Y=108230 $dt=16
M3197 1 744 769 1 pfet_01v8 L=1.5e-07 W=1.13e-06 $X=8800 $Y=114200 $dt=16
M3198 559 745 1 1 pfet_01v8 L=1.5e-07 W=1.13e-06 $X=8800 $Y=116510 $dt=16
M3199 1 746 770 1 pfet_01v8 L=1.5e-07 W=1.13e-06 $X=8800 $Y=122480 $dt=16
M3200 561 747 1 1 pfet_01v8 L=1.5e-07 W=1.13e-06 $X=8800 $Y=124790 $dt=16
M3201 1 748 771 1 pfet_01v8 L=1.5e-07 W=1.13e-06 $X=8800 $Y=130760 $dt=16
M3202 563 749 1 1 pfet_01v8 L=1.5e-07 W=1.13e-06 $X=8800 $Y=133070 $dt=16
M3203 1 750 772 1 pfet_01v8 L=1.5e-07 W=1.13e-06 $X=8800 $Y=139040 $dt=16
M3204 565 751 1 1 pfet_01v8 L=1.5e-07 W=1.13e-06 $X=8800 $Y=141350 $dt=16
M3205 1 752 773 1 pfet_01v8 L=1.5e-07 W=1.13e-06 $X=8800 $Y=147320 $dt=16
M3206 567 753 1 1 pfet_01v8 L=1.5e-07 W=1.13e-06 $X=8800 $Y=149630 $dt=16
M3207 1 754 774 1 pfet_01v8 L=1.5e-07 W=1.13e-06 $X=8800 $Y=155600 $dt=16
M3208 569 755 1 1 pfet_01v8 L=1.5e-07 W=1.13e-06 $X=8800 $Y=157910 $dt=16
M3209 1 756 775 1 pfet_01v8 L=1.5e-07 W=1.13e-06 $X=8800 $Y=163880 $dt=16
M3210 1 719 533 1 pfet_01v8 L=1.5e-07 W=1.13e-06 $X=9230 $Y=8870 $dt=16
M3211 458 757 1 1 pfet_01v8 L=1.5e-07 W=1.13e-06 $X=9230 $Y=14840 $dt=16
M3212 1 721 535 1 pfet_01v8 L=1.5e-07 W=1.13e-06 $X=9230 $Y=17150 $dt=16
M3213 460 758 1 1 pfet_01v8 L=1.5e-07 W=1.13e-06 $X=9230 $Y=23120 $dt=16
M3214 1 723 537 1 pfet_01v8 L=1.5e-07 W=1.13e-06 $X=9230 $Y=25430 $dt=16
M3215 462 759 1 1 pfet_01v8 L=1.5e-07 W=1.13e-06 $X=9230 $Y=31400 $dt=16
M3216 1 725 539 1 pfet_01v8 L=1.5e-07 W=1.13e-06 $X=9230 $Y=33710 $dt=16
M3217 464 760 1 1 pfet_01v8 L=1.5e-07 W=1.13e-06 $X=9230 $Y=39680 $dt=16
M3218 1 727 541 1 pfet_01v8 L=1.5e-07 W=1.13e-06 $X=9230 $Y=41990 $dt=16
M3219 466 761 1 1 pfet_01v8 L=1.5e-07 W=1.13e-06 $X=9230 $Y=47960 $dt=16
M3220 1 729 543 1 pfet_01v8 L=1.5e-07 W=1.13e-06 $X=9230 $Y=50270 $dt=16
M3221 468 762 1 1 pfet_01v8 L=1.5e-07 W=1.13e-06 $X=9230 $Y=56240 $dt=16
M3222 1 731 545 1 pfet_01v8 L=1.5e-07 W=1.13e-06 $X=9230 $Y=58550 $dt=16
M3223 470 763 1 1 pfet_01v8 L=1.5e-07 W=1.13e-06 $X=9230 $Y=64520 $dt=16
M3224 1 733 547 1 pfet_01v8 L=1.5e-07 W=1.13e-06 $X=9230 $Y=66830 $dt=16
M3225 472 764 1 1 pfet_01v8 L=1.5e-07 W=1.13e-06 $X=9230 $Y=72800 $dt=16
M3226 1 735 549 1 pfet_01v8 L=1.5e-07 W=1.13e-06 $X=9230 $Y=75110 $dt=16
M3227 474 765 1 1 pfet_01v8 L=1.5e-07 W=1.13e-06 $X=9230 $Y=81080 $dt=16
M3228 1 737 551 1 pfet_01v8 L=1.5e-07 W=1.13e-06 $X=9230 $Y=83390 $dt=16
M3229 476 766 1 1 pfet_01v8 L=1.5e-07 W=1.13e-06 $X=9230 $Y=89360 $dt=16
M3230 1 739 553 1 pfet_01v8 L=1.5e-07 W=1.13e-06 $X=9230 $Y=91670 $dt=16
M3231 478 767 1 1 pfet_01v8 L=1.5e-07 W=1.13e-06 $X=9230 $Y=97640 $dt=16
M3232 1 741 555 1 pfet_01v8 L=1.5e-07 W=1.13e-06 $X=9230 $Y=99950 $dt=16
M3233 480 768 1 1 pfet_01v8 L=1.5e-07 W=1.13e-06 $X=9230 $Y=105920 $dt=16
M3234 1 743 557 1 pfet_01v8 L=1.5e-07 W=1.13e-06 $X=9230 $Y=108230 $dt=16
M3235 482 769 1 1 pfet_01v8 L=1.5e-07 W=1.13e-06 $X=9230 $Y=114200 $dt=16
M3236 1 745 559 1 pfet_01v8 L=1.5e-07 W=1.13e-06 $X=9230 $Y=116510 $dt=16
M3237 484 770 1 1 pfet_01v8 L=1.5e-07 W=1.13e-06 $X=9230 $Y=122480 $dt=16
M3238 1 747 561 1 pfet_01v8 L=1.5e-07 W=1.13e-06 $X=9230 $Y=124790 $dt=16
M3239 486 771 1 1 pfet_01v8 L=1.5e-07 W=1.13e-06 $X=9230 $Y=130760 $dt=16
M3240 1 749 563 1 pfet_01v8 L=1.5e-07 W=1.13e-06 $X=9230 $Y=133070 $dt=16
M3241 488 772 1 1 pfet_01v8 L=1.5e-07 W=1.13e-06 $X=9230 $Y=139040 $dt=16
M3242 1 751 565 1 pfet_01v8 L=1.5e-07 W=1.13e-06 $X=9230 $Y=141350 $dt=16
M3243 490 773 1 1 pfet_01v8 L=1.5e-07 W=1.13e-06 $X=9230 $Y=147320 $dt=16
M3244 1 753 567 1 pfet_01v8 L=1.5e-07 W=1.13e-06 $X=9230 $Y=149630 $dt=16
M3245 492 774 1 1 pfet_01v8 L=1.5e-07 W=1.13e-06 $X=9230 $Y=155600 $dt=16
M3246 1 755 569 1 pfet_01v8 L=1.5e-07 W=1.13e-06 $X=9230 $Y=157910 $dt=16
M3247 494 775 1 1 pfet_01v8 L=1.5e-07 W=1.13e-06 $X=9230 $Y=163880 $dt=16
M3248 533 719 1 1 pfet_01v8 L=1.5e-07 W=1.13e-06 $X=9660 $Y=8870 $dt=16
M3249 1 757 458 1 pfet_01v8 L=1.5e-07 W=1.13e-06 $X=9660 $Y=14840 $dt=16
M3250 535 721 1 1 pfet_01v8 L=1.5e-07 W=1.13e-06 $X=9660 $Y=17150 $dt=16
M3251 1 758 460 1 pfet_01v8 L=1.5e-07 W=1.13e-06 $X=9660 $Y=23120 $dt=16
M3252 537 723 1 1 pfet_01v8 L=1.5e-07 W=1.13e-06 $X=9660 $Y=25430 $dt=16
M3253 1 759 462 1 pfet_01v8 L=1.5e-07 W=1.13e-06 $X=9660 $Y=31400 $dt=16
M3254 539 725 1 1 pfet_01v8 L=1.5e-07 W=1.13e-06 $X=9660 $Y=33710 $dt=16
M3255 1 760 464 1 pfet_01v8 L=1.5e-07 W=1.13e-06 $X=9660 $Y=39680 $dt=16
M3256 541 727 1 1 pfet_01v8 L=1.5e-07 W=1.13e-06 $X=9660 $Y=41990 $dt=16
M3257 1 761 466 1 pfet_01v8 L=1.5e-07 W=1.13e-06 $X=9660 $Y=47960 $dt=16
M3258 543 729 1 1 pfet_01v8 L=1.5e-07 W=1.13e-06 $X=9660 $Y=50270 $dt=16
M3259 1 762 468 1 pfet_01v8 L=1.5e-07 W=1.13e-06 $X=9660 $Y=56240 $dt=16
M3260 545 731 1 1 pfet_01v8 L=1.5e-07 W=1.13e-06 $X=9660 $Y=58550 $dt=16
M3261 1 763 470 1 pfet_01v8 L=1.5e-07 W=1.13e-06 $X=9660 $Y=64520 $dt=16
M3262 547 733 1 1 pfet_01v8 L=1.5e-07 W=1.13e-06 $X=9660 $Y=66830 $dt=16
M3263 1 764 472 1 pfet_01v8 L=1.5e-07 W=1.13e-06 $X=9660 $Y=72800 $dt=16
M3264 549 735 1 1 pfet_01v8 L=1.5e-07 W=1.13e-06 $X=9660 $Y=75110 $dt=16
M3265 1 765 474 1 pfet_01v8 L=1.5e-07 W=1.13e-06 $X=9660 $Y=81080 $dt=16
M3266 551 737 1 1 pfet_01v8 L=1.5e-07 W=1.13e-06 $X=9660 $Y=83390 $dt=16
M3267 1 766 476 1 pfet_01v8 L=1.5e-07 W=1.13e-06 $X=9660 $Y=89360 $dt=16
M3268 553 739 1 1 pfet_01v8 L=1.5e-07 W=1.13e-06 $X=9660 $Y=91670 $dt=16
M3269 1 767 478 1 pfet_01v8 L=1.5e-07 W=1.13e-06 $X=9660 $Y=97640 $dt=16
M3270 555 741 1 1 pfet_01v8 L=1.5e-07 W=1.13e-06 $X=9660 $Y=99950 $dt=16
M3271 1 768 480 1 pfet_01v8 L=1.5e-07 W=1.13e-06 $X=9660 $Y=105920 $dt=16
M3272 557 743 1 1 pfet_01v8 L=1.5e-07 W=1.13e-06 $X=9660 $Y=108230 $dt=16
M3273 1 769 482 1 pfet_01v8 L=1.5e-07 W=1.13e-06 $X=9660 $Y=114200 $dt=16
M3274 559 745 1 1 pfet_01v8 L=1.5e-07 W=1.13e-06 $X=9660 $Y=116510 $dt=16
M3275 1 770 484 1 pfet_01v8 L=1.5e-07 W=1.13e-06 $X=9660 $Y=122480 $dt=16
M3276 561 747 1 1 pfet_01v8 L=1.5e-07 W=1.13e-06 $X=9660 $Y=124790 $dt=16
M3277 1 771 486 1 pfet_01v8 L=1.5e-07 W=1.13e-06 $X=9660 $Y=130760 $dt=16
M3278 563 749 1 1 pfet_01v8 L=1.5e-07 W=1.13e-06 $X=9660 $Y=133070 $dt=16
M3279 1 772 488 1 pfet_01v8 L=1.5e-07 W=1.13e-06 $X=9660 $Y=139040 $dt=16
M3280 565 751 1 1 pfet_01v8 L=1.5e-07 W=1.13e-06 $X=9660 $Y=141350 $dt=16
M3281 1 773 490 1 pfet_01v8 L=1.5e-07 W=1.13e-06 $X=9660 $Y=147320 $dt=16
M3282 567 753 1 1 pfet_01v8 L=1.5e-07 W=1.13e-06 $X=9660 $Y=149630 $dt=16
M3283 1 774 492 1 pfet_01v8 L=1.5e-07 W=1.13e-06 $X=9660 $Y=155600 $dt=16
M3284 569 755 1 1 pfet_01v8 L=1.5e-07 W=1.13e-06 $X=9660 $Y=157910 $dt=16
M3285 1 775 494 1 pfet_01v8 L=1.5e-07 W=1.13e-06 $X=9660 $Y=163880 $dt=16
M3286 1 719 533 1 pfet_01v8 L=1.5e-07 W=1.13e-06 $X=10090 $Y=8870 $dt=16
M3287 458 757 1 1 pfet_01v8 L=1.5e-07 W=1.13e-06 $X=10090 $Y=14840 $dt=16
M3288 1 721 535 1 pfet_01v8 L=1.5e-07 W=1.13e-06 $X=10090 $Y=17150 $dt=16
M3289 460 758 1 1 pfet_01v8 L=1.5e-07 W=1.13e-06 $X=10090 $Y=23120 $dt=16
M3290 1 723 537 1 pfet_01v8 L=1.5e-07 W=1.13e-06 $X=10090 $Y=25430 $dt=16
M3291 462 759 1 1 pfet_01v8 L=1.5e-07 W=1.13e-06 $X=10090 $Y=31400 $dt=16
M3292 1 725 539 1 pfet_01v8 L=1.5e-07 W=1.13e-06 $X=10090 $Y=33710 $dt=16
M3293 464 760 1 1 pfet_01v8 L=1.5e-07 W=1.13e-06 $X=10090 $Y=39680 $dt=16
M3294 1 727 541 1 pfet_01v8 L=1.5e-07 W=1.13e-06 $X=10090 $Y=41990 $dt=16
M3295 466 761 1 1 pfet_01v8 L=1.5e-07 W=1.13e-06 $X=10090 $Y=47960 $dt=16
M3296 1 729 543 1 pfet_01v8 L=1.5e-07 W=1.13e-06 $X=10090 $Y=50270 $dt=16
M3297 468 762 1 1 pfet_01v8 L=1.5e-07 W=1.13e-06 $X=10090 $Y=56240 $dt=16
M3298 1 731 545 1 pfet_01v8 L=1.5e-07 W=1.13e-06 $X=10090 $Y=58550 $dt=16
M3299 470 763 1 1 pfet_01v8 L=1.5e-07 W=1.13e-06 $X=10090 $Y=64520 $dt=16
M3300 1 733 547 1 pfet_01v8 L=1.5e-07 W=1.13e-06 $X=10090 $Y=66830 $dt=16
M3301 472 764 1 1 pfet_01v8 L=1.5e-07 W=1.13e-06 $X=10090 $Y=72800 $dt=16
M3302 1 735 549 1 pfet_01v8 L=1.5e-07 W=1.13e-06 $X=10090 $Y=75110 $dt=16
M3303 474 765 1 1 pfet_01v8 L=1.5e-07 W=1.13e-06 $X=10090 $Y=81080 $dt=16
M3304 1 737 551 1 pfet_01v8 L=1.5e-07 W=1.13e-06 $X=10090 $Y=83390 $dt=16
M3305 476 766 1 1 pfet_01v8 L=1.5e-07 W=1.13e-06 $X=10090 $Y=89360 $dt=16
M3306 1 739 553 1 pfet_01v8 L=1.5e-07 W=1.13e-06 $X=10090 $Y=91670 $dt=16
M3307 478 767 1 1 pfet_01v8 L=1.5e-07 W=1.13e-06 $X=10090 $Y=97640 $dt=16
M3308 1 741 555 1 pfet_01v8 L=1.5e-07 W=1.13e-06 $X=10090 $Y=99950 $dt=16
M3309 480 768 1 1 pfet_01v8 L=1.5e-07 W=1.13e-06 $X=10090 $Y=105920 $dt=16
M3310 1 743 557 1 pfet_01v8 L=1.5e-07 W=1.13e-06 $X=10090 $Y=108230 $dt=16
M3311 482 769 1 1 pfet_01v8 L=1.5e-07 W=1.13e-06 $X=10090 $Y=114200 $dt=16
M3312 1 745 559 1 pfet_01v8 L=1.5e-07 W=1.13e-06 $X=10090 $Y=116510 $dt=16
M3313 484 770 1 1 pfet_01v8 L=1.5e-07 W=1.13e-06 $X=10090 $Y=122480 $dt=16
M3314 1 747 561 1 pfet_01v8 L=1.5e-07 W=1.13e-06 $X=10090 $Y=124790 $dt=16
M3315 486 771 1 1 pfet_01v8 L=1.5e-07 W=1.13e-06 $X=10090 $Y=130760 $dt=16
M3316 1 749 563 1 pfet_01v8 L=1.5e-07 W=1.13e-06 $X=10090 $Y=133070 $dt=16
M3317 488 772 1 1 pfet_01v8 L=1.5e-07 W=1.13e-06 $X=10090 $Y=139040 $dt=16
M3318 1 751 565 1 pfet_01v8 L=1.5e-07 W=1.13e-06 $X=10090 $Y=141350 $dt=16
M3319 490 773 1 1 pfet_01v8 L=1.5e-07 W=1.13e-06 $X=10090 $Y=147320 $dt=16
M3320 1 753 567 1 pfet_01v8 L=1.5e-07 W=1.13e-06 $X=10090 $Y=149630 $dt=16
M3321 492 774 1 1 pfet_01v8 L=1.5e-07 W=1.13e-06 $X=10090 $Y=155600 $dt=16
M3322 1 755 569 1 pfet_01v8 L=1.5e-07 W=1.13e-06 $X=10090 $Y=157910 $dt=16
M3323 494 775 1 1 pfet_01v8 L=1.5e-07 W=1.13e-06 $X=10090 $Y=163880 $dt=16
M3324 1 757 458 1 pfet_01v8 L=1.5e-07 W=1.13e-06 $X=10520 $Y=14840 $dt=16
M3325 1 758 460 1 pfet_01v8 L=1.5e-07 W=1.13e-06 $X=10520 $Y=23120 $dt=16
M3326 1 759 462 1 pfet_01v8 L=1.5e-07 W=1.13e-06 $X=10520 $Y=31400 $dt=16
M3327 1 760 464 1 pfet_01v8 L=1.5e-07 W=1.13e-06 $X=10520 $Y=39680 $dt=16
M3328 1 761 466 1 pfet_01v8 L=1.5e-07 W=1.13e-06 $X=10520 $Y=47960 $dt=16
M3329 1 762 468 1 pfet_01v8 L=1.5e-07 W=1.13e-06 $X=10520 $Y=56240 $dt=16
M3330 1 763 470 1 pfet_01v8 L=1.5e-07 W=1.13e-06 $X=10520 $Y=64520 $dt=16
M3331 1 764 472 1 pfet_01v8 L=1.5e-07 W=1.13e-06 $X=10520 $Y=72800 $dt=16
M3332 1 765 474 1 pfet_01v8 L=1.5e-07 W=1.13e-06 $X=10520 $Y=81080 $dt=16
M3333 1 766 476 1 pfet_01v8 L=1.5e-07 W=1.13e-06 $X=10520 $Y=89360 $dt=16
M3334 1 767 478 1 pfet_01v8 L=1.5e-07 W=1.13e-06 $X=10520 $Y=97640 $dt=16
M3335 1 768 480 1 pfet_01v8 L=1.5e-07 W=1.13e-06 $X=10520 $Y=105920 $dt=16
M3336 1 769 482 1 pfet_01v8 L=1.5e-07 W=1.13e-06 $X=10520 $Y=114200 $dt=16
M3337 1 770 484 1 pfet_01v8 L=1.5e-07 W=1.13e-06 $X=10520 $Y=122480 $dt=16
M3338 1 771 486 1 pfet_01v8 L=1.5e-07 W=1.13e-06 $X=10520 $Y=130760 $dt=16
M3339 1 772 488 1 pfet_01v8 L=1.5e-07 W=1.13e-06 $X=10520 $Y=139040 $dt=16
M3340 1 773 490 1 pfet_01v8 L=1.5e-07 W=1.13e-06 $X=10520 $Y=147320 $dt=16
M3341 1 774 492 1 pfet_01v8 L=1.5e-07 W=1.13e-06 $X=10520 $Y=155600 $dt=16
M3342 1 775 494 1 pfet_01v8 L=1.5e-07 W=1.13e-06 $X=10520 $Y=163880 $dt=16
M3343 700 681 1 1 pfet_01v8 L=1.5e-07 W=1.13e-06 $X=11560 $Y=14840 $dt=16
M3344 701 682 1 1 pfet_01v8 L=1.5e-07 W=1.13e-06 $X=11560 $Y=23120 $dt=16
M3345 702 683 1 1 pfet_01v8 L=1.5e-07 W=1.13e-06 $X=11560 $Y=31400 $dt=16
M3346 703 684 1 1 pfet_01v8 L=1.5e-07 W=1.13e-06 $X=11560 $Y=39680 $dt=16
M3347 704 685 1 1 pfet_01v8 L=1.5e-07 W=1.13e-06 $X=11560 $Y=47960 $dt=16
M3348 705 686 1 1 pfet_01v8 L=1.5e-07 W=1.13e-06 $X=11560 $Y=56240 $dt=16
M3349 706 687 1 1 pfet_01v8 L=1.5e-07 W=1.13e-06 $X=11560 $Y=64520 $dt=16
M3350 707 688 1 1 pfet_01v8 L=1.5e-07 W=1.13e-06 $X=11560 $Y=72800 $dt=16
M3351 708 689 1 1 pfet_01v8 L=1.5e-07 W=1.13e-06 $X=11560 $Y=81080 $dt=16
M3352 709 690 1 1 pfet_01v8 L=1.5e-07 W=1.13e-06 $X=11560 $Y=89360 $dt=16
M3353 710 691 1 1 pfet_01v8 L=1.5e-07 W=1.13e-06 $X=11560 $Y=97640 $dt=16
M3354 711 692 1 1 pfet_01v8 L=1.5e-07 W=1.13e-06 $X=11560 $Y=105920 $dt=16
M3355 712 693 1 1 pfet_01v8 L=1.5e-07 W=1.13e-06 $X=11560 $Y=114200 $dt=16
M3356 713 694 1 1 pfet_01v8 L=1.5e-07 W=1.13e-06 $X=11560 $Y=122480 $dt=16
M3357 714 695 1 1 pfet_01v8 L=1.5e-07 W=1.13e-06 $X=11560 $Y=130760 $dt=16
M3358 715 696 1 1 pfet_01v8 L=1.5e-07 W=1.13e-06 $X=11560 $Y=139040 $dt=16
M3359 716 697 1 1 pfet_01v8 L=1.5e-07 W=1.13e-06 $X=11560 $Y=147320 $dt=16
M3360 717 698 1 1 pfet_01v8 L=1.5e-07 W=1.13e-06 $X=11560 $Y=155600 $dt=16
M3361 718 699 1 1 pfet_01v8 L=1.5e-07 W=1.13e-06 $X=11560 $Y=163880 $dt=16
M3362 1 681 700 1 pfet_01v8 L=1.5e-07 W=1.13e-06 $X=11990 $Y=14840 $dt=16
M3363 1 682 701 1 pfet_01v8 L=1.5e-07 W=1.13e-06 $X=11990 $Y=23120 $dt=16
M3364 1 683 702 1 pfet_01v8 L=1.5e-07 W=1.13e-06 $X=11990 $Y=31400 $dt=16
M3365 1 684 703 1 pfet_01v8 L=1.5e-07 W=1.13e-06 $X=11990 $Y=39680 $dt=16
M3366 1 685 704 1 pfet_01v8 L=1.5e-07 W=1.13e-06 $X=11990 $Y=47960 $dt=16
M3367 1 686 705 1 pfet_01v8 L=1.5e-07 W=1.13e-06 $X=11990 $Y=56240 $dt=16
M3368 1 687 706 1 pfet_01v8 L=1.5e-07 W=1.13e-06 $X=11990 $Y=64520 $dt=16
M3369 1 688 707 1 pfet_01v8 L=1.5e-07 W=1.13e-06 $X=11990 $Y=72800 $dt=16
M3370 1 689 708 1 pfet_01v8 L=1.5e-07 W=1.13e-06 $X=11990 $Y=81080 $dt=16
M3371 1 690 709 1 pfet_01v8 L=1.5e-07 W=1.13e-06 $X=11990 $Y=89360 $dt=16
M3372 1 691 710 1 pfet_01v8 L=1.5e-07 W=1.13e-06 $X=11990 $Y=97640 $dt=16
M3373 1 692 711 1 pfet_01v8 L=1.5e-07 W=1.13e-06 $X=11990 $Y=105920 $dt=16
M3374 1 693 712 1 pfet_01v8 L=1.5e-07 W=1.13e-06 $X=11990 $Y=114200 $dt=16
M3375 1 694 713 1 pfet_01v8 L=1.5e-07 W=1.13e-06 $X=11990 $Y=122480 $dt=16
M3376 1 695 714 1 pfet_01v8 L=1.5e-07 W=1.13e-06 $X=11990 $Y=130760 $dt=16
M3377 1 696 715 1 pfet_01v8 L=1.5e-07 W=1.13e-06 $X=11990 $Y=139040 $dt=16
M3378 1 697 716 1 pfet_01v8 L=1.5e-07 W=1.13e-06 $X=11990 $Y=147320 $dt=16
M3379 1 698 717 1 pfet_01v8 L=1.5e-07 W=1.13e-06 $X=11990 $Y=155600 $dt=16
M3380 1 699 718 1 pfet_01v8 L=1.5e-07 W=1.13e-06 $X=11990 $Y=163880 $dt=16
M3381 495 700 1 1 pfet_01v8 L=1.5e-07 W=1.13e-06 $X=12420 $Y=14840 $dt=16
M3382 496 701 1 1 pfet_01v8 L=1.5e-07 W=1.13e-06 $X=12420 $Y=23120 $dt=16
M3383 497 702 1 1 pfet_01v8 L=1.5e-07 W=1.13e-06 $X=12420 $Y=31400 $dt=16
M3384 498 703 1 1 pfet_01v8 L=1.5e-07 W=1.13e-06 $X=12420 $Y=39680 $dt=16
M3385 499 704 1 1 pfet_01v8 L=1.5e-07 W=1.13e-06 $X=12420 $Y=47960 $dt=16
M3386 500 705 1 1 pfet_01v8 L=1.5e-07 W=1.13e-06 $X=12420 $Y=56240 $dt=16
M3387 501 706 1 1 pfet_01v8 L=1.5e-07 W=1.13e-06 $X=12420 $Y=64520 $dt=16
M3388 502 707 1 1 pfet_01v8 L=1.5e-07 W=1.13e-06 $X=12420 $Y=72800 $dt=16
M3389 503 708 1 1 pfet_01v8 L=1.5e-07 W=1.13e-06 $X=12420 $Y=81080 $dt=16
M3390 504 709 1 1 pfet_01v8 L=1.5e-07 W=1.13e-06 $X=12420 $Y=89360 $dt=16
M3391 505 710 1 1 pfet_01v8 L=1.5e-07 W=1.13e-06 $X=12420 $Y=97640 $dt=16
M3392 506 711 1 1 pfet_01v8 L=1.5e-07 W=1.13e-06 $X=12420 $Y=105920 $dt=16
M3393 507 712 1 1 pfet_01v8 L=1.5e-07 W=1.13e-06 $X=12420 $Y=114200 $dt=16
M3394 508 713 1 1 pfet_01v8 L=1.5e-07 W=1.13e-06 $X=12420 $Y=122480 $dt=16
M3395 509 714 1 1 pfet_01v8 L=1.5e-07 W=1.13e-06 $X=12420 $Y=130760 $dt=16
M3396 510 715 1 1 pfet_01v8 L=1.5e-07 W=1.13e-06 $X=12420 $Y=139040 $dt=16
M3397 511 716 1 1 pfet_01v8 L=1.5e-07 W=1.13e-06 $X=12420 $Y=147320 $dt=16
M3398 512 717 1 1 pfet_01v8 L=1.5e-07 W=1.13e-06 $X=12420 $Y=155600 $dt=16
M3399 513 718 1 1 pfet_01v8 L=1.5e-07 W=1.13e-06 $X=12420 $Y=163880 $dt=16
M3400 514 681 1 1 pfet_01v8 L=1.5e-07 W=1.13e-06 $X=12480 $Y=8870 $dt=16
M3401 515 682 1 1 pfet_01v8 L=1.5e-07 W=1.13e-06 $X=12480 $Y=17150 $dt=16
M3402 516 683 1 1 pfet_01v8 L=1.5e-07 W=1.13e-06 $X=12480 $Y=25430 $dt=16
M3403 517 684 1 1 pfet_01v8 L=1.5e-07 W=1.13e-06 $X=12480 $Y=33710 $dt=16
M3404 518 685 1 1 pfet_01v8 L=1.5e-07 W=1.13e-06 $X=12480 $Y=41990 $dt=16
M3405 519 686 1 1 pfet_01v8 L=1.5e-07 W=1.13e-06 $X=12480 $Y=50270 $dt=16
M3406 520 687 1 1 pfet_01v8 L=1.5e-07 W=1.13e-06 $X=12480 $Y=58550 $dt=16
M3407 521 688 1 1 pfet_01v8 L=1.5e-07 W=1.13e-06 $X=12480 $Y=66830 $dt=16
M3408 522 689 1 1 pfet_01v8 L=1.5e-07 W=1.13e-06 $X=12480 $Y=75110 $dt=16
M3409 523 690 1 1 pfet_01v8 L=1.5e-07 W=1.13e-06 $X=12480 $Y=83390 $dt=16
M3410 524 691 1 1 pfet_01v8 L=1.5e-07 W=1.13e-06 $X=12480 $Y=91670 $dt=16
M3411 525 692 1 1 pfet_01v8 L=1.5e-07 W=1.13e-06 $X=12480 $Y=99950 $dt=16
M3412 526 693 1 1 pfet_01v8 L=1.5e-07 W=1.13e-06 $X=12480 $Y=108230 $dt=16
M3413 527 694 1 1 pfet_01v8 L=1.5e-07 W=1.13e-06 $X=12480 $Y=116510 $dt=16
M3414 528 695 1 1 pfet_01v8 L=1.5e-07 W=1.13e-06 $X=12480 $Y=124790 $dt=16
M3415 529 696 1 1 pfet_01v8 L=1.5e-07 W=1.13e-06 $X=12480 $Y=133070 $dt=16
M3416 530 697 1 1 pfet_01v8 L=1.5e-07 W=1.13e-06 $X=12480 $Y=141350 $dt=16
M3417 531 698 1 1 pfet_01v8 L=1.5e-07 W=1.13e-06 $X=12480 $Y=149630 $dt=16
M3418 532 699 1 1 pfet_01v8 L=1.5e-07 W=1.13e-06 $X=12480 $Y=157910 $dt=16
M3419 1 700 495 1 pfet_01v8 L=1.5e-07 W=1.13e-06 $X=12850 $Y=14840 $dt=16
M3420 1 701 496 1 pfet_01v8 L=1.5e-07 W=1.13e-06 $X=12850 $Y=23120 $dt=16
M3421 1 702 497 1 pfet_01v8 L=1.5e-07 W=1.13e-06 $X=12850 $Y=31400 $dt=16
M3422 1 703 498 1 pfet_01v8 L=1.5e-07 W=1.13e-06 $X=12850 $Y=39680 $dt=16
M3423 1 704 499 1 pfet_01v8 L=1.5e-07 W=1.13e-06 $X=12850 $Y=47960 $dt=16
M3424 1 705 500 1 pfet_01v8 L=1.5e-07 W=1.13e-06 $X=12850 $Y=56240 $dt=16
M3425 1 706 501 1 pfet_01v8 L=1.5e-07 W=1.13e-06 $X=12850 $Y=64520 $dt=16
M3426 1 707 502 1 pfet_01v8 L=1.5e-07 W=1.13e-06 $X=12850 $Y=72800 $dt=16
M3427 1 708 503 1 pfet_01v8 L=1.5e-07 W=1.13e-06 $X=12850 $Y=81080 $dt=16
M3428 1 709 504 1 pfet_01v8 L=1.5e-07 W=1.13e-06 $X=12850 $Y=89360 $dt=16
M3429 1 710 505 1 pfet_01v8 L=1.5e-07 W=1.13e-06 $X=12850 $Y=97640 $dt=16
M3430 1 711 506 1 pfet_01v8 L=1.5e-07 W=1.13e-06 $X=12850 $Y=105920 $dt=16
M3431 1 712 507 1 pfet_01v8 L=1.5e-07 W=1.13e-06 $X=12850 $Y=114200 $dt=16
M3432 1 713 508 1 pfet_01v8 L=1.5e-07 W=1.13e-06 $X=12850 $Y=122480 $dt=16
M3433 1 714 509 1 pfet_01v8 L=1.5e-07 W=1.13e-06 $X=12850 $Y=130760 $dt=16
M3434 1 715 510 1 pfet_01v8 L=1.5e-07 W=1.13e-06 $X=12850 $Y=139040 $dt=16
M3435 1 716 511 1 pfet_01v8 L=1.5e-07 W=1.13e-06 $X=12850 $Y=147320 $dt=16
M3436 1 717 512 1 pfet_01v8 L=1.5e-07 W=1.13e-06 $X=12850 $Y=155600 $dt=16
M3437 1 718 513 1 pfet_01v8 L=1.5e-07 W=1.13e-06 $X=12850 $Y=163880 $dt=16
M3438 1 681 514 1 pfet_01v8 L=1.5e-07 W=1.13e-06 $X=12910 $Y=8870 $dt=16
M3439 1 682 515 1 pfet_01v8 L=1.5e-07 W=1.13e-06 $X=12910 $Y=17150 $dt=16
M3440 1 683 516 1 pfet_01v8 L=1.5e-07 W=1.13e-06 $X=12910 $Y=25430 $dt=16
M3441 1 684 517 1 pfet_01v8 L=1.5e-07 W=1.13e-06 $X=12910 $Y=33710 $dt=16
M3442 1 685 518 1 pfet_01v8 L=1.5e-07 W=1.13e-06 $X=12910 $Y=41990 $dt=16
M3443 1 686 519 1 pfet_01v8 L=1.5e-07 W=1.13e-06 $X=12910 $Y=50270 $dt=16
M3444 1 687 520 1 pfet_01v8 L=1.5e-07 W=1.13e-06 $X=12910 $Y=58550 $dt=16
M3445 1 688 521 1 pfet_01v8 L=1.5e-07 W=1.13e-06 $X=12910 $Y=66830 $dt=16
M3446 1 689 522 1 pfet_01v8 L=1.5e-07 W=1.13e-06 $X=12910 $Y=75110 $dt=16
M3447 1 690 523 1 pfet_01v8 L=1.5e-07 W=1.13e-06 $X=12910 $Y=83390 $dt=16
M3448 1 691 524 1 pfet_01v8 L=1.5e-07 W=1.13e-06 $X=12910 $Y=91670 $dt=16
M3449 1 692 525 1 pfet_01v8 L=1.5e-07 W=1.13e-06 $X=12910 $Y=99950 $dt=16
M3450 1 693 526 1 pfet_01v8 L=1.5e-07 W=1.13e-06 $X=12910 $Y=108230 $dt=16
M3451 1 694 527 1 pfet_01v8 L=1.5e-07 W=1.13e-06 $X=12910 $Y=116510 $dt=16
M3452 1 695 528 1 pfet_01v8 L=1.5e-07 W=1.13e-06 $X=12910 $Y=124790 $dt=16
M3453 1 696 529 1 pfet_01v8 L=1.5e-07 W=1.13e-06 $X=12910 $Y=133070 $dt=16
M3454 1 697 530 1 pfet_01v8 L=1.5e-07 W=1.13e-06 $X=12910 $Y=141350 $dt=16
M3455 1 698 531 1 pfet_01v8 L=1.5e-07 W=1.13e-06 $X=12910 $Y=149630 $dt=16
M3456 1 699 532 1 pfet_01v8 L=1.5e-07 W=1.13e-06 $X=12910 $Y=157910 $dt=16
M3457 495 700 1 1 pfet_01v8 L=1.5e-07 W=1.13e-06 $X=13280 $Y=14840 $dt=16
M3458 496 701 1 1 pfet_01v8 L=1.5e-07 W=1.13e-06 $X=13280 $Y=23120 $dt=16
M3459 497 702 1 1 pfet_01v8 L=1.5e-07 W=1.13e-06 $X=13280 $Y=31400 $dt=16
M3460 498 703 1 1 pfet_01v8 L=1.5e-07 W=1.13e-06 $X=13280 $Y=39680 $dt=16
M3461 499 704 1 1 pfet_01v8 L=1.5e-07 W=1.13e-06 $X=13280 $Y=47960 $dt=16
M3462 500 705 1 1 pfet_01v8 L=1.5e-07 W=1.13e-06 $X=13280 $Y=56240 $dt=16
M3463 501 706 1 1 pfet_01v8 L=1.5e-07 W=1.13e-06 $X=13280 $Y=64520 $dt=16
M3464 502 707 1 1 pfet_01v8 L=1.5e-07 W=1.13e-06 $X=13280 $Y=72800 $dt=16
M3465 503 708 1 1 pfet_01v8 L=1.5e-07 W=1.13e-06 $X=13280 $Y=81080 $dt=16
M3466 504 709 1 1 pfet_01v8 L=1.5e-07 W=1.13e-06 $X=13280 $Y=89360 $dt=16
M3467 505 710 1 1 pfet_01v8 L=1.5e-07 W=1.13e-06 $X=13280 $Y=97640 $dt=16
M3468 506 711 1 1 pfet_01v8 L=1.5e-07 W=1.13e-06 $X=13280 $Y=105920 $dt=16
M3469 507 712 1 1 pfet_01v8 L=1.5e-07 W=1.13e-06 $X=13280 $Y=114200 $dt=16
M3470 508 713 1 1 pfet_01v8 L=1.5e-07 W=1.13e-06 $X=13280 $Y=122480 $dt=16
M3471 509 714 1 1 pfet_01v8 L=1.5e-07 W=1.13e-06 $X=13280 $Y=130760 $dt=16
M3472 510 715 1 1 pfet_01v8 L=1.5e-07 W=1.13e-06 $X=13280 $Y=139040 $dt=16
M3473 511 716 1 1 pfet_01v8 L=1.5e-07 W=1.13e-06 $X=13280 $Y=147320 $dt=16
M3474 512 717 1 1 pfet_01v8 L=1.5e-07 W=1.13e-06 $X=13280 $Y=155600 $dt=16
M3475 513 718 1 1 pfet_01v8 L=1.5e-07 W=1.13e-06 $X=13280 $Y=163880 $dt=16
M3476 514 681 1 1 pfet_01v8 L=1.5e-07 W=1.13e-06 $X=13340 $Y=8870 $dt=16
M3477 515 682 1 1 pfet_01v8 L=1.5e-07 W=1.13e-06 $X=13340 $Y=17150 $dt=16
M3478 516 683 1 1 pfet_01v8 L=1.5e-07 W=1.13e-06 $X=13340 $Y=25430 $dt=16
M3479 517 684 1 1 pfet_01v8 L=1.5e-07 W=1.13e-06 $X=13340 $Y=33710 $dt=16
M3480 518 685 1 1 pfet_01v8 L=1.5e-07 W=1.13e-06 $X=13340 $Y=41990 $dt=16
M3481 519 686 1 1 pfet_01v8 L=1.5e-07 W=1.13e-06 $X=13340 $Y=50270 $dt=16
M3482 520 687 1 1 pfet_01v8 L=1.5e-07 W=1.13e-06 $X=13340 $Y=58550 $dt=16
M3483 521 688 1 1 pfet_01v8 L=1.5e-07 W=1.13e-06 $X=13340 $Y=66830 $dt=16
M3484 522 689 1 1 pfet_01v8 L=1.5e-07 W=1.13e-06 $X=13340 $Y=75110 $dt=16
M3485 523 690 1 1 pfet_01v8 L=1.5e-07 W=1.13e-06 $X=13340 $Y=83390 $dt=16
M3486 524 691 1 1 pfet_01v8 L=1.5e-07 W=1.13e-06 $X=13340 $Y=91670 $dt=16
M3487 525 692 1 1 pfet_01v8 L=1.5e-07 W=1.13e-06 $X=13340 $Y=99950 $dt=16
M3488 526 693 1 1 pfet_01v8 L=1.5e-07 W=1.13e-06 $X=13340 $Y=108230 $dt=16
M3489 527 694 1 1 pfet_01v8 L=1.5e-07 W=1.13e-06 $X=13340 $Y=116510 $dt=16
M3490 528 695 1 1 pfet_01v8 L=1.5e-07 W=1.13e-06 $X=13340 $Y=124790 $dt=16
M3491 529 696 1 1 pfet_01v8 L=1.5e-07 W=1.13e-06 $X=13340 $Y=133070 $dt=16
M3492 530 697 1 1 pfet_01v8 L=1.5e-07 W=1.13e-06 $X=13340 $Y=141350 $dt=16
M3493 531 698 1 1 pfet_01v8 L=1.5e-07 W=1.13e-06 $X=13340 $Y=149630 $dt=16
M3494 532 699 1 1 pfet_01v8 L=1.5e-07 W=1.13e-06 $X=13340 $Y=157910 $dt=16
M3495 1 700 495 1 pfet_01v8 L=1.5e-07 W=1.13e-06 $X=13710 $Y=14840 $dt=16
M3496 1 701 496 1 pfet_01v8 L=1.5e-07 W=1.13e-06 $X=13710 $Y=23120 $dt=16
M3497 1 702 497 1 pfet_01v8 L=1.5e-07 W=1.13e-06 $X=13710 $Y=31400 $dt=16
M3498 1 703 498 1 pfet_01v8 L=1.5e-07 W=1.13e-06 $X=13710 $Y=39680 $dt=16
M3499 1 704 499 1 pfet_01v8 L=1.5e-07 W=1.13e-06 $X=13710 $Y=47960 $dt=16
M3500 1 705 500 1 pfet_01v8 L=1.5e-07 W=1.13e-06 $X=13710 $Y=56240 $dt=16
M3501 1 706 501 1 pfet_01v8 L=1.5e-07 W=1.13e-06 $X=13710 $Y=64520 $dt=16
M3502 1 707 502 1 pfet_01v8 L=1.5e-07 W=1.13e-06 $X=13710 $Y=72800 $dt=16
M3503 1 708 503 1 pfet_01v8 L=1.5e-07 W=1.13e-06 $X=13710 $Y=81080 $dt=16
M3504 1 709 504 1 pfet_01v8 L=1.5e-07 W=1.13e-06 $X=13710 $Y=89360 $dt=16
M3505 1 710 505 1 pfet_01v8 L=1.5e-07 W=1.13e-06 $X=13710 $Y=97640 $dt=16
M3506 1 711 506 1 pfet_01v8 L=1.5e-07 W=1.13e-06 $X=13710 $Y=105920 $dt=16
M3507 1 712 507 1 pfet_01v8 L=1.5e-07 W=1.13e-06 $X=13710 $Y=114200 $dt=16
M3508 1 713 508 1 pfet_01v8 L=1.5e-07 W=1.13e-06 $X=13710 $Y=122480 $dt=16
M3509 1 714 509 1 pfet_01v8 L=1.5e-07 W=1.13e-06 $X=13710 $Y=130760 $dt=16
M3510 1 715 510 1 pfet_01v8 L=1.5e-07 W=1.13e-06 $X=13710 $Y=139040 $dt=16
M3511 1 716 511 1 pfet_01v8 L=1.5e-07 W=1.13e-06 $X=13710 $Y=147320 $dt=16
M3512 1 717 512 1 pfet_01v8 L=1.5e-07 W=1.13e-06 $X=13710 $Y=155600 $dt=16
M3513 1 718 513 1 pfet_01v8 L=1.5e-07 W=1.13e-06 $X=13710 $Y=163880 $dt=16
M3514 1 681 514 1 pfet_01v8 L=1.5e-07 W=1.13e-06 $X=13770 $Y=8870 $dt=16
M3515 1 682 515 1 pfet_01v8 L=1.5e-07 W=1.13e-06 $X=13770 $Y=17150 $dt=16
M3516 1 683 516 1 pfet_01v8 L=1.5e-07 W=1.13e-06 $X=13770 $Y=25430 $dt=16
M3517 1 684 517 1 pfet_01v8 L=1.5e-07 W=1.13e-06 $X=13770 $Y=33710 $dt=16
M3518 1 685 518 1 pfet_01v8 L=1.5e-07 W=1.13e-06 $X=13770 $Y=41990 $dt=16
M3519 1 686 519 1 pfet_01v8 L=1.5e-07 W=1.13e-06 $X=13770 $Y=50270 $dt=16
M3520 1 687 520 1 pfet_01v8 L=1.5e-07 W=1.13e-06 $X=13770 $Y=58550 $dt=16
M3521 1 688 521 1 pfet_01v8 L=1.5e-07 W=1.13e-06 $X=13770 $Y=66830 $dt=16
M3522 1 689 522 1 pfet_01v8 L=1.5e-07 W=1.13e-06 $X=13770 $Y=75110 $dt=16
M3523 1 690 523 1 pfet_01v8 L=1.5e-07 W=1.13e-06 $X=13770 $Y=83390 $dt=16
M3524 1 691 524 1 pfet_01v8 L=1.5e-07 W=1.13e-06 $X=13770 $Y=91670 $dt=16
M3525 1 692 525 1 pfet_01v8 L=1.5e-07 W=1.13e-06 $X=13770 $Y=99950 $dt=16
M3526 1 693 526 1 pfet_01v8 L=1.5e-07 W=1.13e-06 $X=13770 $Y=108230 $dt=16
M3527 1 694 527 1 pfet_01v8 L=1.5e-07 W=1.13e-06 $X=13770 $Y=116510 $dt=16
M3528 1 695 528 1 pfet_01v8 L=1.5e-07 W=1.13e-06 $X=13770 $Y=124790 $dt=16
M3529 1 696 529 1 pfet_01v8 L=1.5e-07 W=1.13e-06 $X=13770 $Y=133070 $dt=16
M3530 1 697 530 1 pfet_01v8 L=1.5e-07 W=1.13e-06 $X=13770 $Y=141350 $dt=16
M3531 1 698 531 1 pfet_01v8 L=1.5e-07 W=1.13e-06 $X=13770 $Y=149630 $dt=16
M3532 1 699 532 1 pfet_01v8 L=1.5e-07 W=1.13e-06 $X=13770 $Y=157910 $dt=16
M3533 495 700 1 1 pfet_01v8 L=1.5e-07 W=1.13e-06 $X=14140 $Y=14840 $dt=16
M3534 496 701 1 1 pfet_01v8 L=1.5e-07 W=1.13e-06 $X=14140 $Y=23120 $dt=16
M3535 497 702 1 1 pfet_01v8 L=1.5e-07 W=1.13e-06 $X=14140 $Y=31400 $dt=16
M3536 498 703 1 1 pfet_01v8 L=1.5e-07 W=1.13e-06 $X=14140 $Y=39680 $dt=16
M3537 499 704 1 1 pfet_01v8 L=1.5e-07 W=1.13e-06 $X=14140 $Y=47960 $dt=16
M3538 500 705 1 1 pfet_01v8 L=1.5e-07 W=1.13e-06 $X=14140 $Y=56240 $dt=16
M3539 501 706 1 1 pfet_01v8 L=1.5e-07 W=1.13e-06 $X=14140 $Y=64520 $dt=16
M3540 502 707 1 1 pfet_01v8 L=1.5e-07 W=1.13e-06 $X=14140 $Y=72800 $dt=16
M3541 503 708 1 1 pfet_01v8 L=1.5e-07 W=1.13e-06 $X=14140 $Y=81080 $dt=16
M3542 504 709 1 1 pfet_01v8 L=1.5e-07 W=1.13e-06 $X=14140 $Y=89360 $dt=16
M3543 505 710 1 1 pfet_01v8 L=1.5e-07 W=1.13e-06 $X=14140 $Y=97640 $dt=16
M3544 506 711 1 1 pfet_01v8 L=1.5e-07 W=1.13e-06 $X=14140 $Y=105920 $dt=16
M3545 507 712 1 1 pfet_01v8 L=1.5e-07 W=1.13e-06 $X=14140 $Y=114200 $dt=16
M3546 508 713 1 1 pfet_01v8 L=1.5e-07 W=1.13e-06 $X=14140 $Y=122480 $dt=16
M3547 509 714 1 1 pfet_01v8 L=1.5e-07 W=1.13e-06 $X=14140 $Y=130760 $dt=16
M3548 510 715 1 1 pfet_01v8 L=1.5e-07 W=1.13e-06 $X=14140 $Y=139040 $dt=16
M3549 511 716 1 1 pfet_01v8 L=1.5e-07 W=1.13e-06 $X=14140 $Y=147320 $dt=16
M3550 512 717 1 1 pfet_01v8 L=1.5e-07 W=1.13e-06 $X=14140 $Y=155600 $dt=16
M3551 513 718 1 1 pfet_01v8 L=1.5e-07 W=1.13e-06 $X=14140 $Y=163880 $dt=16
M3552 514 681 1 1 pfet_01v8 L=1.5e-07 W=1.13e-06 $X=14200 $Y=8870 $dt=16
M3553 515 682 1 1 pfet_01v8 L=1.5e-07 W=1.13e-06 $X=14200 $Y=17150 $dt=16
M3554 516 683 1 1 pfet_01v8 L=1.5e-07 W=1.13e-06 $X=14200 $Y=25430 $dt=16
M3555 517 684 1 1 pfet_01v8 L=1.5e-07 W=1.13e-06 $X=14200 $Y=33710 $dt=16
M3556 518 685 1 1 pfet_01v8 L=1.5e-07 W=1.13e-06 $X=14200 $Y=41990 $dt=16
M3557 519 686 1 1 pfet_01v8 L=1.5e-07 W=1.13e-06 $X=14200 $Y=50270 $dt=16
M3558 520 687 1 1 pfet_01v8 L=1.5e-07 W=1.13e-06 $X=14200 $Y=58550 $dt=16
M3559 521 688 1 1 pfet_01v8 L=1.5e-07 W=1.13e-06 $X=14200 $Y=66830 $dt=16
M3560 522 689 1 1 pfet_01v8 L=1.5e-07 W=1.13e-06 $X=14200 $Y=75110 $dt=16
M3561 523 690 1 1 pfet_01v8 L=1.5e-07 W=1.13e-06 $X=14200 $Y=83390 $dt=16
M3562 524 691 1 1 pfet_01v8 L=1.5e-07 W=1.13e-06 $X=14200 $Y=91670 $dt=16
M3563 525 692 1 1 pfet_01v8 L=1.5e-07 W=1.13e-06 $X=14200 $Y=99950 $dt=16
M3564 526 693 1 1 pfet_01v8 L=1.5e-07 W=1.13e-06 $X=14200 $Y=108230 $dt=16
M3565 527 694 1 1 pfet_01v8 L=1.5e-07 W=1.13e-06 $X=14200 $Y=116510 $dt=16
M3566 528 695 1 1 pfet_01v8 L=1.5e-07 W=1.13e-06 $X=14200 $Y=124790 $dt=16
M3567 529 696 1 1 pfet_01v8 L=1.5e-07 W=1.13e-06 $X=14200 $Y=133070 $dt=16
M3568 530 697 1 1 pfet_01v8 L=1.5e-07 W=1.13e-06 $X=14200 $Y=141350 $dt=16
M3569 531 698 1 1 pfet_01v8 L=1.5e-07 W=1.13e-06 $X=14200 $Y=149630 $dt=16
M3570 532 699 1 1 pfet_01v8 L=1.5e-07 W=1.13e-06 $X=14200 $Y=157910 $dt=16
M3571 1 700 495 1 pfet_01v8 L=1.5e-07 W=1.13e-06 $X=14570 $Y=14840 $dt=16
M3572 1 701 496 1 pfet_01v8 L=1.5e-07 W=1.13e-06 $X=14570 $Y=23120 $dt=16
M3573 1 702 497 1 pfet_01v8 L=1.5e-07 W=1.13e-06 $X=14570 $Y=31400 $dt=16
M3574 1 703 498 1 pfet_01v8 L=1.5e-07 W=1.13e-06 $X=14570 $Y=39680 $dt=16
M3575 1 704 499 1 pfet_01v8 L=1.5e-07 W=1.13e-06 $X=14570 $Y=47960 $dt=16
M3576 1 705 500 1 pfet_01v8 L=1.5e-07 W=1.13e-06 $X=14570 $Y=56240 $dt=16
M3577 1 706 501 1 pfet_01v8 L=1.5e-07 W=1.13e-06 $X=14570 $Y=64520 $dt=16
M3578 1 707 502 1 pfet_01v8 L=1.5e-07 W=1.13e-06 $X=14570 $Y=72800 $dt=16
M3579 1 708 503 1 pfet_01v8 L=1.5e-07 W=1.13e-06 $X=14570 $Y=81080 $dt=16
M3580 1 709 504 1 pfet_01v8 L=1.5e-07 W=1.13e-06 $X=14570 $Y=89360 $dt=16
M3581 1 710 505 1 pfet_01v8 L=1.5e-07 W=1.13e-06 $X=14570 $Y=97640 $dt=16
M3582 1 711 506 1 pfet_01v8 L=1.5e-07 W=1.13e-06 $X=14570 $Y=105920 $dt=16
M3583 1 712 507 1 pfet_01v8 L=1.5e-07 W=1.13e-06 $X=14570 $Y=114200 $dt=16
M3584 1 713 508 1 pfet_01v8 L=1.5e-07 W=1.13e-06 $X=14570 $Y=122480 $dt=16
M3585 1 714 509 1 pfet_01v8 L=1.5e-07 W=1.13e-06 $X=14570 $Y=130760 $dt=16
M3586 1 715 510 1 pfet_01v8 L=1.5e-07 W=1.13e-06 $X=14570 $Y=139040 $dt=16
M3587 1 716 511 1 pfet_01v8 L=1.5e-07 W=1.13e-06 $X=14570 $Y=147320 $dt=16
M3588 1 717 512 1 pfet_01v8 L=1.5e-07 W=1.13e-06 $X=14570 $Y=155600 $dt=16
M3589 1 718 513 1 pfet_01v8 L=1.5e-07 W=1.13e-06 $X=14570 $Y=163880 $dt=16
M3590 1 681 514 1 pfet_01v8 L=1.5e-07 W=1.13e-06 $X=14630 $Y=8870 $dt=16
M3591 1 682 515 1 pfet_01v8 L=1.5e-07 W=1.13e-06 $X=14630 $Y=17150 $dt=16
M3592 1 683 516 1 pfet_01v8 L=1.5e-07 W=1.13e-06 $X=14630 $Y=25430 $dt=16
M3593 1 684 517 1 pfet_01v8 L=1.5e-07 W=1.13e-06 $X=14630 $Y=33710 $dt=16
M3594 1 685 518 1 pfet_01v8 L=1.5e-07 W=1.13e-06 $X=14630 $Y=41990 $dt=16
M3595 1 686 519 1 pfet_01v8 L=1.5e-07 W=1.13e-06 $X=14630 $Y=50270 $dt=16
M3596 1 687 520 1 pfet_01v8 L=1.5e-07 W=1.13e-06 $X=14630 $Y=58550 $dt=16
M3597 1 688 521 1 pfet_01v8 L=1.5e-07 W=1.13e-06 $X=14630 $Y=66830 $dt=16
M3598 1 689 522 1 pfet_01v8 L=1.5e-07 W=1.13e-06 $X=14630 $Y=75110 $dt=16
M3599 1 690 523 1 pfet_01v8 L=1.5e-07 W=1.13e-06 $X=14630 $Y=83390 $dt=16
M3600 1 691 524 1 pfet_01v8 L=1.5e-07 W=1.13e-06 $X=14630 $Y=91670 $dt=16
M3601 1 692 525 1 pfet_01v8 L=1.5e-07 W=1.13e-06 $X=14630 $Y=99950 $dt=16
M3602 1 693 526 1 pfet_01v8 L=1.5e-07 W=1.13e-06 $X=14630 $Y=108230 $dt=16
M3603 1 694 527 1 pfet_01v8 L=1.5e-07 W=1.13e-06 $X=14630 $Y=116510 $dt=16
M3604 1 695 528 1 pfet_01v8 L=1.5e-07 W=1.13e-06 $X=14630 $Y=124790 $dt=16
M3605 1 696 529 1 pfet_01v8 L=1.5e-07 W=1.13e-06 $X=14630 $Y=133070 $dt=16
M3606 1 697 530 1 pfet_01v8 L=1.5e-07 W=1.13e-06 $X=14630 $Y=141350 $dt=16
M3607 1 698 531 1 pfet_01v8 L=1.5e-07 W=1.13e-06 $X=14630 $Y=149630 $dt=16
M3608 1 699 532 1 pfet_01v8 L=1.5e-07 W=1.13e-06 $X=14630 $Y=157910 $dt=16
M3609 495 700 1 1 pfet_01v8 L=1.5e-07 W=1.13e-06 $X=15000 $Y=14840 $dt=16
M3610 496 701 1 1 pfet_01v8 L=1.5e-07 W=1.13e-06 $X=15000 $Y=23120 $dt=16
M3611 497 702 1 1 pfet_01v8 L=1.5e-07 W=1.13e-06 $X=15000 $Y=31400 $dt=16
M3612 498 703 1 1 pfet_01v8 L=1.5e-07 W=1.13e-06 $X=15000 $Y=39680 $dt=16
M3613 499 704 1 1 pfet_01v8 L=1.5e-07 W=1.13e-06 $X=15000 $Y=47960 $dt=16
M3614 500 705 1 1 pfet_01v8 L=1.5e-07 W=1.13e-06 $X=15000 $Y=56240 $dt=16
M3615 501 706 1 1 pfet_01v8 L=1.5e-07 W=1.13e-06 $X=15000 $Y=64520 $dt=16
M3616 502 707 1 1 pfet_01v8 L=1.5e-07 W=1.13e-06 $X=15000 $Y=72800 $dt=16
M3617 503 708 1 1 pfet_01v8 L=1.5e-07 W=1.13e-06 $X=15000 $Y=81080 $dt=16
M3618 504 709 1 1 pfet_01v8 L=1.5e-07 W=1.13e-06 $X=15000 $Y=89360 $dt=16
M3619 505 710 1 1 pfet_01v8 L=1.5e-07 W=1.13e-06 $X=15000 $Y=97640 $dt=16
M3620 506 711 1 1 pfet_01v8 L=1.5e-07 W=1.13e-06 $X=15000 $Y=105920 $dt=16
M3621 507 712 1 1 pfet_01v8 L=1.5e-07 W=1.13e-06 $X=15000 $Y=114200 $dt=16
M3622 508 713 1 1 pfet_01v8 L=1.5e-07 W=1.13e-06 $X=15000 $Y=122480 $dt=16
M3623 509 714 1 1 pfet_01v8 L=1.5e-07 W=1.13e-06 $X=15000 $Y=130760 $dt=16
M3624 510 715 1 1 pfet_01v8 L=1.5e-07 W=1.13e-06 $X=15000 $Y=139040 $dt=16
M3625 511 716 1 1 pfet_01v8 L=1.5e-07 W=1.13e-06 $X=15000 $Y=147320 $dt=16
M3626 512 717 1 1 pfet_01v8 L=1.5e-07 W=1.13e-06 $X=15000 $Y=155600 $dt=16
M3627 513 718 1 1 pfet_01v8 L=1.5e-07 W=1.13e-06 $X=15000 $Y=163880 $dt=16
M3628 514 681 1 1 pfet_01v8 L=1.5e-07 W=1.13e-06 $X=15060 $Y=8870 $dt=16
M3629 515 682 1 1 pfet_01v8 L=1.5e-07 W=1.13e-06 $X=15060 $Y=17150 $dt=16
M3630 516 683 1 1 pfet_01v8 L=1.5e-07 W=1.13e-06 $X=15060 $Y=25430 $dt=16
M3631 517 684 1 1 pfet_01v8 L=1.5e-07 W=1.13e-06 $X=15060 $Y=33710 $dt=16
M3632 518 685 1 1 pfet_01v8 L=1.5e-07 W=1.13e-06 $X=15060 $Y=41990 $dt=16
M3633 519 686 1 1 pfet_01v8 L=1.5e-07 W=1.13e-06 $X=15060 $Y=50270 $dt=16
M3634 520 687 1 1 pfet_01v8 L=1.5e-07 W=1.13e-06 $X=15060 $Y=58550 $dt=16
M3635 521 688 1 1 pfet_01v8 L=1.5e-07 W=1.13e-06 $X=15060 $Y=66830 $dt=16
M3636 522 689 1 1 pfet_01v8 L=1.5e-07 W=1.13e-06 $X=15060 $Y=75110 $dt=16
M3637 523 690 1 1 pfet_01v8 L=1.5e-07 W=1.13e-06 $X=15060 $Y=83390 $dt=16
M3638 524 691 1 1 pfet_01v8 L=1.5e-07 W=1.13e-06 $X=15060 $Y=91670 $dt=16
M3639 525 692 1 1 pfet_01v8 L=1.5e-07 W=1.13e-06 $X=15060 $Y=99950 $dt=16
M3640 526 693 1 1 pfet_01v8 L=1.5e-07 W=1.13e-06 $X=15060 $Y=108230 $dt=16
M3641 527 694 1 1 pfet_01v8 L=1.5e-07 W=1.13e-06 $X=15060 $Y=116510 $dt=16
M3642 528 695 1 1 pfet_01v8 L=1.5e-07 W=1.13e-06 $X=15060 $Y=124790 $dt=16
M3643 529 696 1 1 pfet_01v8 L=1.5e-07 W=1.13e-06 $X=15060 $Y=133070 $dt=16
M3644 530 697 1 1 pfet_01v8 L=1.5e-07 W=1.13e-06 $X=15060 $Y=141350 $dt=16
M3645 531 698 1 1 pfet_01v8 L=1.5e-07 W=1.13e-06 $X=15060 $Y=149630 $dt=16
M3646 532 699 1 1 pfet_01v8 L=1.5e-07 W=1.13e-06 $X=15060 $Y=157910 $dt=16
M3647 1 700 495 1 pfet_01v8 L=1.5e-07 W=1.13e-06 $X=15430 $Y=14840 $dt=16
M3648 1 701 496 1 pfet_01v8 L=1.5e-07 W=1.13e-06 $X=15430 $Y=23120 $dt=16
M3649 1 702 497 1 pfet_01v8 L=1.5e-07 W=1.13e-06 $X=15430 $Y=31400 $dt=16
M3650 1 703 498 1 pfet_01v8 L=1.5e-07 W=1.13e-06 $X=15430 $Y=39680 $dt=16
M3651 1 704 499 1 pfet_01v8 L=1.5e-07 W=1.13e-06 $X=15430 $Y=47960 $dt=16
M3652 1 705 500 1 pfet_01v8 L=1.5e-07 W=1.13e-06 $X=15430 $Y=56240 $dt=16
M3653 1 706 501 1 pfet_01v8 L=1.5e-07 W=1.13e-06 $X=15430 $Y=64520 $dt=16
M3654 1 707 502 1 pfet_01v8 L=1.5e-07 W=1.13e-06 $X=15430 $Y=72800 $dt=16
M3655 1 708 503 1 pfet_01v8 L=1.5e-07 W=1.13e-06 $X=15430 $Y=81080 $dt=16
M3656 1 709 504 1 pfet_01v8 L=1.5e-07 W=1.13e-06 $X=15430 $Y=89360 $dt=16
M3657 1 710 505 1 pfet_01v8 L=1.5e-07 W=1.13e-06 $X=15430 $Y=97640 $dt=16
M3658 1 711 506 1 pfet_01v8 L=1.5e-07 W=1.13e-06 $X=15430 $Y=105920 $dt=16
M3659 1 712 507 1 pfet_01v8 L=1.5e-07 W=1.13e-06 $X=15430 $Y=114200 $dt=16
M3660 1 713 508 1 pfet_01v8 L=1.5e-07 W=1.13e-06 $X=15430 $Y=122480 $dt=16
M3661 1 714 509 1 pfet_01v8 L=1.5e-07 W=1.13e-06 $X=15430 $Y=130760 $dt=16
M3662 1 715 510 1 pfet_01v8 L=1.5e-07 W=1.13e-06 $X=15430 $Y=139040 $dt=16
M3663 1 716 511 1 pfet_01v8 L=1.5e-07 W=1.13e-06 $X=15430 $Y=147320 $dt=16
M3664 1 717 512 1 pfet_01v8 L=1.5e-07 W=1.13e-06 $X=15430 $Y=155600 $dt=16
M3665 1 718 513 1 pfet_01v8 L=1.5e-07 W=1.13e-06 $X=15430 $Y=163880 $dt=16
M3666 1 681 514 1 pfet_01v8 L=1.5e-07 W=1.13e-06 $X=15490 $Y=8870 $dt=16
M3667 1 682 515 1 pfet_01v8 L=1.5e-07 W=1.13e-06 $X=15490 $Y=17150 $dt=16
M3668 1 683 516 1 pfet_01v8 L=1.5e-07 W=1.13e-06 $X=15490 $Y=25430 $dt=16
M3669 1 684 517 1 pfet_01v8 L=1.5e-07 W=1.13e-06 $X=15490 $Y=33710 $dt=16
M3670 1 685 518 1 pfet_01v8 L=1.5e-07 W=1.13e-06 $X=15490 $Y=41990 $dt=16
M3671 1 686 519 1 pfet_01v8 L=1.5e-07 W=1.13e-06 $X=15490 $Y=50270 $dt=16
M3672 1 687 520 1 pfet_01v8 L=1.5e-07 W=1.13e-06 $X=15490 $Y=58550 $dt=16
M3673 1 688 521 1 pfet_01v8 L=1.5e-07 W=1.13e-06 $X=15490 $Y=66830 $dt=16
M3674 1 689 522 1 pfet_01v8 L=1.5e-07 W=1.13e-06 $X=15490 $Y=75110 $dt=16
M3675 1 690 523 1 pfet_01v8 L=1.5e-07 W=1.13e-06 $X=15490 $Y=83390 $dt=16
M3676 1 691 524 1 pfet_01v8 L=1.5e-07 W=1.13e-06 $X=15490 $Y=91670 $dt=16
M3677 1 692 525 1 pfet_01v8 L=1.5e-07 W=1.13e-06 $X=15490 $Y=99950 $dt=16
M3678 1 693 526 1 pfet_01v8 L=1.5e-07 W=1.13e-06 $X=15490 $Y=108230 $dt=16
M3679 1 694 527 1 pfet_01v8 L=1.5e-07 W=1.13e-06 $X=15490 $Y=116510 $dt=16
M3680 1 695 528 1 pfet_01v8 L=1.5e-07 W=1.13e-06 $X=15490 $Y=124790 $dt=16
M3681 1 696 529 1 pfet_01v8 L=1.5e-07 W=1.13e-06 $X=15490 $Y=133070 $dt=16
M3682 1 697 530 1 pfet_01v8 L=1.5e-07 W=1.13e-06 $X=15490 $Y=141350 $dt=16
M3683 1 698 531 1 pfet_01v8 L=1.5e-07 W=1.13e-06 $X=15490 $Y=149630 $dt=16
M3684 1 699 532 1 pfet_01v8 L=1.5e-07 W=1.13e-06 $X=15490 $Y=157910 $dt=16
M3685 667 533 324 1 pfet_01v8 L=1.5e-07 W=1.5e-06 $X=17630 $Y=10150 $dt=16
M3686 668 535 324 1 pfet_01v8 L=1.5e-07 W=1.5e-06 $X=17630 $Y=18430 $dt=16
M3687 669 537 324 1 pfet_01v8 L=1.5e-07 W=1.5e-06 $X=17630 $Y=26710 $dt=16
M3688 670 539 324 1 pfet_01v8 L=1.5e-07 W=1.5e-06 $X=17630 $Y=34990 $dt=16
M3689 671 541 324 1 pfet_01v8 L=1.5e-07 W=1.5e-06 $X=17630 $Y=43270 $dt=16
M3690 672 543 324 1 pfet_01v8 L=1.5e-07 W=1.5e-06 $X=17630 $Y=51550 $dt=16
M3691 673 545 324 1 pfet_01v8 L=1.5e-07 W=1.5e-06 $X=17630 $Y=59830 $dt=16
M3692 1 3 1 1 pfet_01v8 L=5.8e-07 W=1.5e-06 $X=17630 $Y=68110 $dt=16
M3693 1 3 1 1 pfet_01v8 L=5.8e-07 W=1.5e-06 $X=17630 $Y=76390 $dt=16
M3694 1 3 1 1 pfet_01v8 L=5.8e-07 W=1.5e-06 $X=17630 $Y=84670 $dt=16
M3695 1 3 1 1 pfet_01v8 L=5.8e-07 W=1.5e-06 $X=17630 $Y=92950 $dt=16
M3696 1 3 1 1 pfet_01v8 L=5.8e-07 W=1.5e-06 $X=17630 $Y=101230 $dt=16
M3697 674 557 324 1 pfet_01v8 L=1.5e-07 W=1.5e-06 $X=17630 $Y=109510 $dt=16
M3698 675 559 324 1 pfet_01v8 L=1.5e-07 W=1.5e-06 $X=17630 $Y=117790 $dt=16
M3699 676 561 324 1 pfet_01v8 L=1.5e-07 W=1.5e-06 $X=17630 $Y=126070 $dt=16
M3700 677 563 324 1 pfet_01v8 L=1.5e-07 W=1.5e-06 $X=17630 $Y=134350 $dt=16
M3701 678 565 324 1 pfet_01v8 L=1.5e-07 W=1.5e-06 $X=17630 $Y=142630 $dt=16
M3702 679 567 324 1 pfet_01v8 L=1.5e-07 W=1.5e-06 $X=17630 $Y=150910 $dt=16
M3703 680 569 324 1 pfet_01v8 L=1.5e-07 W=1.5e-06 $X=17630 $Y=159190 $dt=16
M3704 309 514 667 1 pfet_01v8 L=1.5e-07 W=1.5e-06 $X=18060 $Y=10150 $dt=16
M3705 309 515 668 1 pfet_01v8 L=1.5e-07 W=1.5e-06 $X=18060 $Y=18430 $dt=16
M3706 309 516 669 1 pfet_01v8 L=1.5e-07 W=1.5e-06 $X=18060 $Y=26710 $dt=16
M3707 309 517 670 1 pfet_01v8 L=1.5e-07 W=1.5e-06 $X=18060 $Y=34990 $dt=16
M3708 309 518 671 1 pfet_01v8 L=1.5e-07 W=1.5e-06 $X=18060 $Y=43270 $dt=16
M3709 309 519 672 1 pfet_01v8 L=1.5e-07 W=1.5e-06 $X=18060 $Y=51550 $dt=16
M3710 309 520 673 1 pfet_01v8 L=1.5e-07 W=1.5e-06 $X=18060 $Y=59830 $dt=16
M3711 309 526 674 1 pfet_01v8 L=1.5e-07 W=1.5e-06 $X=18060 $Y=109510 $dt=16
M3712 309 527 675 1 pfet_01v8 L=1.5e-07 W=1.5e-06 $X=18060 $Y=117790 $dt=16
M3713 309 528 676 1 pfet_01v8 L=1.5e-07 W=1.5e-06 $X=18060 $Y=126070 $dt=16
M3714 309 529 677 1 pfet_01v8 L=1.5e-07 W=1.5e-06 $X=18060 $Y=134350 $dt=16
M3715 309 530 678 1 pfet_01v8 L=1.5e-07 W=1.5e-06 $X=18060 $Y=142630 $dt=16
M3716 309 531 679 1 pfet_01v8 L=1.5e-07 W=1.5e-06 $X=18060 $Y=150910 $dt=16
M3717 309 532 680 1 pfet_01v8 L=1.5e-07 W=1.5e-06 $X=18060 $Y=159190 $dt=16
M3718 1 3 1 1 pfet_01v8 L=5.8e-07 W=1.5e-06 $X=23750 $Y=68110 $dt=16
M3719 1 3 1 1 pfet_01v8 L=5.8e-07 W=1.5e-06 $X=23750 $Y=76390 $dt=16
M3720 1 3 1 1 pfet_01v8 L=5.8e-07 W=1.5e-06 $X=23750 $Y=84670 $dt=16
M3721 1 3 1 1 pfet_01v8 L=5.8e-07 W=1.5e-06 $X=23750 $Y=92950 $dt=16
M3722 1 3 1 1 pfet_01v8 L=5.8e-07 W=1.5e-06 $X=23750 $Y=101230 $dt=16
M3723 667 495 667 1 pfet_01v8 L=1.5e-07 W=1.5e-06 $X=23760 $Y=10150 $dt=16
M3724 668 496 668 1 pfet_01v8 L=1.5e-07 W=1.5e-06 $X=23760 $Y=18430 $dt=16
M3725 669 497 669 1 pfet_01v8 L=1.5e-07 W=1.5e-06 $X=23760 $Y=26710 $dt=16
M3726 670 498 670 1 pfet_01v8 L=1.5e-07 W=1.5e-06 $X=23760 $Y=34990 $dt=16
M3727 671 499 671 1 pfet_01v8 L=1.5e-07 W=1.5e-06 $X=23760 $Y=43270 $dt=16
M3728 672 500 672 1 pfet_01v8 L=1.5e-07 W=1.5e-06 $X=23760 $Y=51550 $dt=16
M3729 673 501 673 1 pfet_01v8 L=1.5e-07 W=1.5e-06 $X=23760 $Y=59830 $dt=16
M3730 674 507 674 1 pfet_01v8 L=1.5e-07 W=1.5e-06 $X=23760 $Y=109510 $dt=16
M3731 675 508 675 1 pfet_01v8 L=1.5e-07 W=1.5e-06 $X=23760 $Y=117790 $dt=16
M3732 676 509 676 1 pfet_01v8 L=1.5e-07 W=1.5e-06 $X=23760 $Y=126070 $dt=16
M3733 677 510 677 1 pfet_01v8 L=1.5e-07 W=1.5e-06 $X=23760 $Y=134350 $dt=16
M3734 678 511 678 1 pfet_01v8 L=1.5e-07 W=1.5e-06 $X=23760 $Y=142630 $dt=16
M3735 679 512 679 1 pfet_01v8 L=1.5e-07 W=1.5e-06 $X=23760 $Y=150910 $dt=16
M3736 680 513 680 1 pfet_01v8 L=1.5e-07 W=1.5e-06 $X=23760 $Y=159190 $dt=16
M3737 308 457 667 1 pfet_01v8 L=1.5e-07 W=1.5e-06 $X=24190 $Y=10150 $dt=16
M3738 308 459 668 1 pfet_01v8 L=1.5e-07 W=1.5e-06 $X=24190 $Y=18430 $dt=16
M3739 308 461 669 1 pfet_01v8 L=1.5e-07 W=1.5e-06 $X=24190 $Y=26710 $dt=16
M3740 308 463 670 1 pfet_01v8 L=1.5e-07 W=1.5e-06 $X=24190 $Y=34990 $dt=16
M3741 308 465 671 1 pfet_01v8 L=1.5e-07 W=1.5e-06 $X=24190 $Y=43270 $dt=16
M3742 308 467 672 1 pfet_01v8 L=1.5e-07 W=1.5e-06 $X=24190 $Y=51550 $dt=16
M3743 308 469 673 1 pfet_01v8 L=1.5e-07 W=1.5e-06 $X=24190 $Y=59830 $dt=16
M3744 308 481 674 1 pfet_01v8 L=1.5e-07 W=1.5e-06 $X=24190 $Y=109510 $dt=16
M3745 308 483 675 1 pfet_01v8 L=1.5e-07 W=1.5e-06 $X=24190 $Y=117790 $dt=16
M3746 308 485 676 1 pfet_01v8 L=1.5e-07 W=1.5e-06 $X=24190 $Y=126070 $dt=16
M3747 308 487 677 1 pfet_01v8 L=1.5e-07 W=1.5e-06 $X=24190 $Y=134350 $dt=16
M3748 308 489 678 1 pfet_01v8 L=1.5e-07 W=1.5e-06 $X=24190 $Y=142630 $dt=16
M3749 308 491 679 1 pfet_01v8 L=1.5e-07 W=1.5e-06 $X=24190 $Y=150910 $dt=16
M3750 308 493 680 1 pfet_01v8 L=1.5e-07 W=1.5e-06 $X=24190 $Y=159190 $dt=16
M3751 653 533 324 1 pfet_01v8 L=1.5e-07 W=1.5e-06 $X=25910 $Y=10150 $dt=16
M3752 654 535 324 1 pfet_01v8 L=1.5e-07 W=1.5e-06 $X=25910 $Y=18430 $dt=16
M3753 655 537 324 1 pfet_01v8 L=1.5e-07 W=1.5e-06 $X=25910 $Y=26710 $dt=16
M3754 656 539 324 1 pfet_01v8 L=1.5e-07 W=1.5e-06 $X=25910 $Y=34990 $dt=16
M3755 657 541 324 1 pfet_01v8 L=1.5e-07 W=1.5e-06 $X=25910 $Y=43270 $dt=16
M3756 658 543 324 1 pfet_01v8 L=1.5e-07 W=1.5e-06 $X=25910 $Y=51550 $dt=16
M3757 659 545 324 1 pfet_01v8 L=1.5e-07 W=1.5e-06 $X=25910 $Y=59830 $dt=16
M3758 1 3 1 1 pfet_01v8 L=5.8e-07 W=1.5e-06 $X=25910 $Y=68110 $dt=16
M3759 1 3 1 1 pfet_01v8 L=5.8e-07 W=1.5e-06 $X=25910 $Y=76390 $dt=16
M3760 1 3 1 1 pfet_01v8 L=5.8e-07 W=1.5e-06 $X=25910 $Y=84670 $dt=16
M3761 1 3 1 1 pfet_01v8 L=5.8e-07 W=1.5e-06 $X=25910 $Y=92950 $dt=16
M3762 1 3 1 1 pfet_01v8 L=5.8e-07 W=1.5e-06 $X=25910 $Y=101230 $dt=16
M3763 660 557 324 1 pfet_01v8 L=1.5e-07 W=1.5e-06 $X=25910 $Y=109510 $dt=16
M3764 661 559 324 1 pfet_01v8 L=1.5e-07 W=1.5e-06 $X=25910 $Y=117790 $dt=16
M3765 662 561 324 1 pfet_01v8 L=1.5e-07 W=1.5e-06 $X=25910 $Y=126070 $dt=16
M3766 663 563 324 1 pfet_01v8 L=1.5e-07 W=1.5e-06 $X=25910 $Y=134350 $dt=16
M3767 664 565 324 1 pfet_01v8 L=1.5e-07 W=1.5e-06 $X=25910 $Y=142630 $dt=16
M3768 665 567 324 1 pfet_01v8 L=1.5e-07 W=1.5e-06 $X=25910 $Y=150910 $dt=16
M3769 666 569 324 1 pfet_01v8 L=1.5e-07 W=1.5e-06 $X=25910 $Y=159190 $dt=16
M3770 309 514 653 1 pfet_01v8 L=1.5e-07 W=1.5e-06 $X=26340 $Y=10150 $dt=16
M3771 309 515 654 1 pfet_01v8 L=1.5e-07 W=1.5e-06 $X=26340 $Y=18430 $dt=16
M3772 309 516 655 1 pfet_01v8 L=1.5e-07 W=1.5e-06 $X=26340 $Y=26710 $dt=16
M3773 309 517 656 1 pfet_01v8 L=1.5e-07 W=1.5e-06 $X=26340 $Y=34990 $dt=16
M3774 309 518 657 1 pfet_01v8 L=1.5e-07 W=1.5e-06 $X=26340 $Y=43270 $dt=16
M3775 309 519 658 1 pfet_01v8 L=1.5e-07 W=1.5e-06 $X=26340 $Y=51550 $dt=16
M3776 309 520 659 1 pfet_01v8 L=1.5e-07 W=1.5e-06 $X=26340 $Y=59830 $dt=16
M3777 309 526 660 1 pfet_01v8 L=1.5e-07 W=1.5e-06 $X=26340 $Y=109510 $dt=16
M3778 309 527 661 1 pfet_01v8 L=1.5e-07 W=1.5e-06 $X=26340 $Y=117790 $dt=16
M3779 309 528 662 1 pfet_01v8 L=1.5e-07 W=1.5e-06 $X=26340 $Y=126070 $dt=16
M3780 309 529 663 1 pfet_01v8 L=1.5e-07 W=1.5e-06 $X=26340 $Y=134350 $dt=16
M3781 309 530 664 1 pfet_01v8 L=1.5e-07 W=1.5e-06 $X=26340 $Y=142630 $dt=16
M3782 309 531 665 1 pfet_01v8 L=1.5e-07 W=1.5e-06 $X=26340 $Y=150910 $dt=16
M3783 309 532 666 1 pfet_01v8 L=1.5e-07 W=1.5e-06 $X=26340 $Y=159190 $dt=16
M3784 1 3 1 1 pfet_01v8 L=5.8e-07 W=1.5e-06 $X=32030 $Y=68110 $dt=16
M3785 1 3 1 1 pfet_01v8 L=5.8e-07 W=1.5e-06 $X=32030 $Y=76390 $dt=16
M3786 1 3 1 1 pfet_01v8 L=5.8e-07 W=1.5e-06 $X=32030 $Y=84670 $dt=16
M3787 1 3 1 1 pfet_01v8 L=5.8e-07 W=1.5e-06 $X=32030 $Y=92950 $dt=16
M3788 1 3 1 1 pfet_01v8 L=5.8e-07 W=1.5e-06 $X=32030 $Y=101230 $dt=16
M3789 653 495 653 1 pfet_01v8 L=1.5e-07 W=1.5e-06 $X=32040 $Y=10150 $dt=16
M3790 654 496 654 1 pfet_01v8 L=1.5e-07 W=1.5e-06 $X=32040 $Y=18430 $dt=16
M3791 655 497 655 1 pfet_01v8 L=1.5e-07 W=1.5e-06 $X=32040 $Y=26710 $dt=16
M3792 656 498 656 1 pfet_01v8 L=1.5e-07 W=1.5e-06 $X=32040 $Y=34990 $dt=16
M3793 657 499 657 1 pfet_01v8 L=1.5e-07 W=1.5e-06 $X=32040 $Y=43270 $dt=16
M3794 658 500 658 1 pfet_01v8 L=1.5e-07 W=1.5e-06 $X=32040 $Y=51550 $dt=16
M3795 659 501 659 1 pfet_01v8 L=1.5e-07 W=1.5e-06 $X=32040 $Y=59830 $dt=16
M3796 660 507 660 1 pfet_01v8 L=1.5e-07 W=1.5e-06 $X=32040 $Y=109510 $dt=16
M3797 661 508 661 1 pfet_01v8 L=1.5e-07 W=1.5e-06 $X=32040 $Y=117790 $dt=16
M3798 662 509 662 1 pfet_01v8 L=1.5e-07 W=1.5e-06 $X=32040 $Y=126070 $dt=16
M3799 663 510 663 1 pfet_01v8 L=1.5e-07 W=1.5e-06 $X=32040 $Y=134350 $dt=16
M3800 664 511 664 1 pfet_01v8 L=1.5e-07 W=1.5e-06 $X=32040 $Y=142630 $dt=16
M3801 665 512 665 1 pfet_01v8 L=1.5e-07 W=1.5e-06 $X=32040 $Y=150910 $dt=16
M3802 666 513 666 1 pfet_01v8 L=1.5e-07 W=1.5e-06 $X=32040 $Y=159190 $dt=16
M3803 308 457 653 1 pfet_01v8 L=1.5e-07 W=1.5e-06 $X=32470 $Y=10150 $dt=16
M3804 308 459 654 1 pfet_01v8 L=1.5e-07 W=1.5e-06 $X=32470 $Y=18430 $dt=16
M3805 308 461 655 1 pfet_01v8 L=1.5e-07 W=1.5e-06 $X=32470 $Y=26710 $dt=16
M3806 308 463 656 1 pfet_01v8 L=1.5e-07 W=1.5e-06 $X=32470 $Y=34990 $dt=16
M3807 308 465 657 1 pfet_01v8 L=1.5e-07 W=1.5e-06 $X=32470 $Y=43270 $dt=16
M3808 308 467 658 1 pfet_01v8 L=1.5e-07 W=1.5e-06 $X=32470 $Y=51550 $dt=16
M3809 308 469 659 1 pfet_01v8 L=1.5e-07 W=1.5e-06 $X=32470 $Y=59830 $dt=16
M3810 308 481 660 1 pfet_01v8 L=1.5e-07 W=1.5e-06 $X=32470 $Y=109510 $dt=16
M3811 308 483 661 1 pfet_01v8 L=1.5e-07 W=1.5e-06 $X=32470 $Y=117790 $dt=16
M3812 308 485 662 1 pfet_01v8 L=1.5e-07 W=1.5e-06 $X=32470 $Y=126070 $dt=16
M3813 308 487 663 1 pfet_01v8 L=1.5e-07 W=1.5e-06 $X=32470 $Y=134350 $dt=16
M3814 308 489 664 1 pfet_01v8 L=1.5e-07 W=1.5e-06 $X=32470 $Y=142630 $dt=16
M3815 308 491 665 1 pfet_01v8 L=1.5e-07 W=1.5e-06 $X=32470 $Y=150910 $dt=16
M3816 308 493 666 1 pfet_01v8 L=1.5e-07 W=1.5e-06 $X=32470 $Y=159190 $dt=16
M3817 639 533 324 1 pfet_01v8 L=1.5e-07 W=1.5e-06 $X=34190 $Y=10150 $dt=16
M3818 640 535 324 1 pfet_01v8 L=1.5e-07 W=1.5e-06 $X=34190 $Y=18430 $dt=16
M3819 641 537 324 1 pfet_01v8 L=1.5e-07 W=1.5e-06 $X=34190 $Y=26710 $dt=16
M3820 642 539 324 1 pfet_01v8 L=1.5e-07 W=1.5e-06 $X=34190 $Y=34990 $dt=16
M3821 643 541 324 1 pfet_01v8 L=1.5e-07 W=1.5e-06 $X=34190 $Y=43270 $dt=16
M3822 644 543 324 1 pfet_01v8 L=1.5e-07 W=1.5e-06 $X=34190 $Y=51550 $dt=16
M3823 645 545 324 1 pfet_01v8 L=1.5e-07 W=1.5e-06 $X=34190 $Y=59830 $dt=16
M3824 1 3 1 1 pfet_01v8 L=5.8e-07 W=1.5e-06 $X=34190 $Y=68110 $dt=16
M3825 1 3 1 1 pfet_01v8 L=5.8e-07 W=1.5e-06 $X=34190 $Y=76390 $dt=16
M3826 1 3 1 1 pfet_01v8 L=5.8e-07 W=1.5e-06 $X=34190 $Y=84670 $dt=16
M3827 1 3 1 1 pfet_01v8 L=5.8e-07 W=1.5e-06 $X=34190 $Y=92950 $dt=16
M3828 1 3 1 1 pfet_01v8 L=5.8e-07 W=1.5e-06 $X=34190 $Y=101230 $dt=16
M3829 646 557 324 1 pfet_01v8 L=1.5e-07 W=1.5e-06 $X=34190 $Y=109510 $dt=16
M3830 647 559 324 1 pfet_01v8 L=1.5e-07 W=1.5e-06 $X=34190 $Y=117790 $dt=16
M3831 648 561 324 1 pfet_01v8 L=1.5e-07 W=1.5e-06 $X=34190 $Y=126070 $dt=16
M3832 649 563 324 1 pfet_01v8 L=1.5e-07 W=1.5e-06 $X=34190 $Y=134350 $dt=16
M3833 650 565 324 1 pfet_01v8 L=1.5e-07 W=1.5e-06 $X=34190 $Y=142630 $dt=16
M3834 651 567 324 1 pfet_01v8 L=1.5e-07 W=1.5e-06 $X=34190 $Y=150910 $dt=16
M3835 652 569 324 1 pfet_01v8 L=1.5e-07 W=1.5e-06 $X=34190 $Y=159190 $dt=16
M3836 309 514 639 1 pfet_01v8 L=1.5e-07 W=1.5e-06 $X=34620 $Y=10150 $dt=16
M3837 309 515 640 1 pfet_01v8 L=1.5e-07 W=1.5e-06 $X=34620 $Y=18430 $dt=16
M3838 309 516 641 1 pfet_01v8 L=1.5e-07 W=1.5e-06 $X=34620 $Y=26710 $dt=16
M3839 309 517 642 1 pfet_01v8 L=1.5e-07 W=1.5e-06 $X=34620 $Y=34990 $dt=16
M3840 309 518 643 1 pfet_01v8 L=1.5e-07 W=1.5e-06 $X=34620 $Y=43270 $dt=16
M3841 309 519 644 1 pfet_01v8 L=1.5e-07 W=1.5e-06 $X=34620 $Y=51550 $dt=16
M3842 309 520 645 1 pfet_01v8 L=1.5e-07 W=1.5e-06 $X=34620 $Y=59830 $dt=16
M3843 309 526 646 1 pfet_01v8 L=1.5e-07 W=1.5e-06 $X=34620 $Y=109510 $dt=16
M3844 309 527 647 1 pfet_01v8 L=1.5e-07 W=1.5e-06 $X=34620 $Y=117790 $dt=16
M3845 309 528 648 1 pfet_01v8 L=1.5e-07 W=1.5e-06 $X=34620 $Y=126070 $dt=16
M3846 309 529 649 1 pfet_01v8 L=1.5e-07 W=1.5e-06 $X=34620 $Y=134350 $dt=16
M3847 309 530 650 1 pfet_01v8 L=1.5e-07 W=1.5e-06 $X=34620 $Y=142630 $dt=16
M3848 309 531 651 1 pfet_01v8 L=1.5e-07 W=1.5e-06 $X=34620 $Y=150910 $dt=16
M3849 309 532 652 1 pfet_01v8 L=1.5e-07 W=1.5e-06 $X=34620 $Y=159190 $dt=16
M3850 1 3 1 1 pfet_01v8 L=5.8e-07 W=1.5e-06 $X=40310 $Y=68110 $dt=16
M3851 1 3 1 1 pfet_01v8 L=5.8e-07 W=1.5e-06 $X=40310 $Y=76390 $dt=16
M3852 1 3 1 1 pfet_01v8 L=5.8e-07 W=1.5e-06 $X=40310 $Y=84670 $dt=16
M3853 1 3 1 1 pfet_01v8 L=5.8e-07 W=1.5e-06 $X=40310 $Y=92950 $dt=16
M3854 1 3 1 1 pfet_01v8 L=5.8e-07 W=1.5e-06 $X=40310 $Y=101230 $dt=16
M3855 639 495 639 1 pfet_01v8 L=1.5e-07 W=1.5e-06 $X=40320 $Y=10150 $dt=16
M3856 640 496 640 1 pfet_01v8 L=1.5e-07 W=1.5e-06 $X=40320 $Y=18430 $dt=16
M3857 641 497 641 1 pfet_01v8 L=1.5e-07 W=1.5e-06 $X=40320 $Y=26710 $dt=16
M3858 642 498 642 1 pfet_01v8 L=1.5e-07 W=1.5e-06 $X=40320 $Y=34990 $dt=16
M3859 643 499 643 1 pfet_01v8 L=1.5e-07 W=1.5e-06 $X=40320 $Y=43270 $dt=16
M3860 644 500 644 1 pfet_01v8 L=1.5e-07 W=1.5e-06 $X=40320 $Y=51550 $dt=16
M3861 645 501 645 1 pfet_01v8 L=1.5e-07 W=1.5e-06 $X=40320 $Y=59830 $dt=16
M3862 646 507 646 1 pfet_01v8 L=1.5e-07 W=1.5e-06 $X=40320 $Y=109510 $dt=16
M3863 647 508 647 1 pfet_01v8 L=1.5e-07 W=1.5e-06 $X=40320 $Y=117790 $dt=16
M3864 648 509 648 1 pfet_01v8 L=1.5e-07 W=1.5e-06 $X=40320 $Y=126070 $dt=16
M3865 649 510 649 1 pfet_01v8 L=1.5e-07 W=1.5e-06 $X=40320 $Y=134350 $dt=16
M3866 650 511 650 1 pfet_01v8 L=1.5e-07 W=1.5e-06 $X=40320 $Y=142630 $dt=16
M3867 651 512 651 1 pfet_01v8 L=1.5e-07 W=1.5e-06 $X=40320 $Y=150910 $dt=16
M3868 652 513 652 1 pfet_01v8 L=1.5e-07 W=1.5e-06 $X=40320 $Y=159190 $dt=16
M3869 308 457 639 1 pfet_01v8 L=1.5e-07 W=1.5e-06 $X=40750 $Y=10150 $dt=16
M3870 308 459 640 1 pfet_01v8 L=1.5e-07 W=1.5e-06 $X=40750 $Y=18430 $dt=16
M3871 308 461 641 1 pfet_01v8 L=1.5e-07 W=1.5e-06 $X=40750 $Y=26710 $dt=16
M3872 308 463 642 1 pfet_01v8 L=1.5e-07 W=1.5e-06 $X=40750 $Y=34990 $dt=16
M3873 308 465 643 1 pfet_01v8 L=1.5e-07 W=1.5e-06 $X=40750 $Y=43270 $dt=16
M3874 308 467 644 1 pfet_01v8 L=1.5e-07 W=1.5e-06 $X=40750 $Y=51550 $dt=16
M3875 308 469 645 1 pfet_01v8 L=1.5e-07 W=1.5e-06 $X=40750 $Y=59830 $dt=16
M3876 308 481 646 1 pfet_01v8 L=1.5e-07 W=1.5e-06 $X=40750 $Y=109510 $dt=16
M3877 308 483 647 1 pfet_01v8 L=1.5e-07 W=1.5e-06 $X=40750 $Y=117790 $dt=16
M3878 308 485 648 1 pfet_01v8 L=1.5e-07 W=1.5e-06 $X=40750 $Y=126070 $dt=16
M3879 308 487 649 1 pfet_01v8 L=1.5e-07 W=1.5e-06 $X=40750 $Y=134350 $dt=16
M3880 308 489 650 1 pfet_01v8 L=1.5e-07 W=1.5e-06 $X=40750 $Y=142630 $dt=16
M3881 308 491 651 1 pfet_01v8 L=1.5e-07 W=1.5e-06 $X=40750 $Y=150910 $dt=16
M3882 308 493 652 1 pfet_01v8 L=1.5e-07 W=1.5e-06 $X=40750 $Y=159190 $dt=16
M3883 625 533 324 1 pfet_01v8 L=1.5e-07 W=1.5e-06 $X=42470 $Y=10150 $dt=16
M3884 626 535 324 1 pfet_01v8 L=1.5e-07 W=1.5e-06 $X=42470 $Y=18430 $dt=16
M3885 627 537 324 1 pfet_01v8 L=1.5e-07 W=1.5e-06 $X=42470 $Y=26710 $dt=16
M3886 628 539 324 1 pfet_01v8 L=1.5e-07 W=1.5e-06 $X=42470 $Y=34990 $dt=16
M3887 629 541 324 1 pfet_01v8 L=1.5e-07 W=1.5e-06 $X=42470 $Y=43270 $dt=16
M3888 630 543 324 1 pfet_01v8 L=1.5e-07 W=1.5e-06 $X=42470 $Y=51550 $dt=16
M3889 631 545 324 1 pfet_01v8 L=1.5e-07 W=1.5e-06 $X=42470 $Y=59830 $dt=16
M3890 1 3 1 1 pfet_01v8 L=5.8e-07 W=1.5e-06 $X=42470 $Y=68110 $dt=16
M3891 1 3 1 1 pfet_01v8 L=5.8e-07 W=1.5e-06 $X=42470 $Y=76390 $dt=16
M3892 1 3 1 1 pfet_01v8 L=5.8e-07 W=1.5e-06 $X=42470 $Y=84670 $dt=16
M3893 1 3 1 1 pfet_01v8 L=5.8e-07 W=1.5e-06 $X=42470 $Y=92950 $dt=16
M3894 1 3 1 1 pfet_01v8 L=5.8e-07 W=1.5e-06 $X=42470 $Y=101230 $dt=16
M3895 632 557 324 1 pfet_01v8 L=1.5e-07 W=1.5e-06 $X=42470 $Y=109510 $dt=16
M3896 633 559 324 1 pfet_01v8 L=1.5e-07 W=1.5e-06 $X=42470 $Y=117790 $dt=16
M3897 634 561 324 1 pfet_01v8 L=1.5e-07 W=1.5e-06 $X=42470 $Y=126070 $dt=16
M3898 635 563 324 1 pfet_01v8 L=1.5e-07 W=1.5e-06 $X=42470 $Y=134350 $dt=16
M3899 636 565 324 1 pfet_01v8 L=1.5e-07 W=1.5e-06 $X=42470 $Y=142630 $dt=16
M3900 637 567 324 1 pfet_01v8 L=1.5e-07 W=1.5e-06 $X=42470 $Y=150910 $dt=16
M3901 638 569 324 1 pfet_01v8 L=1.5e-07 W=1.5e-06 $X=42470 $Y=159190 $dt=16
M3902 309 514 625 1 pfet_01v8 L=1.5e-07 W=1.5e-06 $X=42900 $Y=10150 $dt=16
M3903 309 515 626 1 pfet_01v8 L=1.5e-07 W=1.5e-06 $X=42900 $Y=18430 $dt=16
M3904 309 516 627 1 pfet_01v8 L=1.5e-07 W=1.5e-06 $X=42900 $Y=26710 $dt=16
M3905 309 517 628 1 pfet_01v8 L=1.5e-07 W=1.5e-06 $X=42900 $Y=34990 $dt=16
M3906 309 518 629 1 pfet_01v8 L=1.5e-07 W=1.5e-06 $X=42900 $Y=43270 $dt=16
M3907 309 519 630 1 pfet_01v8 L=1.5e-07 W=1.5e-06 $X=42900 $Y=51550 $dt=16
M3908 309 520 631 1 pfet_01v8 L=1.5e-07 W=1.5e-06 $X=42900 $Y=59830 $dt=16
M3909 309 526 632 1 pfet_01v8 L=1.5e-07 W=1.5e-06 $X=42900 $Y=109510 $dt=16
M3910 309 527 633 1 pfet_01v8 L=1.5e-07 W=1.5e-06 $X=42900 $Y=117790 $dt=16
M3911 309 528 634 1 pfet_01v8 L=1.5e-07 W=1.5e-06 $X=42900 $Y=126070 $dt=16
M3912 309 529 635 1 pfet_01v8 L=1.5e-07 W=1.5e-06 $X=42900 $Y=134350 $dt=16
M3913 309 530 636 1 pfet_01v8 L=1.5e-07 W=1.5e-06 $X=42900 $Y=142630 $dt=16
M3914 309 531 637 1 pfet_01v8 L=1.5e-07 W=1.5e-06 $X=42900 $Y=150910 $dt=16
M3915 309 532 638 1 pfet_01v8 L=1.5e-07 W=1.5e-06 $X=42900 $Y=159190 $dt=16
M3916 1 3 1 1 pfet_01v8 L=5.8e-07 W=1.5e-06 $X=48590 $Y=68110 $dt=16
M3917 1 3 1 1 pfet_01v8 L=5.8e-07 W=1.5e-06 $X=48590 $Y=76390 $dt=16
M3918 1 3 1 1 pfet_01v8 L=5.8e-07 W=1.5e-06 $X=48590 $Y=84670 $dt=16
M3919 1 3 1 1 pfet_01v8 L=5.8e-07 W=1.5e-06 $X=48590 $Y=92950 $dt=16
M3920 1 3 1 1 pfet_01v8 L=5.8e-07 W=1.5e-06 $X=48590 $Y=101230 $dt=16
M3921 625 495 625 1 pfet_01v8 L=1.5e-07 W=1.5e-06 $X=48600 $Y=10150 $dt=16
M3922 626 496 626 1 pfet_01v8 L=1.5e-07 W=1.5e-06 $X=48600 $Y=18430 $dt=16
M3923 627 497 627 1 pfet_01v8 L=1.5e-07 W=1.5e-06 $X=48600 $Y=26710 $dt=16
M3924 628 498 628 1 pfet_01v8 L=1.5e-07 W=1.5e-06 $X=48600 $Y=34990 $dt=16
M3925 629 499 629 1 pfet_01v8 L=1.5e-07 W=1.5e-06 $X=48600 $Y=43270 $dt=16
M3926 630 500 630 1 pfet_01v8 L=1.5e-07 W=1.5e-06 $X=48600 $Y=51550 $dt=16
M3927 631 501 631 1 pfet_01v8 L=1.5e-07 W=1.5e-06 $X=48600 $Y=59830 $dt=16
M3928 632 507 632 1 pfet_01v8 L=1.5e-07 W=1.5e-06 $X=48600 $Y=109510 $dt=16
M3929 633 508 633 1 pfet_01v8 L=1.5e-07 W=1.5e-06 $X=48600 $Y=117790 $dt=16
M3930 634 509 634 1 pfet_01v8 L=1.5e-07 W=1.5e-06 $X=48600 $Y=126070 $dt=16
M3931 635 510 635 1 pfet_01v8 L=1.5e-07 W=1.5e-06 $X=48600 $Y=134350 $dt=16
M3932 636 511 636 1 pfet_01v8 L=1.5e-07 W=1.5e-06 $X=48600 $Y=142630 $dt=16
M3933 637 512 637 1 pfet_01v8 L=1.5e-07 W=1.5e-06 $X=48600 $Y=150910 $dt=16
M3934 638 513 638 1 pfet_01v8 L=1.5e-07 W=1.5e-06 $X=48600 $Y=159190 $dt=16
M3935 308 457 625 1 pfet_01v8 L=1.5e-07 W=1.5e-06 $X=49030 $Y=10150 $dt=16
M3936 308 459 626 1 pfet_01v8 L=1.5e-07 W=1.5e-06 $X=49030 $Y=18430 $dt=16
M3937 308 461 627 1 pfet_01v8 L=1.5e-07 W=1.5e-06 $X=49030 $Y=26710 $dt=16
M3938 308 463 628 1 pfet_01v8 L=1.5e-07 W=1.5e-06 $X=49030 $Y=34990 $dt=16
M3939 308 465 629 1 pfet_01v8 L=1.5e-07 W=1.5e-06 $X=49030 $Y=43270 $dt=16
M3940 308 467 630 1 pfet_01v8 L=1.5e-07 W=1.5e-06 $X=49030 $Y=51550 $dt=16
M3941 308 469 631 1 pfet_01v8 L=1.5e-07 W=1.5e-06 $X=49030 $Y=59830 $dt=16
M3942 308 481 632 1 pfet_01v8 L=1.5e-07 W=1.5e-06 $X=49030 $Y=109510 $dt=16
M3943 308 483 633 1 pfet_01v8 L=1.5e-07 W=1.5e-06 $X=49030 $Y=117790 $dt=16
M3944 308 485 634 1 pfet_01v8 L=1.5e-07 W=1.5e-06 $X=49030 $Y=126070 $dt=16
M3945 308 487 635 1 pfet_01v8 L=1.5e-07 W=1.5e-06 $X=49030 $Y=134350 $dt=16
M3946 308 489 636 1 pfet_01v8 L=1.5e-07 W=1.5e-06 $X=49030 $Y=142630 $dt=16
M3947 308 491 637 1 pfet_01v8 L=1.5e-07 W=1.5e-06 $X=49030 $Y=150910 $dt=16
M3948 308 493 638 1 pfet_01v8 L=1.5e-07 W=1.5e-06 $X=49030 $Y=159190 $dt=16
M3949 607 533 324 1 pfet_01v8 L=1.5e-07 W=1.5e-06 $X=50750 $Y=10150 $dt=16
M3950 608 535 324 1 pfet_01v8 L=1.5e-07 W=1.5e-06 $X=50750 $Y=18430 $dt=16
M3951 609 537 324 1 pfet_01v8 L=1.5e-07 W=1.5e-06 $X=50750 $Y=26710 $dt=16
M3952 610 539 324 1 pfet_01v8 L=1.5e-07 W=1.5e-06 $X=50750 $Y=34990 $dt=16
M3953 611 541 324 1 pfet_01v8 L=1.5e-07 W=1.5e-06 $X=50750 $Y=43270 $dt=16
M3954 612 543 324 1 pfet_01v8 L=1.5e-07 W=1.5e-06 $X=50750 $Y=51550 $dt=16
M3955 613 545 324 1 pfet_01v8 L=1.5e-07 W=1.5e-06 $X=50750 $Y=59830 $dt=16
M3956 614 547 324 1 pfet_01v8 L=1.5e-07 W=1.5e-06 $X=50750 $Y=68110 $dt=16
M3957 615 549 324 1 pfet_01v8 L=1.5e-07 W=1.5e-06 $X=50750 $Y=76390 $dt=16
M3958 1 3 1 1 pfet_01v8 L=5.8e-07 W=1.5e-06 $X=50750 $Y=84670 $dt=16
M3959 616 553 324 1 pfet_01v8 L=1.5e-07 W=1.5e-06 $X=50750 $Y=92950 $dt=16
M3960 617 555 324 1 pfet_01v8 L=1.5e-07 W=1.5e-06 $X=50750 $Y=101230 $dt=16
M3961 618 557 324 1 pfet_01v8 L=1.5e-07 W=1.5e-06 $X=50750 $Y=109510 $dt=16
M3962 619 559 324 1 pfet_01v8 L=1.5e-07 W=1.5e-06 $X=50750 $Y=117790 $dt=16
M3963 620 561 324 1 pfet_01v8 L=1.5e-07 W=1.5e-06 $X=50750 $Y=126070 $dt=16
M3964 621 563 324 1 pfet_01v8 L=1.5e-07 W=1.5e-06 $X=50750 $Y=134350 $dt=16
M3965 622 565 324 1 pfet_01v8 L=1.5e-07 W=1.5e-06 $X=50750 $Y=142630 $dt=16
M3966 623 567 324 1 pfet_01v8 L=1.5e-07 W=1.5e-06 $X=50750 $Y=150910 $dt=16
M3967 624 569 324 1 pfet_01v8 L=1.5e-07 W=1.5e-06 $X=50750 $Y=159190 $dt=16
M3968 309 514 607 1 pfet_01v8 L=1.5e-07 W=1.5e-06 $X=51180 $Y=10150 $dt=16
M3969 309 515 608 1 pfet_01v8 L=1.5e-07 W=1.5e-06 $X=51180 $Y=18430 $dt=16
M3970 309 516 609 1 pfet_01v8 L=1.5e-07 W=1.5e-06 $X=51180 $Y=26710 $dt=16
M3971 309 517 610 1 pfet_01v8 L=1.5e-07 W=1.5e-06 $X=51180 $Y=34990 $dt=16
M3972 309 518 611 1 pfet_01v8 L=1.5e-07 W=1.5e-06 $X=51180 $Y=43270 $dt=16
M3973 309 519 612 1 pfet_01v8 L=1.5e-07 W=1.5e-06 $X=51180 $Y=51550 $dt=16
M3974 309 520 613 1 pfet_01v8 L=1.5e-07 W=1.5e-06 $X=51180 $Y=59830 $dt=16
M3975 309 521 614 1 pfet_01v8 L=1.5e-07 W=1.5e-06 $X=51180 $Y=68110 $dt=16
M3976 309 522 615 1 pfet_01v8 L=1.5e-07 W=1.5e-06 $X=51180 $Y=76390 $dt=16
M3977 309 524 616 1 pfet_01v8 L=1.5e-07 W=1.5e-06 $X=51180 $Y=92950 $dt=16
M3978 309 525 617 1 pfet_01v8 L=1.5e-07 W=1.5e-06 $X=51180 $Y=101230 $dt=16
M3979 309 526 618 1 pfet_01v8 L=1.5e-07 W=1.5e-06 $X=51180 $Y=109510 $dt=16
M3980 309 527 619 1 pfet_01v8 L=1.5e-07 W=1.5e-06 $X=51180 $Y=117790 $dt=16
M3981 309 528 620 1 pfet_01v8 L=1.5e-07 W=1.5e-06 $X=51180 $Y=126070 $dt=16
M3982 309 529 621 1 pfet_01v8 L=1.5e-07 W=1.5e-06 $X=51180 $Y=134350 $dt=16
M3983 309 530 622 1 pfet_01v8 L=1.5e-07 W=1.5e-06 $X=51180 $Y=142630 $dt=16
M3984 309 531 623 1 pfet_01v8 L=1.5e-07 W=1.5e-06 $X=51180 $Y=150910 $dt=16
M3985 309 532 624 1 pfet_01v8 L=1.5e-07 W=1.5e-06 $X=51180 $Y=159190 $dt=16
M3986 1 3 1 1 pfet_01v8 L=5.8e-07 W=1.5e-06 $X=56870 $Y=84670 $dt=16
M3987 607 495 607 1 pfet_01v8 L=1.5e-07 W=1.5e-06 $X=56880 $Y=10150 $dt=16
M3988 608 496 608 1 pfet_01v8 L=1.5e-07 W=1.5e-06 $X=56880 $Y=18430 $dt=16
M3989 609 497 609 1 pfet_01v8 L=1.5e-07 W=1.5e-06 $X=56880 $Y=26710 $dt=16
M3990 610 498 610 1 pfet_01v8 L=1.5e-07 W=1.5e-06 $X=56880 $Y=34990 $dt=16
M3991 611 499 611 1 pfet_01v8 L=1.5e-07 W=1.5e-06 $X=56880 $Y=43270 $dt=16
M3992 612 500 612 1 pfet_01v8 L=1.5e-07 W=1.5e-06 $X=56880 $Y=51550 $dt=16
M3993 613 501 613 1 pfet_01v8 L=1.5e-07 W=1.5e-06 $X=56880 $Y=59830 $dt=16
M3994 614 502 614 1 pfet_01v8 L=1.5e-07 W=1.5e-06 $X=56880 $Y=68110 $dt=16
M3995 615 503 615 1 pfet_01v8 L=1.5e-07 W=1.5e-06 $X=56880 $Y=76390 $dt=16
M3996 616 505 616 1 pfet_01v8 L=1.5e-07 W=1.5e-06 $X=56880 $Y=92950 $dt=16
M3997 617 506 617 1 pfet_01v8 L=1.5e-07 W=1.5e-06 $X=56880 $Y=101230 $dt=16
M3998 618 507 618 1 pfet_01v8 L=1.5e-07 W=1.5e-06 $X=56880 $Y=109510 $dt=16
M3999 619 508 619 1 pfet_01v8 L=1.5e-07 W=1.5e-06 $X=56880 $Y=117790 $dt=16
M4000 620 509 620 1 pfet_01v8 L=1.5e-07 W=1.5e-06 $X=56880 $Y=126070 $dt=16
M4001 621 510 621 1 pfet_01v8 L=1.5e-07 W=1.5e-06 $X=56880 $Y=134350 $dt=16
M4002 622 511 622 1 pfet_01v8 L=1.5e-07 W=1.5e-06 $X=56880 $Y=142630 $dt=16
M4003 623 512 623 1 pfet_01v8 L=1.5e-07 W=1.5e-06 $X=56880 $Y=150910 $dt=16
M4004 624 513 624 1 pfet_01v8 L=1.5e-07 W=1.5e-06 $X=56880 $Y=159190 $dt=16
M4005 308 457 607 1 pfet_01v8 L=1.5e-07 W=1.5e-06 $X=57310 $Y=10150 $dt=16
M4006 308 459 608 1 pfet_01v8 L=1.5e-07 W=1.5e-06 $X=57310 $Y=18430 $dt=16
M4007 308 461 609 1 pfet_01v8 L=1.5e-07 W=1.5e-06 $X=57310 $Y=26710 $dt=16
M4008 308 463 610 1 pfet_01v8 L=1.5e-07 W=1.5e-06 $X=57310 $Y=34990 $dt=16
M4009 308 465 611 1 pfet_01v8 L=1.5e-07 W=1.5e-06 $X=57310 $Y=43270 $dt=16
M4010 308 467 612 1 pfet_01v8 L=1.5e-07 W=1.5e-06 $X=57310 $Y=51550 $dt=16
M4011 308 469 613 1 pfet_01v8 L=1.5e-07 W=1.5e-06 $X=57310 $Y=59830 $dt=16
M4012 308 471 614 1 pfet_01v8 L=1.5e-07 W=1.5e-06 $X=57310 $Y=68110 $dt=16
M4013 308 473 615 1 pfet_01v8 L=1.5e-07 W=1.5e-06 $X=57310 $Y=76390 $dt=16
M4014 308 477 616 1 pfet_01v8 L=1.5e-07 W=1.5e-06 $X=57310 $Y=92950 $dt=16
M4015 308 479 617 1 pfet_01v8 L=1.5e-07 W=1.5e-06 $X=57310 $Y=101230 $dt=16
M4016 308 481 618 1 pfet_01v8 L=1.5e-07 W=1.5e-06 $X=57310 $Y=109510 $dt=16
M4017 308 483 619 1 pfet_01v8 L=1.5e-07 W=1.5e-06 $X=57310 $Y=117790 $dt=16
M4018 308 485 620 1 pfet_01v8 L=1.5e-07 W=1.5e-06 $X=57310 $Y=126070 $dt=16
M4019 308 487 621 1 pfet_01v8 L=1.5e-07 W=1.5e-06 $X=57310 $Y=134350 $dt=16
M4020 308 489 622 1 pfet_01v8 L=1.5e-07 W=1.5e-06 $X=57310 $Y=142630 $dt=16
M4021 308 491 623 1 pfet_01v8 L=1.5e-07 W=1.5e-06 $X=57310 $Y=150910 $dt=16
M4022 308 493 624 1 pfet_01v8 L=1.5e-07 W=1.5e-06 $X=57310 $Y=159190 $dt=16
M4023 589 533 324 1 pfet_01v8 L=1.5e-07 W=1.5e-06 $X=59030 $Y=10150 $dt=16
M4024 590 535 324 1 pfet_01v8 L=1.5e-07 W=1.5e-06 $X=59030 $Y=18430 $dt=16
M4025 591 537 324 1 pfet_01v8 L=1.5e-07 W=1.5e-06 $X=59030 $Y=26710 $dt=16
M4026 592 539 324 1 pfet_01v8 L=1.5e-07 W=1.5e-06 $X=59030 $Y=34990 $dt=16
M4027 593 541 324 1 pfet_01v8 L=1.5e-07 W=1.5e-06 $X=59030 $Y=43270 $dt=16
M4028 594 543 324 1 pfet_01v8 L=1.5e-07 W=1.5e-06 $X=59030 $Y=51550 $dt=16
M4029 595 545 324 1 pfet_01v8 L=1.5e-07 W=1.5e-06 $X=59030 $Y=59830 $dt=16
M4030 596 547 324 1 pfet_01v8 L=1.5e-07 W=1.5e-06 $X=59030 $Y=68110 $dt=16
M4031 597 549 324 1 pfet_01v8 L=1.5e-07 W=1.5e-06 $X=59030 $Y=76390 $dt=16
M4032 1 3 1 1 pfet_01v8 L=5.8e-07 W=1.5e-06 $X=59030 $Y=84670 $dt=16
M4033 598 553 324 1 pfet_01v8 L=1.5e-07 W=1.5e-06 $X=59030 $Y=92950 $dt=16
M4034 599 555 324 1 pfet_01v8 L=1.5e-07 W=1.5e-06 $X=59030 $Y=101230 $dt=16
M4035 600 557 324 1 pfet_01v8 L=1.5e-07 W=1.5e-06 $X=59030 $Y=109510 $dt=16
M4036 601 559 324 1 pfet_01v8 L=1.5e-07 W=1.5e-06 $X=59030 $Y=117790 $dt=16
M4037 602 561 324 1 pfet_01v8 L=1.5e-07 W=1.5e-06 $X=59030 $Y=126070 $dt=16
M4038 603 563 324 1 pfet_01v8 L=1.5e-07 W=1.5e-06 $X=59030 $Y=134350 $dt=16
M4039 604 565 324 1 pfet_01v8 L=1.5e-07 W=1.5e-06 $X=59030 $Y=142630 $dt=16
M4040 605 567 324 1 pfet_01v8 L=1.5e-07 W=1.5e-06 $X=59030 $Y=150910 $dt=16
M4041 606 569 324 1 pfet_01v8 L=1.5e-07 W=1.5e-06 $X=59030 $Y=159190 $dt=16
M4042 309 514 589 1 pfet_01v8 L=1.5e-07 W=1.5e-06 $X=59460 $Y=10150 $dt=16
M4043 309 515 590 1 pfet_01v8 L=1.5e-07 W=1.5e-06 $X=59460 $Y=18430 $dt=16
M4044 309 516 591 1 pfet_01v8 L=1.5e-07 W=1.5e-06 $X=59460 $Y=26710 $dt=16
M4045 309 517 592 1 pfet_01v8 L=1.5e-07 W=1.5e-06 $X=59460 $Y=34990 $dt=16
M4046 309 518 593 1 pfet_01v8 L=1.5e-07 W=1.5e-06 $X=59460 $Y=43270 $dt=16
M4047 309 519 594 1 pfet_01v8 L=1.5e-07 W=1.5e-06 $X=59460 $Y=51550 $dt=16
M4048 309 520 595 1 pfet_01v8 L=1.5e-07 W=1.5e-06 $X=59460 $Y=59830 $dt=16
M4049 309 521 596 1 pfet_01v8 L=1.5e-07 W=1.5e-06 $X=59460 $Y=68110 $dt=16
M4050 309 522 597 1 pfet_01v8 L=1.5e-07 W=1.5e-06 $X=59460 $Y=76390 $dt=16
M4051 309 524 598 1 pfet_01v8 L=1.5e-07 W=1.5e-06 $X=59460 $Y=92950 $dt=16
M4052 309 525 599 1 pfet_01v8 L=1.5e-07 W=1.5e-06 $X=59460 $Y=101230 $dt=16
M4053 309 526 600 1 pfet_01v8 L=1.5e-07 W=1.5e-06 $X=59460 $Y=109510 $dt=16
M4054 309 527 601 1 pfet_01v8 L=1.5e-07 W=1.5e-06 $X=59460 $Y=117790 $dt=16
M4055 309 528 602 1 pfet_01v8 L=1.5e-07 W=1.5e-06 $X=59460 $Y=126070 $dt=16
M4056 309 529 603 1 pfet_01v8 L=1.5e-07 W=1.5e-06 $X=59460 $Y=134350 $dt=16
M4057 309 530 604 1 pfet_01v8 L=1.5e-07 W=1.5e-06 $X=59460 $Y=142630 $dt=16
M4058 309 531 605 1 pfet_01v8 L=1.5e-07 W=1.5e-06 $X=59460 $Y=150910 $dt=16
M4059 309 532 606 1 pfet_01v8 L=1.5e-07 W=1.5e-06 $X=59460 $Y=159190 $dt=16
M4060 1 3 1 1 pfet_01v8 L=5.8e-07 W=1.5e-06 $X=65150 $Y=84670 $dt=16
M4061 589 495 589 1 pfet_01v8 L=1.5e-07 W=1.5e-06 $X=65160 $Y=10150 $dt=16
M4062 590 496 590 1 pfet_01v8 L=1.5e-07 W=1.5e-06 $X=65160 $Y=18430 $dt=16
M4063 591 497 591 1 pfet_01v8 L=1.5e-07 W=1.5e-06 $X=65160 $Y=26710 $dt=16
M4064 592 498 592 1 pfet_01v8 L=1.5e-07 W=1.5e-06 $X=65160 $Y=34990 $dt=16
M4065 593 499 593 1 pfet_01v8 L=1.5e-07 W=1.5e-06 $X=65160 $Y=43270 $dt=16
M4066 594 500 594 1 pfet_01v8 L=1.5e-07 W=1.5e-06 $X=65160 $Y=51550 $dt=16
M4067 595 501 595 1 pfet_01v8 L=1.5e-07 W=1.5e-06 $X=65160 $Y=59830 $dt=16
M4068 596 502 596 1 pfet_01v8 L=1.5e-07 W=1.5e-06 $X=65160 $Y=68110 $dt=16
M4069 597 503 597 1 pfet_01v8 L=1.5e-07 W=1.5e-06 $X=65160 $Y=76390 $dt=16
M4070 598 505 598 1 pfet_01v8 L=1.5e-07 W=1.5e-06 $X=65160 $Y=92950 $dt=16
M4071 599 506 599 1 pfet_01v8 L=1.5e-07 W=1.5e-06 $X=65160 $Y=101230 $dt=16
M4072 600 507 600 1 pfet_01v8 L=1.5e-07 W=1.5e-06 $X=65160 $Y=109510 $dt=16
M4073 601 508 601 1 pfet_01v8 L=1.5e-07 W=1.5e-06 $X=65160 $Y=117790 $dt=16
M4074 602 509 602 1 pfet_01v8 L=1.5e-07 W=1.5e-06 $X=65160 $Y=126070 $dt=16
M4075 603 510 603 1 pfet_01v8 L=1.5e-07 W=1.5e-06 $X=65160 $Y=134350 $dt=16
M4076 604 511 604 1 pfet_01v8 L=1.5e-07 W=1.5e-06 $X=65160 $Y=142630 $dt=16
M4077 605 512 605 1 pfet_01v8 L=1.5e-07 W=1.5e-06 $X=65160 $Y=150910 $dt=16
M4078 606 513 606 1 pfet_01v8 L=1.5e-07 W=1.5e-06 $X=65160 $Y=159190 $dt=16
M4079 308 457 589 1 pfet_01v8 L=1.5e-07 W=1.5e-06 $X=65590 $Y=10150 $dt=16
M4080 308 459 590 1 pfet_01v8 L=1.5e-07 W=1.5e-06 $X=65590 $Y=18430 $dt=16
M4081 308 461 591 1 pfet_01v8 L=1.5e-07 W=1.5e-06 $X=65590 $Y=26710 $dt=16
M4082 308 463 592 1 pfet_01v8 L=1.5e-07 W=1.5e-06 $X=65590 $Y=34990 $dt=16
M4083 308 465 593 1 pfet_01v8 L=1.5e-07 W=1.5e-06 $X=65590 $Y=43270 $dt=16
M4084 308 467 594 1 pfet_01v8 L=1.5e-07 W=1.5e-06 $X=65590 $Y=51550 $dt=16
M4085 308 469 595 1 pfet_01v8 L=1.5e-07 W=1.5e-06 $X=65590 $Y=59830 $dt=16
M4086 308 471 596 1 pfet_01v8 L=1.5e-07 W=1.5e-06 $X=65590 $Y=68110 $dt=16
M4087 308 473 597 1 pfet_01v8 L=1.5e-07 W=1.5e-06 $X=65590 $Y=76390 $dt=16
M4088 308 477 598 1 pfet_01v8 L=1.5e-07 W=1.5e-06 $X=65590 $Y=92950 $dt=16
M4089 308 479 599 1 pfet_01v8 L=1.5e-07 W=1.5e-06 $X=65590 $Y=101230 $dt=16
M4090 308 481 600 1 pfet_01v8 L=1.5e-07 W=1.5e-06 $X=65590 $Y=109510 $dt=16
M4091 308 483 601 1 pfet_01v8 L=1.5e-07 W=1.5e-06 $X=65590 $Y=117790 $dt=16
M4092 308 485 602 1 pfet_01v8 L=1.5e-07 W=1.5e-06 $X=65590 $Y=126070 $dt=16
M4093 308 487 603 1 pfet_01v8 L=1.5e-07 W=1.5e-06 $X=65590 $Y=134350 $dt=16
M4094 308 489 604 1 pfet_01v8 L=1.5e-07 W=1.5e-06 $X=65590 $Y=142630 $dt=16
M4095 308 491 605 1 pfet_01v8 L=1.5e-07 W=1.5e-06 $X=65590 $Y=150910 $dt=16
M4096 308 493 606 1 pfet_01v8 L=1.5e-07 W=1.5e-06 $X=65590 $Y=159190 $dt=16
M4097 571 533 324 1 pfet_01v8 L=1.5e-07 W=1.5e-06 $X=67310 $Y=10150 $dt=16
M4098 572 535 324 1 pfet_01v8 L=1.5e-07 W=1.5e-06 $X=67310 $Y=18430 $dt=16
M4099 573 537 324 1 pfet_01v8 L=1.5e-07 W=1.5e-06 $X=67310 $Y=26710 $dt=16
M4100 574 539 324 1 pfet_01v8 L=1.5e-07 W=1.5e-06 $X=67310 $Y=34990 $dt=16
M4101 575 541 324 1 pfet_01v8 L=1.5e-07 W=1.5e-06 $X=67310 $Y=43270 $dt=16
M4102 576 543 324 1 pfet_01v8 L=1.5e-07 W=1.5e-06 $X=67310 $Y=51550 $dt=16
M4103 577 545 324 1 pfet_01v8 L=1.5e-07 W=1.5e-06 $X=67310 $Y=59830 $dt=16
M4104 578 547 324 1 pfet_01v8 L=1.5e-07 W=1.5e-06 $X=67310 $Y=68110 $dt=16
M4105 579 549 324 1 pfet_01v8 L=1.5e-07 W=1.5e-06 $X=67310 $Y=76390 $dt=16
M4106 1 3 1 1 pfet_01v8 L=5.8e-07 W=1.5e-06 $X=67310 $Y=84670 $dt=16
M4107 580 553 324 1 pfet_01v8 L=1.5e-07 W=1.5e-06 $X=67310 $Y=92950 $dt=16
M4108 581 555 324 1 pfet_01v8 L=1.5e-07 W=1.5e-06 $X=67310 $Y=101230 $dt=16
M4109 582 557 324 1 pfet_01v8 L=1.5e-07 W=1.5e-06 $X=67310 $Y=109510 $dt=16
M4110 583 559 324 1 pfet_01v8 L=1.5e-07 W=1.5e-06 $X=67310 $Y=117790 $dt=16
M4111 584 561 324 1 pfet_01v8 L=1.5e-07 W=1.5e-06 $X=67310 $Y=126070 $dt=16
M4112 585 563 324 1 pfet_01v8 L=1.5e-07 W=1.5e-06 $X=67310 $Y=134350 $dt=16
M4113 586 565 324 1 pfet_01v8 L=1.5e-07 W=1.5e-06 $X=67310 $Y=142630 $dt=16
M4114 587 567 324 1 pfet_01v8 L=1.5e-07 W=1.5e-06 $X=67310 $Y=150910 $dt=16
M4115 588 569 324 1 pfet_01v8 L=1.5e-07 W=1.5e-06 $X=67310 $Y=159190 $dt=16
M4116 309 514 571 1 pfet_01v8 L=1.5e-07 W=1.5e-06 $X=67740 $Y=10150 $dt=16
M4117 309 515 572 1 pfet_01v8 L=1.5e-07 W=1.5e-06 $X=67740 $Y=18430 $dt=16
M4118 309 516 573 1 pfet_01v8 L=1.5e-07 W=1.5e-06 $X=67740 $Y=26710 $dt=16
M4119 309 517 574 1 pfet_01v8 L=1.5e-07 W=1.5e-06 $X=67740 $Y=34990 $dt=16
M4120 309 518 575 1 pfet_01v8 L=1.5e-07 W=1.5e-06 $X=67740 $Y=43270 $dt=16
M4121 309 519 576 1 pfet_01v8 L=1.5e-07 W=1.5e-06 $X=67740 $Y=51550 $dt=16
M4122 309 520 577 1 pfet_01v8 L=1.5e-07 W=1.5e-06 $X=67740 $Y=59830 $dt=16
M4123 309 521 578 1 pfet_01v8 L=1.5e-07 W=1.5e-06 $X=67740 $Y=68110 $dt=16
M4124 309 522 579 1 pfet_01v8 L=1.5e-07 W=1.5e-06 $X=67740 $Y=76390 $dt=16
M4125 309 524 580 1 pfet_01v8 L=1.5e-07 W=1.5e-06 $X=67740 $Y=92950 $dt=16
M4126 309 525 581 1 pfet_01v8 L=1.5e-07 W=1.5e-06 $X=67740 $Y=101230 $dt=16
M4127 309 526 582 1 pfet_01v8 L=1.5e-07 W=1.5e-06 $X=67740 $Y=109510 $dt=16
M4128 309 527 583 1 pfet_01v8 L=1.5e-07 W=1.5e-06 $X=67740 $Y=117790 $dt=16
M4129 309 528 584 1 pfet_01v8 L=1.5e-07 W=1.5e-06 $X=67740 $Y=126070 $dt=16
M4130 309 529 585 1 pfet_01v8 L=1.5e-07 W=1.5e-06 $X=67740 $Y=134350 $dt=16
M4131 309 530 586 1 pfet_01v8 L=1.5e-07 W=1.5e-06 $X=67740 $Y=142630 $dt=16
M4132 309 531 587 1 pfet_01v8 L=1.5e-07 W=1.5e-06 $X=67740 $Y=150910 $dt=16
M4133 309 532 588 1 pfet_01v8 L=1.5e-07 W=1.5e-06 $X=67740 $Y=159190 $dt=16
M4134 1 3 1 1 pfet_01v8 L=5.8e-07 W=1.5e-06 $X=73430 $Y=84670 $dt=16
M4135 571 495 571 1 pfet_01v8 L=1.5e-07 W=1.5e-06 $X=73440 $Y=10150 $dt=16
M4136 572 496 572 1 pfet_01v8 L=1.5e-07 W=1.5e-06 $X=73440 $Y=18430 $dt=16
M4137 573 497 573 1 pfet_01v8 L=1.5e-07 W=1.5e-06 $X=73440 $Y=26710 $dt=16
M4138 574 498 574 1 pfet_01v8 L=1.5e-07 W=1.5e-06 $X=73440 $Y=34990 $dt=16
M4139 575 499 575 1 pfet_01v8 L=1.5e-07 W=1.5e-06 $X=73440 $Y=43270 $dt=16
M4140 576 500 576 1 pfet_01v8 L=1.5e-07 W=1.5e-06 $X=73440 $Y=51550 $dt=16
M4141 577 501 577 1 pfet_01v8 L=1.5e-07 W=1.5e-06 $X=73440 $Y=59830 $dt=16
M4142 578 502 578 1 pfet_01v8 L=1.5e-07 W=1.5e-06 $X=73440 $Y=68110 $dt=16
M4143 579 503 579 1 pfet_01v8 L=1.5e-07 W=1.5e-06 $X=73440 $Y=76390 $dt=16
M4144 580 505 580 1 pfet_01v8 L=1.5e-07 W=1.5e-06 $X=73440 $Y=92950 $dt=16
M4145 581 506 581 1 pfet_01v8 L=1.5e-07 W=1.5e-06 $X=73440 $Y=101230 $dt=16
M4146 582 507 582 1 pfet_01v8 L=1.5e-07 W=1.5e-06 $X=73440 $Y=109510 $dt=16
M4147 583 508 583 1 pfet_01v8 L=1.5e-07 W=1.5e-06 $X=73440 $Y=117790 $dt=16
M4148 584 509 584 1 pfet_01v8 L=1.5e-07 W=1.5e-06 $X=73440 $Y=126070 $dt=16
M4149 585 510 585 1 pfet_01v8 L=1.5e-07 W=1.5e-06 $X=73440 $Y=134350 $dt=16
M4150 586 511 586 1 pfet_01v8 L=1.5e-07 W=1.5e-06 $X=73440 $Y=142630 $dt=16
M4151 587 512 587 1 pfet_01v8 L=1.5e-07 W=1.5e-06 $X=73440 $Y=150910 $dt=16
M4152 588 513 588 1 pfet_01v8 L=1.5e-07 W=1.5e-06 $X=73440 $Y=159190 $dt=16
M4153 308 457 571 1 pfet_01v8 L=1.5e-07 W=1.5e-06 $X=73870 $Y=10150 $dt=16
M4154 308 459 572 1 pfet_01v8 L=1.5e-07 W=1.5e-06 $X=73870 $Y=18430 $dt=16
M4155 308 461 573 1 pfet_01v8 L=1.5e-07 W=1.5e-06 $X=73870 $Y=26710 $dt=16
M4156 308 463 574 1 pfet_01v8 L=1.5e-07 W=1.5e-06 $X=73870 $Y=34990 $dt=16
M4157 308 465 575 1 pfet_01v8 L=1.5e-07 W=1.5e-06 $X=73870 $Y=43270 $dt=16
M4158 308 467 576 1 pfet_01v8 L=1.5e-07 W=1.5e-06 $X=73870 $Y=51550 $dt=16
M4159 308 469 577 1 pfet_01v8 L=1.5e-07 W=1.5e-06 $X=73870 $Y=59830 $dt=16
M4160 308 471 578 1 pfet_01v8 L=1.5e-07 W=1.5e-06 $X=73870 $Y=68110 $dt=16
M4161 308 473 579 1 pfet_01v8 L=1.5e-07 W=1.5e-06 $X=73870 $Y=76390 $dt=16
M4162 308 477 580 1 pfet_01v8 L=1.5e-07 W=1.5e-06 $X=73870 $Y=92950 $dt=16
M4163 308 479 581 1 pfet_01v8 L=1.5e-07 W=1.5e-06 $X=73870 $Y=101230 $dt=16
M4164 308 481 582 1 pfet_01v8 L=1.5e-07 W=1.5e-06 $X=73870 $Y=109510 $dt=16
M4165 308 483 583 1 pfet_01v8 L=1.5e-07 W=1.5e-06 $X=73870 $Y=117790 $dt=16
M4166 308 485 584 1 pfet_01v8 L=1.5e-07 W=1.5e-06 $X=73870 $Y=126070 $dt=16
M4167 308 487 585 1 pfet_01v8 L=1.5e-07 W=1.5e-06 $X=73870 $Y=134350 $dt=16
M4168 308 489 586 1 pfet_01v8 L=1.5e-07 W=1.5e-06 $X=73870 $Y=142630 $dt=16
M4169 308 491 587 1 pfet_01v8 L=1.5e-07 W=1.5e-06 $X=73870 $Y=150910 $dt=16
M4170 308 493 588 1 pfet_01v8 L=1.5e-07 W=1.5e-06 $X=73870 $Y=159190 $dt=16
M4171 438 533 324 1 pfet_01v8 L=1.5e-07 W=1.5e-06 $X=75590 $Y=10150 $dt=16
M4172 439 535 324 1 pfet_01v8 L=1.5e-07 W=1.5e-06 $X=75590 $Y=18430 $dt=16
M4173 440 537 324 1 pfet_01v8 L=1.5e-07 W=1.5e-06 $X=75590 $Y=26710 $dt=16
M4174 441 539 324 1 pfet_01v8 L=1.5e-07 W=1.5e-06 $X=75590 $Y=34990 $dt=16
M4175 442 541 324 1 pfet_01v8 L=1.5e-07 W=1.5e-06 $X=75590 $Y=43270 $dt=16
M4176 443 543 324 1 pfet_01v8 L=1.5e-07 W=1.5e-06 $X=75590 $Y=51550 $dt=16
M4177 444 545 324 1 pfet_01v8 L=1.5e-07 W=1.5e-06 $X=75590 $Y=59830 $dt=16
M4178 445 547 324 1 pfet_01v8 L=1.5e-07 W=1.5e-06 $X=75590 $Y=68110 $dt=16
M4179 446 549 324 1 pfet_01v8 L=1.5e-07 W=1.5e-06 $X=75590 $Y=76390 $dt=16
M4180 447 551 324 1 pfet_01v8 L=1.5e-07 W=1.5e-06 $X=75590 $Y=84670 $dt=16
M4181 448 553 324 1 pfet_01v8 L=1.5e-07 W=1.5e-06 $X=75590 $Y=92950 $dt=16
M4182 449 555 324 1 pfet_01v8 L=1.5e-07 W=1.5e-06 $X=75590 $Y=101230 $dt=16
M4183 450 557 324 1 pfet_01v8 L=1.5e-07 W=1.5e-06 $X=75590 $Y=109510 $dt=16
M4184 451 559 324 1 pfet_01v8 L=1.5e-07 W=1.5e-06 $X=75590 $Y=117790 $dt=16
M4185 452 561 324 1 pfet_01v8 L=1.5e-07 W=1.5e-06 $X=75590 $Y=126070 $dt=16
M4186 453 563 324 1 pfet_01v8 L=1.5e-07 W=1.5e-06 $X=75590 $Y=134350 $dt=16
M4187 454 565 324 1 pfet_01v8 L=1.5e-07 W=1.5e-06 $X=75590 $Y=142630 $dt=16
M4188 455 567 324 1 pfet_01v8 L=1.5e-07 W=1.5e-06 $X=75590 $Y=150910 $dt=16
M4189 456 569 324 1 pfet_01v8 L=1.5e-07 W=1.5e-06 $X=75590 $Y=159190 $dt=16
M4190 309 514 438 1 pfet_01v8 L=1.5e-07 W=1.5e-06 $X=76020 $Y=10150 $dt=16
M4191 309 515 439 1 pfet_01v8 L=1.5e-07 W=1.5e-06 $X=76020 $Y=18430 $dt=16
M4192 309 516 440 1 pfet_01v8 L=1.5e-07 W=1.5e-06 $X=76020 $Y=26710 $dt=16
M4193 309 517 441 1 pfet_01v8 L=1.5e-07 W=1.5e-06 $X=76020 $Y=34990 $dt=16
M4194 309 518 442 1 pfet_01v8 L=1.5e-07 W=1.5e-06 $X=76020 $Y=43270 $dt=16
M4195 309 519 443 1 pfet_01v8 L=1.5e-07 W=1.5e-06 $X=76020 $Y=51550 $dt=16
M4196 309 520 444 1 pfet_01v8 L=1.5e-07 W=1.5e-06 $X=76020 $Y=59830 $dt=16
M4197 309 521 445 1 pfet_01v8 L=1.5e-07 W=1.5e-06 $X=76020 $Y=68110 $dt=16
M4198 309 522 446 1 pfet_01v8 L=1.5e-07 W=1.5e-06 $X=76020 $Y=76390 $dt=16
M4199 309 523 447 1 pfet_01v8 L=1.5e-07 W=1.5e-06 $X=76020 $Y=84670 $dt=16
M4200 309 524 448 1 pfet_01v8 L=1.5e-07 W=1.5e-06 $X=76020 $Y=92950 $dt=16
M4201 309 525 449 1 pfet_01v8 L=1.5e-07 W=1.5e-06 $X=76020 $Y=101230 $dt=16
M4202 309 526 450 1 pfet_01v8 L=1.5e-07 W=1.5e-06 $X=76020 $Y=109510 $dt=16
M4203 309 527 451 1 pfet_01v8 L=1.5e-07 W=1.5e-06 $X=76020 $Y=117790 $dt=16
M4204 309 528 452 1 pfet_01v8 L=1.5e-07 W=1.5e-06 $X=76020 $Y=126070 $dt=16
M4205 309 529 453 1 pfet_01v8 L=1.5e-07 W=1.5e-06 $X=76020 $Y=134350 $dt=16
M4206 309 530 454 1 pfet_01v8 L=1.5e-07 W=1.5e-06 $X=76020 $Y=142630 $dt=16
M4207 309 531 455 1 pfet_01v8 L=1.5e-07 W=1.5e-06 $X=76020 $Y=150910 $dt=16
M4208 309 532 456 1 pfet_01v8 L=1.5e-07 W=1.5e-06 $X=76020 $Y=159190 $dt=16
M4209 438 495 438 1 pfet_01v8 L=1.5e-07 W=1.5e-06 $X=81720 $Y=10150 $dt=16
M4210 439 496 439 1 pfet_01v8 L=1.5e-07 W=1.5e-06 $X=81720 $Y=18430 $dt=16
M4211 440 497 440 1 pfet_01v8 L=1.5e-07 W=1.5e-06 $X=81720 $Y=26710 $dt=16
M4212 441 498 441 1 pfet_01v8 L=1.5e-07 W=1.5e-06 $X=81720 $Y=34990 $dt=16
M4213 442 499 442 1 pfet_01v8 L=1.5e-07 W=1.5e-06 $X=81720 $Y=43270 $dt=16
M4214 443 500 443 1 pfet_01v8 L=1.5e-07 W=1.5e-06 $X=81720 $Y=51550 $dt=16
M4215 444 501 444 1 pfet_01v8 L=1.5e-07 W=1.5e-06 $X=81720 $Y=59830 $dt=16
M4216 445 502 445 1 pfet_01v8 L=1.5e-07 W=1.5e-06 $X=81720 $Y=68110 $dt=16
M4217 446 503 446 1 pfet_01v8 L=1.5e-07 W=1.5e-06 $X=81720 $Y=76390 $dt=16
M4218 447 504 447 1 pfet_01v8 L=1.5e-07 W=1.5e-06 $X=81720 $Y=84670 $dt=16
M4219 448 505 448 1 pfet_01v8 L=1.5e-07 W=1.5e-06 $X=81720 $Y=92950 $dt=16
M4220 449 506 449 1 pfet_01v8 L=1.5e-07 W=1.5e-06 $X=81720 $Y=101230 $dt=16
M4221 450 507 450 1 pfet_01v8 L=1.5e-07 W=1.5e-06 $X=81720 $Y=109510 $dt=16
M4222 451 508 451 1 pfet_01v8 L=1.5e-07 W=1.5e-06 $X=81720 $Y=117790 $dt=16
M4223 452 509 452 1 pfet_01v8 L=1.5e-07 W=1.5e-06 $X=81720 $Y=126070 $dt=16
M4224 453 510 453 1 pfet_01v8 L=1.5e-07 W=1.5e-06 $X=81720 $Y=134350 $dt=16
M4225 454 511 454 1 pfet_01v8 L=1.5e-07 W=1.5e-06 $X=81720 $Y=142630 $dt=16
M4226 455 512 455 1 pfet_01v8 L=1.5e-07 W=1.5e-06 $X=81720 $Y=150910 $dt=16
M4227 456 513 456 1 pfet_01v8 L=1.5e-07 W=1.5e-06 $X=81720 $Y=159190 $dt=16
M4228 308 457 438 1 pfet_01v8 L=1.5e-07 W=1.5e-06 $X=82150 $Y=10150 $dt=16
M4229 308 459 439 1 pfet_01v8 L=1.5e-07 W=1.5e-06 $X=82150 $Y=18430 $dt=16
M4230 308 461 440 1 pfet_01v8 L=1.5e-07 W=1.5e-06 $X=82150 $Y=26710 $dt=16
M4231 308 463 441 1 pfet_01v8 L=1.5e-07 W=1.5e-06 $X=82150 $Y=34990 $dt=16
M4232 308 465 442 1 pfet_01v8 L=1.5e-07 W=1.5e-06 $X=82150 $Y=43270 $dt=16
M4233 308 467 443 1 pfet_01v8 L=1.5e-07 W=1.5e-06 $X=82150 $Y=51550 $dt=16
M4234 308 469 444 1 pfet_01v8 L=1.5e-07 W=1.5e-06 $X=82150 $Y=59830 $dt=16
M4235 308 471 445 1 pfet_01v8 L=1.5e-07 W=1.5e-06 $X=82150 $Y=68110 $dt=16
M4236 308 473 446 1 pfet_01v8 L=1.5e-07 W=1.5e-06 $X=82150 $Y=76390 $dt=16
M4237 308 475 447 1 pfet_01v8 L=1.5e-07 W=1.5e-06 $X=82150 $Y=84670 $dt=16
M4238 308 477 448 1 pfet_01v8 L=1.5e-07 W=1.5e-06 $X=82150 $Y=92950 $dt=16
M4239 308 479 449 1 pfet_01v8 L=1.5e-07 W=1.5e-06 $X=82150 $Y=101230 $dt=16
M4240 308 481 450 1 pfet_01v8 L=1.5e-07 W=1.5e-06 $X=82150 $Y=109510 $dt=16
M4241 308 483 451 1 pfet_01v8 L=1.5e-07 W=1.5e-06 $X=82150 $Y=117790 $dt=16
M4242 308 485 452 1 pfet_01v8 L=1.5e-07 W=1.5e-06 $X=82150 $Y=126070 $dt=16
M4243 308 487 453 1 pfet_01v8 L=1.5e-07 W=1.5e-06 $X=82150 $Y=134350 $dt=16
M4244 308 489 454 1 pfet_01v8 L=1.5e-07 W=1.5e-06 $X=82150 $Y=142630 $dt=16
M4245 308 491 455 1 pfet_01v8 L=1.5e-07 W=1.5e-06 $X=82150 $Y=150910 $dt=16
M4246 308 493 456 1 pfet_01v8 L=1.5e-07 W=1.5e-06 $X=82150 $Y=159190 $dt=16
M4247 419 213 324 1 pfet_01v8 L=1.5e-07 W=1.5e-06 $X=83870 $Y=10150 $dt=16
M4248 420 214 324 1 pfet_01v8 L=1.5e-07 W=1.5e-06 $X=83870 $Y=18430 $dt=16
M4249 421 215 324 1 pfet_01v8 L=1.5e-07 W=1.5e-06 $X=83870 $Y=26710 $dt=16
M4250 422 216 324 1 pfet_01v8 L=1.5e-07 W=1.5e-06 $X=83870 $Y=34990 $dt=16
M4251 423 217 324 1 pfet_01v8 L=1.5e-07 W=1.5e-06 $X=83870 $Y=43270 $dt=16
M4252 424 218 324 1 pfet_01v8 L=1.5e-07 W=1.5e-06 $X=83870 $Y=51550 $dt=16
M4253 425 219 324 1 pfet_01v8 L=1.5e-07 W=1.5e-06 $X=83870 $Y=59830 $dt=16
M4254 426 220 324 1 pfet_01v8 L=1.5e-07 W=1.5e-06 $X=83870 $Y=68110 $dt=16
M4255 427 221 324 1 pfet_01v8 L=1.5e-07 W=1.5e-06 $X=83870 $Y=76390 $dt=16
M4256 428 222 324 1 pfet_01v8 L=1.5e-07 W=1.5e-06 $X=83870 $Y=84670 $dt=16
M4257 429 223 324 1 pfet_01v8 L=1.5e-07 W=1.5e-06 $X=83870 $Y=92950 $dt=16
M4258 430 224 324 1 pfet_01v8 L=1.5e-07 W=1.5e-06 $X=83870 $Y=101230 $dt=16
M4259 431 225 324 1 pfet_01v8 L=1.5e-07 W=1.5e-06 $X=83870 $Y=109510 $dt=16
M4260 432 226 324 1 pfet_01v8 L=1.5e-07 W=1.5e-06 $X=83870 $Y=117790 $dt=16
M4261 433 227 324 1 pfet_01v8 L=1.5e-07 W=1.5e-06 $X=83870 $Y=126070 $dt=16
M4262 434 228 324 1 pfet_01v8 L=1.5e-07 W=1.5e-06 $X=83870 $Y=134350 $dt=16
M4263 435 229 324 1 pfet_01v8 L=1.5e-07 W=1.5e-06 $X=83870 $Y=142630 $dt=16
M4264 436 230 324 1 pfet_01v8 L=1.5e-07 W=1.5e-06 $X=83870 $Y=150910 $dt=16
M4265 437 231 324 1 pfet_01v8 L=1.5e-07 W=1.5e-06 $X=83870 $Y=159190 $dt=16
M4266 309 289 419 1 pfet_01v8 L=1.5e-07 W=1.5e-06 $X=84300 $Y=10150 $dt=16
M4267 309 290 420 1 pfet_01v8 L=1.5e-07 W=1.5e-06 $X=84300 $Y=18430 $dt=16
M4268 309 291 421 1 pfet_01v8 L=1.5e-07 W=1.5e-06 $X=84300 $Y=26710 $dt=16
M4269 309 292 422 1 pfet_01v8 L=1.5e-07 W=1.5e-06 $X=84300 $Y=34990 $dt=16
M4270 309 293 423 1 pfet_01v8 L=1.5e-07 W=1.5e-06 $X=84300 $Y=43270 $dt=16
M4271 309 294 424 1 pfet_01v8 L=1.5e-07 W=1.5e-06 $X=84300 $Y=51550 $dt=16
M4272 309 295 425 1 pfet_01v8 L=1.5e-07 W=1.5e-06 $X=84300 $Y=59830 $dt=16
M4273 309 296 426 1 pfet_01v8 L=1.5e-07 W=1.5e-06 $X=84300 $Y=68110 $dt=16
M4274 309 297 427 1 pfet_01v8 L=1.5e-07 W=1.5e-06 $X=84300 $Y=76390 $dt=16
M4275 309 298 428 1 pfet_01v8 L=1.5e-07 W=1.5e-06 $X=84300 $Y=84670 $dt=16
M4276 309 299 429 1 pfet_01v8 L=1.5e-07 W=1.5e-06 $X=84300 $Y=92950 $dt=16
M4277 309 300 430 1 pfet_01v8 L=1.5e-07 W=1.5e-06 $X=84300 $Y=101230 $dt=16
M4278 309 301 431 1 pfet_01v8 L=1.5e-07 W=1.5e-06 $X=84300 $Y=109510 $dt=16
M4279 309 302 432 1 pfet_01v8 L=1.5e-07 W=1.5e-06 $X=84300 $Y=117790 $dt=16
M4280 309 303 433 1 pfet_01v8 L=1.5e-07 W=1.5e-06 $X=84300 $Y=126070 $dt=16
M4281 309 304 434 1 pfet_01v8 L=1.5e-07 W=1.5e-06 $X=84300 $Y=134350 $dt=16
M4282 309 305 435 1 pfet_01v8 L=1.5e-07 W=1.5e-06 $X=84300 $Y=142630 $dt=16
M4283 309 306 436 1 pfet_01v8 L=1.5e-07 W=1.5e-06 $X=84300 $Y=150910 $dt=16
M4284 309 307 437 1 pfet_01v8 L=1.5e-07 W=1.5e-06 $X=84300 $Y=159190 $dt=16
M4285 419 270 419 1 pfet_01v8 L=1.5e-07 W=1.5e-06 $X=90000 $Y=10150 $dt=16
M4286 420 271 420 1 pfet_01v8 L=1.5e-07 W=1.5e-06 $X=90000 $Y=18430 $dt=16
M4287 421 272 421 1 pfet_01v8 L=1.5e-07 W=1.5e-06 $X=90000 $Y=26710 $dt=16
M4288 422 273 422 1 pfet_01v8 L=1.5e-07 W=1.5e-06 $X=90000 $Y=34990 $dt=16
M4289 423 274 423 1 pfet_01v8 L=1.5e-07 W=1.5e-06 $X=90000 $Y=43270 $dt=16
M4290 424 275 424 1 pfet_01v8 L=1.5e-07 W=1.5e-06 $X=90000 $Y=51550 $dt=16
M4291 425 276 425 1 pfet_01v8 L=1.5e-07 W=1.5e-06 $X=90000 $Y=59830 $dt=16
M4292 426 277 426 1 pfet_01v8 L=1.5e-07 W=1.5e-06 $X=90000 $Y=68110 $dt=16
M4293 427 278 427 1 pfet_01v8 L=1.5e-07 W=1.5e-06 $X=90000 $Y=76390 $dt=16
M4294 428 279 428 1 pfet_01v8 L=1.5e-07 W=1.5e-06 $X=90000 $Y=84670 $dt=16
M4295 429 280 429 1 pfet_01v8 L=1.5e-07 W=1.5e-06 $X=90000 $Y=92950 $dt=16
M4296 430 281 430 1 pfet_01v8 L=1.5e-07 W=1.5e-06 $X=90000 $Y=101230 $dt=16
M4297 431 282 431 1 pfet_01v8 L=1.5e-07 W=1.5e-06 $X=90000 $Y=109510 $dt=16
M4298 432 283 432 1 pfet_01v8 L=1.5e-07 W=1.5e-06 $X=90000 $Y=117790 $dt=16
M4299 433 284 433 1 pfet_01v8 L=1.5e-07 W=1.5e-06 $X=90000 $Y=126070 $dt=16
M4300 434 285 434 1 pfet_01v8 L=1.5e-07 W=1.5e-06 $X=90000 $Y=134350 $dt=16
M4301 435 286 435 1 pfet_01v8 L=1.5e-07 W=1.5e-06 $X=90000 $Y=142630 $dt=16
M4302 436 287 436 1 pfet_01v8 L=1.5e-07 W=1.5e-06 $X=90000 $Y=150910 $dt=16
M4303 437 288 437 1 pfet_01v8 L=1.5e-07 W=1.5e-06 $X=90000 $Y=159190 $dt=16
M4304 308 175 419 1 pfet_01v8 L=1.5e-07 W=1.5e-06 $X=90430 $Y=10150 $dt=16
M4305 308 176 420 1 pfet_01v8 L=1.5e-07 W=1.5e-06 $X=90430 $Y=18430 $dt=16
M4306 308 177 421 1 pfet_01v8 L=1.5e-07 W=1.5e-06 $X=90430 $Y=26710 $dt=16
M4307 308 178 422 1 pfet_01v8 L=1.5e-07 W=1.5e-06 $X=90430 $Y=34990 $dt=16
M4308 308 179 423 1 pfet_01v8 L=1.5e-07 W=1.5e-06 $X=90430 $Y=43270 $dt=16
M4309 308 180 424 1 pfet_01v8 L=1.5e-07 W=1.5e-06 $X=90430 $Y=51550 $dt=16
M4310 308 181 425 1 pfet_01v8 L=1.5e-07 W=1.5e-06 $X=90430 $Y=59830 $dt=16
M4311 308 182 426 1 pfet_01v8 L=1.5e-07 W=1.5e-06 $X=90430 $Y=68110 $dt=16
M4312 308 183 427 1 pfet_01v8 L=1.5e-07 W=1.5e-06 $X=90430 $Y=76390 $dt=16
M4313 308 184 428 1 pfet_01v8 L=1.5e-07 W=1.5e-06 $X=90430 $Y=84670 $dt=16
M4314 308 185 429 1 pfet_01v8 L=1.5e-07 W=1.5e-06 $X=90430 $Y=92950 $dt=16
M4315 308 186 430 1 pfet_01v8 L=1.5e-07 W=1.5e-06 $X=90430 $Y=101230 $dt=16
M4316 308 187 431 1 pfet_01v8 L=1.5e-07 W=1.5e-06 $X=90430 $Y=109510 $dt=16
M4317 308 188 432 1 pfet_01v8 L=1.5e-07 W=1.5e-06 $X=90430 $Y=117790 $dt=16
M4318 308 189 433 1 pfet_01v8 L=1.5e-07 W=1.5e-06 $X=90430 $Y=126070 $dt=16
M4319 308 190 434 1 pfet_01v8 L=1.5e-07 W=1.5e-06 $X=90430 $Y=134350 $dt=16
M4320 308 191 435 1 pfet_01v8 L=1.5e-07 W=1.5e-06 $X=90430 $Y=142630 $dt=16
M4321 308 192 436 1 pfet_01v8 L=1.5e-07 W=1.5e-06 $X=90430 $Y=150910 $dt=16
M4322 308 193 437 1 pfet_01v8 L=1.5e-07 W=1.5e-06 $X=90430 $Y=159190 $dt=16
M4323 401 213 324 1 pfet_01v8 L=1.5e-07 W=1.5e-06 $X=92150 $Y=10150 $dt=16
M4324 402 214 324 1 pfet_01v8 L=1.5e-07 W=1.5e-06 $X=92150 $Y=18430 $dt=16
M4325 403 215 324 1 pfet_01v8 L=1.5e-07 W=1.5e-06 $X=92150 $Y=26710 $dt=16
M4326 404 216 324 1 pfet_01v8 L=1.5e-07 W=1.5e-06 $X=92150 $Y=34990 $dt=16
M4327 405 217 324 1 pfet_01v8 L=1.5e-07 W=1.5e-06 $X=92150 $Y=43270 $dt=16
M4328 406 218 324 1 pfet_01v8 L=1.5e-07 W=1.5e-06 $X=92150 $Y=51550 $dt=16
M4329 407 219 324 1 pfet_01v8 L=1.5e-07 W=1.5e-06 $X=92150 $Y=59830 $dt=16
M4330 408 220 324 1 pfet_01v8 L=1.5e-07 W=1.5e-06 $X=92150 $Y=68110 $dt=16
M4331 409 221 324 1 pfet_01v8 L=1.5e-07 W=1.5e-06 $X=92150 $Y=76390 $dt=16
M4332 1 3 1 1 pfet_01v8 L=5.8e-07 W=1.5e-06 $X=92150 $Y=84670 $dt=16
M4333 410 223 324 1 pfet_01v8 L=1.5e-07 W=1.5e-06 $X=92150 $Y=92950 $dt=16
M4334 411 224 324 1 pfet_01v8 L=1.5e-07 W=1.5e-06 $X=92150 $Y=101230 $dt=16
M4335 412 225 324 1 pfet_01v8 L=1.5e-07 W=1.5e-06 $X=92150 $Y=109510 $dt=16
M4336 413 226 324 1 pfet_01v8 L=1.5e-07 W=1.5e-06 $X=92150 $Y=117790 $dt=16
M4337 414 227 324 1 pfet_01v8 L=1.5e-07 W=1.5e-06 $X=92150 $Y=126070 $dt=16
M4338 415 228 324 1 pfet_01v8 L=1.5e-07 W=1.5e-06 $X=92150 $Y=134350 $dt=16
M4339 416 229 324 1 pfet_01v8 L=1.5e-07 W=1.5e-06 $X=92150 $Y=142630 $dt=16
M4340 417 230 324 1 pfet_01v8 L=1.5e-07 W=1.5e-06 $X=92150 $Y=150910 $dt=16
M4341 418 231 324 1 pfet_01v8 L=1.5e-07 W=1.5e-06 $X=92150 $Y=159190 $dt=16
M4342 309 289 401 1 pfet_01v8 L=1.5e-07 W=1.5e-06 $X=92580 $Y=10150 $dt=16
M4343 309 290 402 1 pfet_01v8 L=1.5e-07 W=1.5e-06 $X=92580 $Y=18430 $dt=16
M4344 309 291 403 1 pfet_01v8 L=1.5e-07 W=1.5e-06 $X=92580 $Y=26710 $dt=16
M4345 309 292 404 1 pfet_01v8 L=1.5e-07 W=1.5e-06 $X=92580 $Y=34990 $dt=16
M4346 309 293 405 1 pfet_01v8 L=1.5e-07 W=1.5e-06 $X=92580 $Y=43270 $dt=16
M4347 309 294 406 1 pfet_01v8 L=1.5e-07 W=1.5e-06 $X=92580 $Y=51550 $dt=16
M4348 309 295 407 1 pfet_01v8 L=1.5e-07 W=1.5e-06 $X=92580 $Y=59830 $dt=16
M4349 309 296 408 1 pfet_01v8 L=1.5e-07 W=1.5e-06 $X=92580 $Y=68110 $dt=16
M4350 309 297 409 1 pfet_01v8 L=1.5e-07 W=1.5e-06 $X=92580 $Y=76390 $dt=16
M4351 309 299 410 1 pfet_01v8 L=1.5e-07 W=1.5e-06 $X=92580 $Y=92950 $dt=16
M4352 309 300 411 1 pfet_01v8 L=1.5e-07 W=1.5e-06 $X=92580 $Y=101230 $dt=16
M4353 309 301 412 1 pfet_01v8 L=1.5e-07 W=1.5e-06 $X=92580 $Y=109510 $dt=16
M4354 309 302 413 1 pfet_01v8 L=1.5e-07 W=1.5e-06 $X=92580 $Y=117790 $dt=16
M4355 309 303 414 1 pfet_01v8 L=1.5e-07 W=1.5e-06 $X=92580 $Y=126070 $dt=16
M4356 309 304 415 1 pfet_01v8 L=1.5e-07 W=1.5e-06 $X=92580 $Y=134350 $dt=16
M4357 309 305 416 1 pfet_01v8 L=1.5e-07 W=1.5e-06 $X=92580 $Y=142630 $dt=16
M4358 309 306 417 1 pfet_01v8 L=1.5e-07 W=1.5e-06 $X=92580 $Y=150910 $dt=16
M4359 309 307 418 1 pfet_01v8 L=1.5e-07 W=1.5e-06 $X=92580 $Y=159190 $dt=16
M4360 1 3 1 1 pfet_01v8 L=5.8e-07 W=1.5e-06 $X=98270 $Y=84670 $dt=16
M4361 401 270 401 1 pfet_01v8 L=1.5e-07 W=1.5e-06 $X=98280 $Y=10150 $dt=16
M4362 402 271 402 1 pfet_01v8 L=1.5e-07 W=1.5e-06 $X=98280 $Y=18430 $dt=16
M4363 403 272 403 1 pfet_01v8 L=1.5e-07 W=1.5e-06 $X=98280 $Y=26710 $dt=16
M4364 404 273 404 1 pfet_01v8 L=1.5e-07 W=1.5e-06 $X=98280 $Y=34990 $dt=16
M4365 405 274 405 1 pfet_01v8 L=1.5e-07 W=1.5e-06 $X=98280 $Y=43270 $dt=16
M4366 406 275 406 1 pfet_01v8 L=1.5e-07 W=1.5e-06 $X=98280 $Y=51550 $dt=16
M4367 407 276 407 1 pfet_01v8 L=1.5e-07 W=1.5e-06 $X=98280 $Y=59830 $dt=16
M4368 408 277 408 1 pfet_01v8 L=1.5e-07 W=1.5e-06 $X=98280 $Y=68110 $dt=16
M4369 409 278 409 1 pfet_01v8 L=1.5e-07 W=1.5e-06 $X=98280 $Y=76390 $dt=16
M4370 410 280 410 1 pfet_01v8 L=1.5e-07 W=1.5e-06 $X=98280 $Y=92950 $dt=16
M4371 411 281 411 1 pfet_01v8 L=1.5e-07 W=1.5e-06 $X=98280 $Y=101230 $dt=16
M4372 412 282 412 1 pfet_01v8 L=1.5e-07 W=1.5e-06 $X=98280 $Y=109510 $dt=16
M4373 413 283 413 1 pfet_01v8 L=1.5e-07 W=1.5e-06 $X=98280 $Y=117790 $dt=16
M4374 414 284 414 1 pfet_01v8 L=1.5e-07 W=1.5e-06 $X=98280 $Y=126070 $dt=16
M4375 415 285 415 1 pfet_01v8 L=1.5e-07 W=1.5e-06 $X=98280 $Y=134350 $dt=16
M4376 416 286 416 1 pfet_01v8 L=1.5e-07 W=1.5e-06 $X=98280 $Y=142630 $dt=16
M4377 417 287 417 1 pfet_01v8 L=1.5e-07 W=1.5e-06 $X=98280 $Y=150910 $dt=16
M4378 418 288 418 1 pfet_01v8 L=1.5e-07 W=1.5e-06 $X=98280 $Y=159190 $dt=16
M4379 308 175 401 1 pfet_01v8 L=1.5e-07 W=1.5e-06 $X=98710 $Y=10150 $dt=16
M4380 308 176 402 1 pfet_01v8 L=1.5e-07 W=1.5e-06 $X=98710 $Y=18430 $dt=16
M4381 308 177 403 1 pfet_01v8 L=1.5e-07 W=1.5e-06 $X=98710 $Y=26710 $dt=16
M4382 308 178 404 1 pfet_01v8 L=1.5e-07 W=1.5e-06 $X=98710 $Y=34990 $dt=16
M4383 308 179 405 1 pfet_01v8 L=1.5e-07 W=1.5e-06 $X=98710 $Y=43270 $dt=16
M4384 308 180 406 1 pfet_01v8 L=1.5e-07 W=1.5e-06 $X=98710 $Y=51550 $dt=16
M4385 308 181 407 1 pfet_01v8 L=1.5e-07 W=1.5e-06 $X=98710 $Y=59830 $dt=16
M4386 308 182 408 1 pfet_01v8 L=1.5e-07 W=1.5e-06 $X=98710 $Y=68110 $dt=16
M4387 308 183 409 1 pfet_01v8 L=1.5e-07 W=1.5e-06 $X=98710 $Y=76390 $dt=16
M4388 308 185 410 1 pfet_01v8 L=1.5e-07 W=1.5e-06 $X=98710 $Y=92950 $dt=16
M4389 308 186 411 1 pfet_01v8 L=1.5e-07 W=1.5e-06 $X=98710 $Y=101230 $dt=16
M4390 308 187 412 1 pfet_01v8 L=1.5e-07 W=1.5e-06 $X=98710 $Y=109510 $dt=16
M4391 308 188 413 1 pfet_01v8 L=1.5e-07 W=1.5e-06 $X=98710 $Y=117790 $dt=16
M4392 308 189 414 1 pfet_01v8 L=1.5e-07 W=1.5e-06 $X=98710 $Y=126070 $dt=16
M4393 308 190 415 1 pfet_01v8 L=1.5e-07 W=1.5e-06 $X=98710 $Y=134350 $dt=16
M4394 308 191 416 1 pfet_01v8 L=1.5e-07 W=1.5e-06 $X=98710 $Y=142630 $dt=16
M4395 308 192 417 1 pfet_01v8 L=1.5e-07 W=1.5e-06 $X=98710 $Y=150910 $dt=16
M4396 308 193 418 1 pfet_01v8 L=1.5e-07 W=1.5e-06 $X=98710 $Y=159190 $dt=16
M4397 384 213 324 1 pfet_01v8 L=1.5e-07 W=1.5e-06 $X=100430 $Y=10150 $dt=16
M4398 385 214 324 1 pfet_01v8 L=1.5e-07 W=1.5e-06 $X=100430 $Y=18430 $dt=16
M4399 386 215 324 1 pfet_01v8 L=1.5e-07 W=1.5e-06 $X=100430 $Y=26710 $dt=16
M4400 387 216 324 1 pfet_01v8 L=1.5e-07 W=1.5e-06 $X=100430 $Y=34990 $dt=16
M4401 388 217 324 1 pfet_01v8 L=1.5e-07 W=1.5e-06 $X=100430 $Y=43270 $dt=16
M4402 389 218 324 1 pfet_01v8 L=1.5e-07 W=1.5e-06 $X=100430 $Y=51550 $dt=16
M4403 390 219 324 1 pfet_01v8 L=1.5e-07 W=1.5e-06 $X=100430 $Y=59830 $dt=16
M4404 391 220 324 1 pfet_01v8 L=1.5e-07 W=1.5e-06 $X=100430 $Y=68110 $dt=16
M4405 392 221 324 1 pfet_01v8 L=1.5e-07 W=1.5e-06 $X=100430 $Y=76390 $dt=16
M4406 1 3 1 1 pfet_01v8 L=5.8e-07 W=1.5e-06 $X=100430 $Y=84670 $dt=16
M4407 1 3 1 1 pfet_01v8 L=5.8e-07 W=1.5e-06 $X=100430 $Y=92950 $dt=16
M4408 393 224 324 1 pfet_01v8 L=1.5e-07 W=1.5e-06 $X=100430 $Y=101230 $dt=16
M4409 394 225 324 1 pfet_01v8 L=1.5e-07 W=1.5e-06 $X=100430 $Y=109510 $dt=16
M4410 395 226 324 1 pfet_01v8 L=1.5e-07 W=1.5e-06 $X=100430 $Y=117790 $dt=16
M4411 396 227 324 1 pfet_01v8 L=1.5e-07 W=1.5e-06 $X=100430 $Y=126070 $dt=16
M4412 397 228 324 1 pfet_01v8 L=1.5e-07 W=1.5e-06 $X=100430 $Y=134350 $dt=16
M4413 398 229 324 1 pfet_01v8 L=1.5e-07 W=1.5e-06 $X=100430 $Y=142630 $dt=16
M4414 399 230 324 1 pfet_01v8 L=1.5e-07 W=1.5e-06 $X=100430 $Y=150910 $dt=16
M4415 400 231 324 1 pfet_01v8 L=1.5e-07 W=1.5e-06 $X=100430 $Y=159190 $dt=16
M4416 309 289 384 1 pfet_01v8 L=1.5e-07 W=1.5e-06 $X=100860 $Y=10150 $dt=16
M4417 309 290 385 1 pfet_01v8 L=1.5e-07 W=1.5e-06 $X=100860 $Y=18430 $dt=16
M4418 309 291 386 1 pfet_01v8 L=1.5e-07 W=1.5e-06 $X=100860 $Y=26710 $dt=16
M4419 309 292 387 1 pfet_01v8 L=1.5e-07 W=1.5e-06 $X=100860 $Y=34990 $dt=16
M4420 309 293 388 1 pfet_01v8 L=1.5e-07 W=1.5e-06 $X=100860 $Y=43270 $dt=16
M4421 309 294 389 1 pfet_01v8 L=1.5e-07 W=1.5e-06 $X=100860 $Y=51550 $dt=16
M4422 309 295 390 1 pfet_01v8 L=1.5e-07 W=1.5e-06 $X=100860 $Y=59830 $dt=16
M4423 309 296 391 1 pfet_01v8 L=1.5e-07 W=1.5e-06 $X=100860 $Y=68110 $dt=16
M4424 309 297 392 1 pfet_01v8 L=1.5e-07 W=1.5e-06 $X=100860 $Y=76390 $dt=16
M4425 309 300 393 1 pfet_01v8 L=1.5e-07 W=1.5e-06 $X=100860 $Y=101230 $dt=16
M4426 309 301 394 1 pfet_01v8 L=1.5e-07 W=1.5e-06 $X=100860 $Y=109510 $dt=16
M4427 309 302 395 1 pfet_01v8 L=1.5e-07 W=1.5e-06 $X=100860 $Y=117790 $dt=16
M4428 309 303 396 1 pfet_01v8 L=1.5e-07 W=1.5e-06 $X=100860 $Y=126070 $dt=16
M4429 309 304 397 1 pfet_01v8 L=1.5e-07 W=1.5e-06 $X=100860 $Y=134350 $dt=16
M4430 309 305 398 1 pfet_01v8 L=1.5e-07 W=1.5e-06 $X=100860 $Y=142630 $dt=16
M4431 309 306 399 1 pfet_01v8 L=1.5e-07 W=1.5e-06 $X=100860 $Y=150910 $dt=16
M4432 309 307 400 1 pfet_01v8 L=1.5e-07 W=1.5e-06 $X=100860 $Y=159190 $dt=16
M4433 1 3 1 1 pfet_01v8 L=5.8e-07 W=1.5e-06 $X=106550 $Y=84670 $dt=16
M4434 1 3 1 1 pfet_01v8 L=5.8e-07 W=1.5e-06 $X=106550 $Y=92950 $dt=16
M4435 384 270 384 1 pfet_01v8 L=1.5e-07 W=1.5e-06 $X=106560 $Y=10150 $dt=16
M4436 385 271 385 1 pfet_01v8 L=1.5e-07 W=1.5e-06 $X=106560 $Y=18430 $dt=16
M4437 386 272 386 1 pfet_01v8 L=1.5e-07 W=1.5e-06 $X=106560 $Y=26710 $dt=16
M4438 387 273 387 1 pfet_01v8 L=1.5e-07 W=1.5e-06 $X=106560 $Y=34990 $dt=16
M4439 388 274 388 1 pfet_01v8 L=1.5e-07 W=1.5e-06 $X=106560 $Y=43270 $dt=16
M4440 389 275 389 1 pfet_01v8 L=1.5e-07 W=1.5e-06 $X=106560 $Y=51550 $dt=16
M4441 390 276 390 1 pfet_01v8 L=1.5e-07 W=1.5e-06 $X=106560 $Y=59830 $dt=16
M4442 391 277 391 1 pfet_01v8 L=1.5e-07 W=1.5e-06 $X=106560 $Y=68110 $dt=16
M4443 392 278 392 1 pfet_01v8 L=1.5e-07 W=1.5e-06 $X=106560 $Y=76390 $dt=16
M4444 393 281 393 1 pfet_01v8 L=1.5e-07 W=1.5e-06 $X=106560 $Y=101230 $dt=16
M4445 394 282 394 1 pfet_01v8 L=1.5e-07 W=1.5e-06 $X=106560 $Y=109510 $dt=16
M4446 395 283 395 1 pfet_01v8 L=1.5e-07 W=1.5e-06 $X=106560 $Y=117790 $dt=16
M4447 396 284 396 1 pfet_01v8 L=1.5e-07 W=1.5e-06 $X=106560 $Y=126070 $dt=16
M4448 397 285 397 1 pfet_01v8 L=1.5e-07 W=1.5e-06 $X=106560 $Y=134350 $dt=16
M4449 398 286 398 1 pfet_01v8 L=1.5e-07 W=1.5e-06 $X=106560 $Y=142630 $dt=16
M4450 399 287 399 1 pfet_01v8 L=1.5e-07 W=1.5e-06 $X=106560 $Y=150910 $dt=16
M4451 400 288 400 1 pfet_01v8 L=1.5e-07 W=1.5e-06 $X=106560 $Y=159190 $dt=16
M4452 308 175 384 1 pfet_01v8 L=1.5e-07 W=1.5e-06 $X=106990 $Y=10150 $dt=16
M4453 308 176 385 1 pfet_01v8 L=1.5e-07 W=1.5e-06 $X=106990 $Y=18430 $dt=16
M4454 308 177 386 1 pfet_01v8 L=1.5e-07 W=1.5e-06 $X=106990 $Y=26710 $dt=16
M4455 308 178 387 1 pfet_01v8 L=1.5e-07 W=1.5e-06 $X=106990 $Y=34990 $dt=16
M4456 308 179 388 1 pfet_01v8 L=1.5e-07 W=1.5e-06 $X=106990 $Y=43270 $dt=16
M4457 308 180 389 1 pfet_01v8 L=1.5e-07 W=1.5e-06 $X=106990 $Y=51550 $dt=16
M4458 308 181 390 1 pfet_01v8 L=1.5e-07 W=1.5e-06 $X=106990 $Y=59830 $dt=16
M4459 308 182 391 1 pfet_01v8 L=1.5e-07 W=1.5e-06 $X=106990 $Y=68110 $dt=16
M4460 308 183 392 1 pfet_01v8 L=1.5e-07 W=1.5e-06 $X=106990 $Y=76390 $dt=16
M4461 308 186 393 1 pfet_01v8 L=1.5e-07 W=1.5e-06 $X=106990 $Y=101230 $dt=16
M4462 308 187 394 1 pfet_01v8 L=1.5e-07 W=1.5e-06 $X=106990 $Y=109510 $dt=16
M4463 308 188 395 1 pfet_01v8 L=1.5e-07 W=1.5e-06 $X=106990 $Y=117790 $dt=16
M4464 308 189 396 1 pfet_01v8 L=1.5e-07 W=1.5e-06 $X=106990 $Y=126070 $dt=16
M4465 308 190 397 1 pfet_01v8 L=1.5e-07 W=1.5e-06 $X=106990 $Y=134350 $dt=16
M4466 308 191 398 1 pfet_01v8 L=1.5e-07 W=1.5e-06 $X=106990 $Y=142630 $dt=16
M4467 308 192 399 1 pfet_01v8 L=1.5e-07 W=1.5e-06 $X=106990 $Y=150910 $dt=16
M4468 308 193 400 1 pfet_01v8 L=1.5e-07 W=1.5e-06 $X=106990 $Y=159190 $dt=16
M4469 367 213 324 1 pfet_01v8 L=1.5e-07 W=1.5e-06 $X=108710 $Y=10150 $dt=16
M4470 368 214 324 1 pfet_01v8 L=1.5e-07 W=1.5e-06 $X=108710 $Y=18430 $dt=16
M4471 369 215 324 1 pfet_01v8 L=1.5e-07 W=1.5e-06 $X=108710 $Y=26710 $dt=16
M4472 370 216 324 1 pfet_01v8 L=1.5e-07 W=1.5e-06 $X=108710 $Y=34990 $dt=16
M4473 371 217 324 1 pfet_01v8 L=1.5e-07 W=1.5e-06 $X=108710 $Y=43270 $dt=16
M4474 372 218 324 1 pfet_01v8 L=1.5e-07 W=1.5e-06 $X=108710 $Y=51550 $dt=16
M4475 373 219 324 1 pfet_01v8 L=1.5e-07 W=1.5e-06 $X=108710 $Y=59830 $dt=16
M4476 374 220 324 1 pfet_01v8 L=1.5e-07 W=1.5e-06 $X=108710 $Y=68110 $dt=16
M4477 375 221 324 1 pfet_01v8 L=1.5e-07 W=1.5e-06 $X=108710 $Y=76390 $dt=16
M4478 1 3 1 1 pfet_01v8 L=5.8e-07 W=1.5e-06 $X=108710 $Y=84670 $dt=16
M4479 1 3 1 1 pfet_01v8 L=5.8e-07 W=1.5e-06 $X=108710 $Y=92950 $dt=16
M4480 376 224 324 1 pfet_01v8 L=1.5e-07 W=1.5e-06 $X=108710 $Y=101230 $dt=16
M4481 377 225 324 1 pfet_01v8 L=1.5e-07 W=1.5e-06 $X=108710 $Y=109510 $dt=16
M4482 378 226 324 1 pfet_01v8 L=1.5e-07 W=1.5e-06 $X=108710 $Y=117790 $dt=16
M4483 379 227 324 1 pfet_01v8 L=1.5e-07 W=1.5e-06 $X=108710 $Y=126070 $dt=16
M4484 380 228 324 1 pfet_01v8 L=1.5e-07 W=1.5e-06 $X=108710 $Y=134350 $dt=16
M4485 381 229 324 1 pfet_01v8 L=1.5e-07 W=1.5e-06 $X=108710 $Y=142630 $dt=16
M4486 382 230 324 1 pfet_01v8 L=1.5e-07 W=1.5e-06 $X=108710 $Y=150910 $dt=16
M4487 383 231 324 1 pfet_01v8 L=1.5e-07 W=1.5e-06 $X=108710 $Y=159190 $dt=16
M4488 309 289 367 1 pfet_01v8 L=1.5e-07 W=1.5e-06 $X=109140 $Y=10150 $dt=16
M4489 309 290 368 1 pfet_01v8 L=1.5e-07 W=1.5e-06 $X=109140 $Y=18430 $dt=16
M4490 309 291 369 1 pfet_01v8 L=1.5e-07 W=1.5e-06 $X=109140 $Y=26710 $dt=16
M4491 309 292 370 1 pfet_01v8 L=1.5e-07 W=1.5e-06 $X=109140 $Y=34990 $dt=16
M4492 309 293 371 1 pfet_01v8 L=1.5e-07 W=1.5e-06 $X=109140 $Y=43270 $dt=16
M4493 309 294 372 1 pfet_01v8 L=1.5e-07 W=1.5e-06 $X=109140 $Y=51550 $dt=16
M4494 309 295 373 1 pfet_01v8 L=1.5e-07 W=1.5e-06 $X=109140 $Y=59830 $dt=16
M4495 309 296 374 1 pfet_01v8 L=1.5e-07 W=1.5e-06 $X=109140 $Y=68110 $dt=16
M4496 309 297 375 1 pfet_01v8 L=1.5e-07 W=1.5e-06 $X=109140 $Y=76390 $dt=16
M4497 309 300 376 1 pfet_01v8 L=1.5e-07 W=1.5e-06 $X=109140 $Y=101230 $dt=16
M4498 309 301 377 1 pfet_01v8 L=1.5e-07 W=1.5e-06 $X=109140 $Y=109510 $dt=16
M4499 309 302 378 1 pfet_01v8 L=1.5e-07 W=1.5e-06 $X=109140 $Y=117790 $dt=16
M4500 309 303 379 1 pfet_01v8 L=1.5e-07 W=1.5e-06 $X=109140 $Y=126070 $dt=16
M4501 309 304 380 1 pfet_01v8 L=1.5e-07 W=1.5e-06 $X=109140 $Y=134350 $dt=16
M4502 309 305 381 1 pfet_01v8 L=1.5e-07 W=1.5e-06 $X=109140 $Y=142630 $dt=16
M4503 309 306 382 1 pfet_01v8 L=1.5e-07 W=1.5e-06 $X=109140 $Y=150910 $dt=16
M4504 309 307 383 1 pfet_01v8 L=1.5e-07 W=1.5e-06 $X=109140 $Y=159190 $dt=16
M4505 1 3 1 1 pfet_01v8 L=5.8e-07 W=1.5e-06 $X=114830 $Y=84670 $dt=16
M4506 1 3 1 1 pfet_01v8 L=5.8e-07 W=1.5e-06 $X=114830 $Y=92950 $dt=16
M4507 367 270 367 1 pfet_01v8 L=1.5e-07 W=1.5e-06 $X=114840 $Y=10150 $dt=16
M4508 368 271 368 1 pfet_01v8 L=1.5e-07 W=1.5e-06 $X=114840 $Y=18430 $dt=16
M4509 369 272 369 1 pfet_01v8 L=1.5e-07 W=1.5e-06 $X=114840 $Y=26710 $dt=16
M4510 370 273 370 1 pfet_01v8 L=1.5e-07 W=1.5e-06 $X=114840 $Y=34990 $dt=16
M4511 371 274 371 1 pfet_01v8 L=1.5e-07 W=1.5e-06 $X=114840 $Y=43270 $dt=16
M4512 372 275 372 1 pfet_01v8 L=1.5e-07 W=1.5e-06 $X=114840 $Y=51550 $dt=16
M4513 373 276 373 1 pfet_01v8 L=1.5e-07 W=1.5e-06 $X=114840 $Y=59830 $dt=16
M4514 374 277 374 1 pfet_01v8 L=1.5e-07 W=1.5e-06 $X=114840 $Y=68110 $dt=16
M4515 375 278 375 1 pfet_01v8 L=1.5e-07 W=1.5e-06 $X=114840 $Y=76390 $dt=16
M4516 376 281 376 1 pfet_01v8 L=1.5e-07 W=1.5e-06 $X=114840 $Y=101230 $dt=16
M4517 377 282 377 1 pfet_01v8 L=1.5e-07 W=1.5e-06 $X=114840 $Y=109510 $dt=16
M4518 378 283 378 1 pfet_01v8 L=1.5e-07 W=1.5e-06 $X=114840 $Y=117790 $dt=16
M4519 379 284 379 1 pfet_01v8 L=1.5e-07 W=1.5e-06 $X=114840 $Y=126070 $dt=16
M4520 380 285 380 1 pfet_01v8 L=1.5e-07 W=1.5e-06 $X=114840 $Y=134350 $dt=16
M4521 381 286 381 1 pfet_01v8 L=1.5e-07 W=1.5e-06 $X=114840 $Y=142630 $dt=16
M4522 382 287 382 1 pfet_01v8 L=1.5e-07 W=1.5e-06 $X=114840 $Y=150910 $dt=16
M4523 383 288 383 1 pfet_01v8 L=1.5e-07 W=1.5e-06 $X=114840 $Y=159190 $dt=16
M4524 308 175 367 1 pfet_01v8 L=1.5e-07 W=1.5e-06 $X=115270 $Y=10150 $dt=16
M4525 308 176 368 1 pfet_01v8 L=1.5e-07 W=1.5e-06 $X=115270 $Y=18430 $dt=16
M4526 308 177 369 1 pfet_01v8 L=1.5e-07 W=1.5e-06 $X=115270 $Y=26710 $dt=16
M4527 308 178 370 1 pfet_01v8 L=1.5e-07 W=1.5e-06 $X=115270 $Y=34990 $dt=16
M4528 308 179 371 1 pfet_01v8 L=1.5e-07 W=1.5e-06 $X=115270 $Y=43270 $dt=16
M4529 308 180 372 1 pfet_01v8 L=1.5e-07 W=1.5e-06 $X=115270 $Y=51550 $dt=16
M4530 308 181 373 1 pfet_01v8 L=1.5e-07 W=1.5e-06 $X=115270 $Y=59830 $dt=16
M4531 308 182 374 1 pfet_01v8 L=1.5e-07 W=1.5e-06 $X=115270 $Y=68110 $dt=16
M4532 308 183 375 1 pfet_01v8 L=1.5e-07 W=1.5e-06 $X=115270 $Y=76390 $dt=16
M4533 308 186 376 1 pfet_01v8 L=1.5e-07 W=1.5e-06 $X=115270 $Y=101230 $dt=16
M4534 308 187 377 1 pfet_01v8 L=1.5e-07 W=1.5e-06 $X=115270 $Y=109510 $dt=16
M4535 308 188 378 1 pfet_01v8 L=1.5e-07 W=1.5e-06 $X=115270 $Y=117790 $dt=16
M4536 308 189 379 1 pfet_01v8 L=1.5e-07 W=1.5e-06 $X=115270 $Y=126070 $dt=16
M4537 308 190 380 1 pfet_01v8 L=1.5e-07 W=1.5e-06 $X=115270 $Y=134350 $dt=16
M4538 308 191 381 1 pfet_01v8 L=1.5e-07 W=1.5e-06 $X=115270 $Y=142630 $dt=16
M4539 308 192 382 1 pfet_01v8 L=1.5e-07 W=1.5e-06 $X=115270 $Y=150910 $dt=16
M4540 308 193 383 1 pfet_01v8 L=1.5e-07 W=1.5e-06 $X=115270 $Y=159190 $dt=16
M4541 353 213 324 1 pfet_01v8 L=1.5e-07 W=1.5e-06 $X=116990 $Y=10150 $dt=16
M4542 354 214 324 1 pfet_01v8 L=1.5e-07 W=1.5e-06 $X=116990 $Y=18430 $dt=16
M4543 355 215 324 1 pfet_01v8 L=1.5e-07 W=1.5e-06 $X=116990 $Y=26710 $dt=16
M4544 356 216 324 1 pfet_01v8 L=1.5e-07 W=1.5e-06 $X=116990 $Y=34990 $dt=16
M4545 357 217 324 1 pfet_01v8 L=1.5e-07 W=1.5e-06 $X=116990 $Y=43270 $dt=16
M4546 358 218 324 1 pfet_01v8 L=1.5e-07 W=1.5e-06 $X=116990 $Y=51550 $dt=16
M4547 359 219 324 1 pfet_01v8 L=1.5e-07 W=1.5e-06 $X=116990 $Y=59830 $dt=16
M4548 1 3 1 1 pfet_01v8 L=5.8e-07 W=1.5e-06 $X=116990 $Y=68110 $dt=16
M4549 1 3 1 1 pfet_01v8 L=5.8e-07 W=1.5e-06 $X=116990 $Y=76390 $dt=16
M4550 1 3 1 1 pfet_01v8 L=5.8e-07 W=1.5e-06 $X=116990 $Y=84670 $dt=16
M4551 1 3 1 1 pfet_01v8 L=5.8e-07 W=1.5e-06 $X=116990 $Y=92950 $dt=16
M4552 1 3 1 1 pfet_01v8 L=5.8e-07 W=1.5e-06 $X=116990 $Y=101230 $dt=16
M4553 360 225 324 1 pfet_01v8 L=1.5e-07 W=1.5e-06 $X=116990 $Y=109510 $dt=16
M4554 361 226 324 1 pfet_01v8 L=1.5e-07 W=1.5e-06 $X=116990 $Y=117790 $dt=16
M4555 362 227 324 1 pfet_01v8 L=1.5e-07 W=1.5e-06 $X=116990 $Y=126070 $dt=16
M4556 363 228 324 1 pfet_01v8 L=1.5e-07 W=1.5e-06 $X=116990 $Y=134350 $dt=16
M4557 364 229 324 1 pfet_01v8 L=1.5e-07 W=1.5e-06 $X=116990 $Y=142630 $dt=16
M4558 365 230 324 1 pfet_01v8 L=1.5e-07 W=1.5e-06 $X=116990 $Y=150910 $dt=16
M4559 366 231 324 1 pfet_01v8 L=1.5e-07 W=1.5e-06 $X=116990 $Y=159190 $dt=16
M4560 309 289 353 1 pfet_01v8 L=1.5e-07 W=1.5e-06 $X=117420 $Y=10150 $dt=16
M4561 309 290 354 1 pfet_01v8 L=1.5e-07 W=1.5e-06 $X=117420 $Y=18430 $dt=16
M4562 309 291 355 1 pfet_01v8 L=1.5e-07 W=1.5e-06 $X=117420 $Y=26710 $dt=16
M4563 309 292 356 1 pfet_01v8 L=1.5e-07 W=1.5e-06 $X=117420 $Y=34990 $dt=16
M4564 309 293 357 1 pfet_01v8 L=1.5e-07 W=1.5e-06 $X=117420 $Y=43270 $dt=16
M4565 309 294 358 1 pfet_01v8 L=1.5e-07 W=1.5e-06 $X=117420 $Y=51550 $dt=16
M4566 309 295 359 1 pfet_01v8 L=1.5e-07 W=1.5e-06 $X=117420 $Y=59830 $dt=16
M4567 309 301 360 1 pfet_01v8 L=1.5e-07 W=1.5e-06 $X=117420 $Y=109510 $dt=16
M4568 309 302 361 1 pfet_01v8 L=1.5e-07 W=1.5e-06 $X=117420 $Y=117790 $dt=16
M4569 309 303 362 1 pfet_01v8 L=1.5e-07 W=1.5e-06 $X=117420 $Y=126070 $dt=16
M4570 309 304 363 1 pfet_01v8 L=1.5e-07 W=1.5e-06 $X=117420 $Y=134350 $dt=16
M4571 309 305 364 1 pfet_01v8 L=1.5e-07 W=1.5e-06 $X=117420 $Y=142630 $dt=16
M4572 309 306 365 1 pfet_01v8 L=1.5e-07 W=1.5e-06 $X=117420 $Y=150910 $dt=16
M4573 309 307 366 1 pfet_01v8 L=1.5e-07 W=1.5e-06 $X=117420 $Y=159190 $dt=16
M4574 1 3 1 1 pfet_01v8 L=5.8e-07 W=1.5e-06 $X=123110 $Y=68110 $dt=16
M4575 1 3 1 1 pfet_01v8 L=5.8e-07 W=1.5e-06 $X=123110 $Y=76390 $dt=16
M4576 1 3 1 1 pfet_01v8 L=5.8e-07 W=1.5e-06 $X=123110 $Y=84670 $dt=16
M4577 1 3 1 1 pfet_01v8 L=5.8e-07 W=1.5e-06 $X=123110 $Y=92950 $dt=16
M4578 1 3 1 1 pfet_01v8 L=5.8e-07 W=1.5e-06 $X=123110 $Y=101230 $dt=16
M4579 353 270 353 1 pfet_01v8 L=1.5e-07 W=1.5e-06 $X=123120 $Y=10150 $dt=16
M4580 354 271 354 1 pfet_01v8 L=1.5e-07 W=1.5e-06 $X=123120 $Y=18430 $dt=16
M4581 355 272 355 1 pfet_01v8 L=1.5e-07 W=1.5e-06 $X=123120 $Y=26710 $dt=16
M4582 356 273 356 1 pfet_01v8 L=1.5e-07 W=1.5e-06 $X=123120 $Y=34990 $dt=16
M4583 357 274 357 1 pfet_01v8 L=1.5e-07 W=1.5e-06 $X=123120 $Y=43270 $dt=16
M4584 358 275 358 1 pfet_01v8 L=1.5e-07 W=1.5e-06 $X=123120 $Y=51550 $dt=16
M4585 359 276 359 1 pfet_01v8 L=1.5e-07 W=1.5e-06 $X=123120 $Y=59830 $dt=16
M4586 360 282 360 1 pfet_01v8 L=1.5e-07 W=1.5e-06 $X=123120 $Y=109510 $dt=16
M4587 361 283 361 1 pfet_01v8 L=1.5e-07 W=1.5e-06 $X=123120 $Y=117790 $dt=16
M4588 362 284 362 1 pfet_01v8 L=1.5e-07 W=1.5e-06 $X=123120 $Y=126070 $dt=16
M4589 363 285 363 1 pfet_01v8 L=1.5e-07 W=1.5e-06 $X=123120 $Y=134350 $dt=16
M4590 364 286 364 1 pfet_01v8 L=1.5e-07 W=1.5e-06 $X=123120 $Y=142630 $dt=16
M4591 365 287 365 1 pfet_01v8 L=1.5e-07 W=1.5e-06 $X=123120 $Y=150910 $dt=16
M4592 366 288 366 1 pfet_01v8 L=1.5e-07 W=1.5e-06 $X=123120 $Y=159190 $dt=16
M4593 308 175 353 1 pfet_01v8 L=1.5e-07 W=1.5e-06 $X=123550 $Y=10150 $dt=16
M4594 308 176 354 1 pfet_01v8 L=1.5e-07 W=1.5e-06 $X=123550 $Y=18430 $dt=16
M4595 308 177 355 1 pfet_01v8 L=1.5e-07 W=1.5e-06 $X=123550 $Y=26710 $dt=16
M4596 308 178 356 1 pfet_01v8 L=1.5e-07 W=1.5e-06 $X=123550 $Y=34990 $dt=16
M4597 308 179 357 1 pfet_01v8 L=1.5e-07 W=1.5e-06 $X=123550 $Y=43270 $dt=16
M4598 308 180 358 1 pfet_01v8 L=1.5e-07 W=1.5e-06 $X=123550 $Y=51550 $dt=16
M4599 308 181 359 1 pfet_01v8 L=1.5e-07 W=1.5e-06 $X=123550 $Y=59830 $dt=16
M4600 308 187 360 1 pfet_01v8 L=1.5e-07 W=1.5e-06 $X=123550 $Y=109510 $dt=16
M4601 308 188 361 1 pfet_01v8 L=1.5e-07 W=1.5e-06 $X=123550 $Y=117790 $dt=16
M4602 308 189 362 1 pfet_01v8 L=1.5e-07 W=1.5e-06 $X=123550 $Y=126070 $dt=16
M4603 308 190 363 1 pfet_01v8 L=1.5e-07 W=1.5e-06 $X=123550 $Y=134350 $dt=16
M4604 308 191 364 1 pfet_01v8 L=1.5e-07 W=1.5e-06 $X=123550 $Y=142630 $dt=16
M4605 308 192 365 1 pfet_01v8 L=1.5e-07 W=1.5e-06 $X=123550 $Y=150910 $dt=16
M4606 308 193 366 1 pfet_01v8 L=1.5e-07 W=1.5e-06 $X=123550 $Y=159190 $dt=16
M4607 339 213 324 1 pfet_01v8 L=1.5e-07 W=1.5e-06 $X=125270 $Y=10150 $dt=16
M4608 340 214 324 1 pfet_01v8 L=1.5e-07 W=1.5e-06 $X=125270 $Y=18430 $dt=16
M4609 341 215 324 1 pfet_01v8 L=1.5e-07 W=1.5e-06 $X=125270 $Y=26710 $dt=16
M4610 342 216 324 1 pfet_01v8 L=1.5e-07 W=1.5e-06 $X=125270 $Y=34990 $dt=16
M4611 343 217 324 1 pfet_01v8 L=1.5e-07 W=1.5e-06 $X=125270 $Y=43270 $dt=16
M4612 344 218 324 1 pfet_01v8 L=1.5e-07 W=1.5e-06 $X=125270 $Y=51550 $dt=16
M4613 345 219 324 1 pfet_01v8 L=1.5e-07 W=1.5e-06 $X=125270 $Y=59830 $dt=16
M4614 1 3 1 1 pfet_01v8 L=5.8e-07 W=1.5e-06 $X=125270 $Y=68110 $dt=16
M4615 1 3 1 1 pfet_01v8 L=5.8e-07 W=1.5e-06 $X=125270 $Y=76390 $dt=16
M4616 1 3 1 1 pfet_01v8 L=5.8e-07 W=1.5e-06 $X=125270 $Y=84670 $dt=16
M4617 1 3 1 1 pfet_01v8 L=5.8e-07 W=1.5e-06 $X=125270 $Y=92950 $dt=16
M4618 1 3 1 1 pfet_01v8 L=5.8e-07 W=1.5e-06 $X=125270 $Y=101230 $dt=16
M4619 346 225 324 1 pfet_01v8 L=1.5e-07 W=1.5e-06 $X=125270 $Y=109510 $dt=16
M4620 347 226 324 1 pfet_01v8 L=1.5e-07 W=1.5e-06 $X=125270 $Y=117790 $dt=16
M4621 348 227 324 1 pfet_01v8 L=1.5e-07 W=1.5e-06 $X=125270 $Y=126070 $dt=16
M4622 349 228 324 1 pfet_01v8 L=1.5e-07 W=1.5e-06 $X=125270 $Y=134350 $dt=16
M4623 350 229 324 1 pfet_01v8 L=1.5e-07 W=1.5e-06 $X=125270 $Y=142630 $dt=16
M4624 351 230 324 1 pfet_01v8 L=1.5e-07 W=1.5e-06 $X=125270 $Y=150910 $dt=16
M4625 352 231 324 1 pfet_01v8 L=1.5e-07 W=1.5e-06 $X=125270 $Y=159190 $dt=16
M4626 309 289 339 1 pfet_01v8 L=1.5e-07 W=1.5e-06 $X=125700 $Y=10150 $dt=16
M4627 309 290 340 1 pfet_01v8 L=1.5e-07 W=1.5e-06 $X=125700 $Y=18430 $dt=16
M4628 309 291 341 1 pfet_01v8 L=1.5e-07 W=1.5e-06 $X=125700 $Y=26710 $dt=16
M4629 309 292 342 1 pfet_01v8 L=1.5e-07 W=1.5e-06 $X=125700 $Y=34990 $dt=16
M4630 309 293 343 1 pfet_01v8 L=1.5e-07 W=1.5e-06 $X=125700 $Y=43270 $dt=16
M4631 309 294 344 1 pfet_01v8 L=1.5e-07 W=1.5e-06 $X=125700 $Y=51550 $dt=16
M4632 309 295 345 1 pfet_01v8 L=1.5e-07 W=1.5e-06 $X=125700 $Y=59830 $dt=16
M4633 309 301 346 1 pfet_01v8 L=1.5e-07 W=1.5e-06 $X=125700 $Y=109510 $dt=16
M4634 309 302 347 1 pfet_01v8 L=1.5e-07 W=1.5e-06 $X=125700 $Y=117790 $dt=16
M4635 309 303 348 1 pfet_01v8 L=1.5e-07 W=1.5e-06 $X=125700 $Y=126070 $dt=16
M4636 309 304 349 1 pfet_01v8 L=1.5e-07 W=1.5e-06 $X=125700 $Y=134350 $dt=16
M4637 309 305 350 1 pfet_01v8 L=1.5e-07 W=1.5e-06 $X=125700 $Y=142630 $dt=16
M4638 309 306 351 1 pfet_01v8 L=1.5e-07 W=1.5e-06 $X=125700 $Y=150910 $dt=16
M4639 309 307 352 1 pfet_01v8 L=1.5e-07 W=1.5e-06 $X=125700 $Y=159190 $dt=16
M4640 1 3 1 1 pfet_01v8 L=5.8e-07 W=1.5e-06 $X=131390 $Y=68110 $dt=16
M4641 1 3 1 1 pfet_01v8 L=5.8e-07 W=1.5e-06 $X=131390 $Y=76390 $dt=16
M4642 1 3 1 1 pfet_01v8 L=5.8e-07 W=1.5e-06 $X=131390 $Y=84670 $dt=16
M4643 1 3 1 1 pfet_01v8 L=5.8e-07 W=1.5e-06 $X=131390 $Y=92950 $dt=16
M4644 1 3 1 1 pfet_01v8 L=5.8e-07 W=1.5e-06 $X=131390 $Y=101230 $dt=16
M4645 339 270 339 1 pfet_01v8 L=1.5e-07 W=1.5e-06 $X=131400 $Y=10150 $dt=16
M4646 340 271 340 1 pfet_01v8 L=1.5e-07 W=1.5e-06 $X=131400 $Y=18430 $dt=16
M4647 341 272 341 1 pfet_01v8 L=1.5e-07 W=1.5e-06 $X=131400 $Y=26710 $dt=16
M4648 342 273 342 1 pfet_01v8 L=1.5e-07 W=1.5e-06 $X=131400 $Y=34990 $dt=16
M4649 343 274 343 1 pfet_01v8 L=1.5e-07 W=1.5e-06 $X=131400 $Y=43270 $dt=16
M4650 344 275 344 1 pfet_01v8 L=1.5e-07 W=1.5e-06 $X=131400 $Y=51550 $dt=16
M4651 345 276 345 1 pfet_01v8 L=1.5e-07 W=1.5e-06 $X=131400 $Y=59830 $dt=16
M4652 346 282 346 1 pfet_01v8 L=1.5e-07 W=1.5e-06 $X=131400 $Y=109510 $dt=16
M4653 347 283 347 1 pfet_01v8 L=1.5e-07 W=1.5e-06 $X=131400 $Y=117790 $dt=16
M4654 348 284 348 1 pfet_01v8 L=1.5e-07 W=1.5e-06 $X=131400 $Y=126070 $dt=16
M4655 349 285 349 1 pfet_01v8 L=1.5e-07 W=1.5e-06 $X=131400 $Y=134350 $dt=16
M4656 350 286 350 1 pfet_01v8 L=1.5e-07 W=1.5e-06 $X=131400 $Y=142630 $dt=16
M4657 351 287 351 1 pfet_01v8 L=1.5e-07 W=1.5e-06 $X=131400 $Y=150910 $dt=16
M4658 352 288 352 1 pfet_01v8 L=1.5e-07 W=1.5e-06 $X=131400 $Y=159190 $dt=16
M4659 308 175 339 1 pfet_01v8 L=1.5e-07 W=1.5e-06 $X=131830 $Y=10150 $dt=16
M4660 308 176 340 1 pfet_01v8 L=1.5e-07 W=1.5e-06 $X=131830 $Y=18430 $dt=16
M4661 308 177 341 1 pfet_01v8 L=1.5e-07 W=1.5e-06 $X=131830 $Y=26710 $dt=16
M4662 308 178 342 1 pfet_01v8 L=1.5e-07 W=1.5e-06 $X=131830 $Y=34990 $dt=16
M4663 308 179 343 1 pfet_01v8 L=1.5e-07 W=1.5e-06 $X=131830 $Y=43270 $dt=16
M4664 308 180 344 1 pfet_01v8 L=1.5e-07 W=1.5e-06 $X=131830 $Y=51550 $dt=16
M4665 308 181 345 1 pfet_01v8 L=1.5e-07 W=1.5e-06 $X=131830 $Y=59830 $dt=16
M4666 308 187 346 1 pfet_01v8 L=1.5e-07 W=1.5e-06 $X=131830 $Y=109510 $dt=16
M4667 308 188 347 1 pfet_01v8 L=1.5e-07 W=1.5e-06 $X=131830 $Y=117790 $dt=16
M4668 308 189 348 1 pfet_01v8 L=1.5e-07 W=1.5e-06 $X=131830 $Y=126070 $dt=16
M4669 308 190 349 1 pfet_01v8 L=1.5e-07 W=1.5e-06 $X=131830 $Y=134350 $dt=16
M4670 308 191 350 1 pfet_01v8 L=1.5e-07 W=1.5e-06 $X=131830 $Y=142630 $dt=16
M4671 308 192 351 1 pfet_01v8 L=1.5e-07 W=1.5e-06 $X=131830 $Y=150910 $dt=16
M4672 308 193 352 1 pfet_01v8 L=1.5e-07 W=1.5e-06 $X=131830 $Y=159190 $dt=16
M4673 325 213 324 1 pfet_01v8 L=1.5e-07 W=1.5e-06 $X=133550 $Y=10150 $dt=16
M4674 326 214 324 1 pfet_01v8 L=1.5e-07 W=1.5e-06 $X=133550 $Y=18430 $dt=16
M4675 327 215 324 1 pfet_01v8 L=1.5e-07 W=1.5e-06 $X=133550 $Y=26710 $dt=16
M4676 328 216 324 1 pfet_01v8 L=1.5e-07 W=1.5e-06 $X=133550 $Y=34990 $dt=16
M4677 329 217 324 1 pfet_01v8 L=1.5e-07 W=1.5e-06 $X=133550 $Y=43270 $dt=16
M4678 330 218 324 1 pfet_01v8 L=1.5e-07 W=1.5e-06 $X=133550 $Y=51550 $dt=16
M4679 331 219 324 1 pfet_01v8 L=1.5e-07 W=1.5e-06 $X=133550 $Y=59830 $dt=16
M4680 1 3 1 1 pfet_01v8 L=5.8e-07 W=1.5e-06 $X=133550 $Y=68110 $dt=16
M4681 1 3 1 1 pfet_01v8 L=5.8e-07 W=1.5e-06 $X=133550 $Y=76390 $dt=16
M4682 1 3 1 1 pfet_01v8 L=5.8e-07 W=1.5e-06 $X=133550 $Y=84670 $dt=16
M4683 1 3 1 1 pfet_01v8 L=5.8e-07 W=1.5e-06 $X=133550 $Y=92950 $dt=16
M4684 1 3 1 1 pfet_01v8 L=5.8e-07 W=1.5e-06 $X=133550 $Y=101230 $dt=16
M4685 332 225 324 1 pfet_01v8 L=1.5e-07 W=1.5e-06 $X=133550 $Y=109510 $dt=16
M4686 333 226 324 1 pfet_01v8 L=1.5e-07 W=1.5e-06 $X=133550 $Y=117790 $dt=16
M4687 334 227 324 1 pfet_01v8 L=1.5e-07 W=1.5e-06 $X=133550 $Y=126070 $dt=16
M4688 335 228 324 1 pfet_01v8 L=1.5e-07 W=1.5e-06 $X=133550 $Y=134350 $dt=16
M4689 336 229 324 1 pfet_01v8 L=1.5e-07 W=1.5e-06 $X=133550 $Y=142630 $dt=16
M4690 337 230 324 1 pfet_01v8 L=1.5e-07 W=1.5e-06 $X=133550 $Y=150910 $dt=16
M4691 338 231 324 1 pfet_01v8 L=1.5e-07 W=1.5e-06 $X=133550 $Y=159190 $dt=16
M4692 309 289 325 1 pfet_01v8 L=1.5e-07 W=1.5e-06 $X=133980 $Y=10150 $dt=16
M4693 309 290 326 1 pfet_01v8 L=1.5e-07 W=1.5e-06 $X=133980 $Y=18430 $dt=16
M4694 309 291 327 1 pfet_01v8 L=1.5e-07 W=1.5e-06 $X=133980 $Y=26710 $dt=16
M4695 309 292 328 1 pfet_01v8 L=1.5e-07 W=1.5e-06 $X=133980 $Y=34990 $dt=16
M4696 309 293 329 1 pfet_01v8 L=1.5e-07 W=1.5e-06 $X=133980 $Y=43270 $dt=16
M4697 309 294 330 1 pfet_01v8 L=1.5e-07 W=1.5e-06 $X=133980 $Y=51550 $dt=16
M4698 309 295 331 1 pfet_01v8 L=1.5e-07 W=1.5e-06 $X=133980 $Y=59830 $dt=16
M4699 309 301 332 1 pfet_01v8 L=1.5e-07 W=1.5e-06 $X=133980 $Y=109510 $dt=16
M4700 309 302 333 1 pfet_01v8 L=1.5e-07 W=1.5e-06 $X=133980 $Y=117790 $dt=16
M4701 309 303 334 1 pfet_01v8 L=1.5e-07 W=1.5e-06 $X=133980 $Y=126070 $dt=16
M4702 309 304 335 1 pfet_01v8 L=1.5e-07 W=1.5e-06 $X=133980 $Y=134350 $dt=16
M4703 309 305 336 1 pfet_01v8 L=1.5e-07 W=1.5e-06 $X=133980 $Y=142630 $dt=16
M4704 309 306 337 1 pfet_01v8 L=1.5e-07 W=1.5e-06 $X=133980 $Y=150910 $dt=16
M4705 309 307 338 1 pfet_01v8 L=1.5e-07 W=1.5e-06 $X=133980 $Y=159190 $dt=16
M4706 1 3 1 1 pfet_01v8 L=5.8e-07 W=1.5e-06 $X=139670 $Y=68110 $dt=16
M4707 1 3 1 1 pfet_01v8 L=5.8e-07 W=1.5e-06 $X=139670 $Y=76390 $dt=16
M4708 1 3 1 1 pfet_01v8 L=5.8e-07 W=1.5e-06 $X=139670 $Y=84670 $dt=16
M4709 1 3 1 1 pfet_01v8 L=5.8e-07 W=1.5e-06 $X=139670 $Y=92950 $dt=16
M4710 1 3 1 1 pfet_01v8 L=5.8e-07 W=1.5e-06 $X=139670 $Y=101230 $dt=16
M4711 325 270 325 1 pfet_01v8 L=1.5e-07 W=1.5e-06 $X=139680 $Y=10150 $dt=16
M4712 326 271 326 1 pfet_01v8 L=1.5e-07 W=1.5e-06 $X=139680 $Y=18430 $dt=16
M4713 327 272 327 1 pfet_01v8 L=1.5e-07 W=1.5e-06 $X=139680 $Y=26710 $dt=16
M4714 328 273 328 1 pfet_01v8 L=1.5e-07 W=1.5e-06 $X=139680 $Y=34990 $dt=16
M4715 329 274 329 1 pfet_01v8 L=1.5e-07 W=1.5e-06 $X=139680 $Y=43270 $dt=16
M4716 330 275 330 1 pfet_01v8 L=1.5e-07 W=1.5e-06 $X=139680 $Y=51550 $dt=16
M4717 331 276 331 1 pfet_01v8 L=1.5e-07 W=1.5e-06 $X=139680 $Y=59830 $dt=16
M4718 332 282 332 1 pfet_01v8 L=1.5e-07 W=1.5e-06 $X=139680 $Y=109510 $dt=16
M4719 333 283 333 1 pfet_01v8 L=1.5e-07 W=1.5e-06 $X=139680 $Y=117790 $dt=16
M4720 334 284 334 1 pfet_01v8 L=1.5e-07 W=1.5e-06 $X=139680 $Y=126070 $dt=16
M4721 335 285 335 1 pfet_01v8 L=1.5e-07 W=1.5e-06 $X=139680 $Y=134350 $dt=16
M4722 336 286 336 1 pfet_01v8 L=1.5e-07 W=1.5e-06 $X=139680 $Y=142630 $dt=16
M4723 337 287 337 1 pfet_01v8 L=1.5e-07 W=1.5e-06 $X=139680 $Y=150910 $dt=16
M4724 338 288 338 1 pfet_01v8 L=1.5e-07 W=1.5e-06 $X=139680 $Y=159190 $dt=16
M4725 308 175 325 1 pfet_01v8 L=1.5e-07 W=1.5e-06 $X=140110 $Y=10150 $dt=16
M4726 308 176 326 1 pfet_01v8 L=1.5e-07 W=1.5e-06 $X=140110 $Y=18430 $dt=16
M4727 308 177 327 1 pfet_01v8 L=1.5e-07 W=1.5e-06 $X=140110 $Y=26710 $dt=16
M4728 308 178 328 1 pfet_01v8 L=1.5e-07 W=1.5e-06 $X=140110 $Y=34990 $dt=16
M4729 308 179 329 1 pfet_01v8 L=1.5e-07 W=1.5e-06 $X=140110 $Y=43270 $dt=16
M4730 308 180 330 1 pfet_01v8 L=1.5e-07 W=1.5e-06 $X=140110 $Y=51550 $dt=16
M4731 308 181 331 1 pfet_01v8 L=1.5e-07 W=1.5e-06 $X=140110 $Y=59830 $dt=16
M4732 308 187 332 1 pfet_01v8 L=1.5e-07 W=1.5e-06 $X=140110 $Y=109510 $dt=16
M4733 308 188 333 1 pfet_01v8 L=1.5e-07 W=1.5e-06 $X=140110 $Y=117790 $dt=16
M4734 308 189 334 1 pfet_01v8 L=1.5e-07 W=1.5e-06 $X=140110 $Y=126070 $dt=16
M4735 308 190 335 1 pfet_01v8 L=1.5e-07 W=1.5e-06 $X=140110 $Y=134350 $dt=16
M4736 308 191 336 1 pfet_01v8 L=1.5e-07 W=1.5e-06 $X=140110 $Y=142630 $dt=16
M4737 308 192 337 1 pfet_01v8 L=1.5e-07 W=1.5e-06 $X=140110 $Y=150910 $dt=16
M4738 308 193 338 1 pfet_01v8 L=1.5e-07 W=1.5e-06 $X=140110 $Y=159190 $dt=16
M4739 310 213 324 1 pfet_01v8 L=1.5e-07 W=1.5e-06 $X=141830 $Y=10150 $dt=16
M4740 311 214 324 1 pfet_01v8 L=1.5e-07 W=1.5e-06 $X=141830 $Y=18430 $dt=16
M4741 312 215 324 1 pfet_01v8 L=1.5e-07 W=1.5e-06 $X=141830 $Y=26710 $dt=16
M4742 313 216 324 1 pfet_01v8 L=1.5e-07 W=1.5e-06 $X=141830 $Y=34990 $dt=16
M4743 314 217 324 1 pfet_01v8 L=1.5e-07 W=1.5e-06 $X=141830 $Y=43270 $dt=16
M4744 315 218 324 1 pfet_01v8 L=1.5e-07 W=1.5e-06 $X=141830 $Y=51550 $dt=16
M4745 316 219 324 1 pfet_01v8 L=1.5e-07 W=1.5e-06 $X=141830 $Y=59830 $dt=16
M4746 1 3 1 1 pfet_01v8 L=5.8e-07 W=1.5e-06 $X=141830 $Y=68110 $dt=16
M4747 1 3 1 1 pfet_01v8 L=5.8e-07 W=1.5e-06 $X=141830 $Y=76390 $dt=16
M4748 1 3 1 1 pfet_01v8 L=5.8e-07 W=1.5e-06 $X=141830 $Y=84670 $dt=16
M4749 1 3 1 1 pfet_01v8 L=5.8e-07 W=1.5e-06 $X=141830 $Y=92950 $dt=16
M4750 1 3 1 1 pfet_01v8 L=5.8e-07 W=1.5e-06 $X=141830 $Y=101230 $dt=16
M4751 317 225 324 1 pfet_01v8 L=1.5e-07 W=1.5e-06 $X=141830 $Y=109510 $dt=16
M4752 318 226 324 1 pfet_01v8 L=1.5e-07 W=1.5e-06 $X=141830 $Y=117790 $dt=16
M4753 319 227 324 1 pfet_01v8 L=1.5e-07 W=1.5e-06 $X=141830 $Y=126070 $dt=16
M4754 320 228 324 1 pfet_01v8 L=1.5e-07 W=1.5e-06 $X=141830 $Y=134350 $dt=16
M4755 321 229 324 1 pfet_01v8 L=1.5e-07 W=1.5e-06 $X=141830 $Y=142630 $dt=16
M4756 322 230 324 1 pfet_01v8 L=1.5e-07 W=1.5e-06 $X=141830 $Y=150910 $dt=16
M4757 323 231 324 1 pfet_01v8 L=1.5e-07 W=1.5e-06 $X=141830 $Y=159190 $dt=16
M4758 309 289 310 1 pfet_01v8 L=1.5e-07 W=1.5e-06 $X=142260 $Y=10150 $dt=16
M4759 309 290 311 1 pfet_01v8 L=1.5e-07 W=1.5e-06 $X=142260 $Y=18430 $dt=16
M4760 309 291 312 1 pfet_01v8 L=1.5e-07 W=1.5e-06 $X=142260 $Y=26710 $dt=16
M4761 309 292 313 1 pfet_01v8 L=1.5e-07 W=1.5e-06 $X=142260 $Y=34990 $dt=16
M4762 309 293 314 1 pfet_01v8 L=1.5e-07 W=1.5e-06 $X=142260 $Y=43270 $dt=16
M4763 309 294 315 1 pfet_01v8 L=1.5e-07 W=1.5e-06 $X=142260 $Y=51550 $dt=16
M4764 309 295 316 1 pfet_01v8 L=1.5e-07 W=1.5e-06 $X=142260 $Y=59830 $dt=16
M4765 309 301 317 1 pfet_01v8 L=1.5e-07 W=1.5e-06 $X=142260 $Y=109510 $dt=16
M4766 309 302 318 1 pfet_01v8 L=1.5e-07 W=1.5e-06 $X=142260 $Y=117790 $dt=16
M4767 309 303 319 1 pfet_01v8 L=1.5e-07 W=1.5e-06 $X=142260 $Y=126070 $dt=16
M4768 309 304 320 1 pfet_01v8 L=1.5e-07 W=1.5e-06 $X=142260 $Y=134350 $dt=16
M4769 309 305 321 1 pfet_01v8 L=1.5e-07 W=1.5e-06 $X=142260 $Y=142630 $dt=16
M4770 309 306 322 1 pfet_01v8 L=1.5e-07 W=1.5e-06 $X=142260 $Y=150910 $dt=16
M4771 309 307 323 1 pfet_01v8 L=1.5e-07 W=1.5e-06 $X=142260 $Y=159190 $dt=16
M4772 1 3 1 1 pfet_01v8 L=5.8e-07 W=1.5e-06 $X=147950 $Y=68110 $dt=16
M4773 1 3 1 1 pfet_01v8 L=5.8e-07 W=1.5e-06 $X=147950 $Y=76390 $dt=16
M4774 1 3 1 1 pfet_01v8 L=5.8e-07 W=1.5e-06 $X=147950 $Y=84670 $dt=16
M4775 1 3 1 1 pfet_01v8 L=5.8e-07 W=1.5e-06 $X=147950 $Y=92950 $dt=16
M4776 1 3 1 1 pfet_01v8 L=5.8e-07 W=1.5e-06 $X=147950 $Y=101230 $dt=16
M4777 310 270 310 1 pfet_01v8 L=1.5e-07 W=1.5e-06 $X=147960 $Y=10150 $dt=16
M4778 311 271 311 1 pfet_01v8 L=1.5e-07 W=1.5e-06 $X=147960 $Y=18430 $dt=16
M4779 312 272 312 1 pfet_01v8 L=1.5e-07 W=1.5e-06 $X=147960 $Y=26710 $dt=16
M4780 313 273 313 1 pfet_01v8 L=1.5e-07 W=1.5e-06 $X=147960 $Y=34990 $dt=16
M4781 314 274 314 1 pfet_01v8 L=1.5e-07 W=1.5e-06 $X=147960 $Y=43270 $dt=16
M4782 315 275 315 1 pfet_01v8 L=1.5e-07 W=1.5e-06 $X=147960 $Y=51550 $dt=16
M4783 316 276 316 1 pfet_01v8 L=1.5e-07 W=1.5e-06 $X=147960 $Y=59830 $dt=16
M4784 317 282 317 1 pfet_01v8 L=1.5e-07 W=1.5e-06 $X=147960 $Y=109510 $dt=16
M4785 318 283 318 1 pfet_01v8 L=1.5e-07 W=1.5e-06 $X=147960 $Y=117790 $dt=16
M4786 319 284 319 1 pfet_01v8 L=1.5e-07 W=1.5e-06 $X=147960 $Y=126070 $dt=16
M4787 320 285 320 1 pfet_01v8 L=1.5e-07 W=1.5e-06 $X=147960 $Y=134350 $dt=16
M4788 321 286 321 1 pfet_01v8 L=1.5e-07 W=1.5e-06 $X=147960 $Y=142630 $dt=16
M4789 322 287 322 1 pfet_01v8 L=1.5e-07 W=1.5e-06 $X=147960 $Y=150910 $dt=16
M4790 323 288 323 1 pfet_01v8 L=1.5e-07 W=1.5e-06 $X=147960 $Y=159190 $dt=16
M4791 308 175 310 1 pfet_01v8 L=1.5e-07 W=1.5e-06 $X=148390 $Y=10150 $dt=16
M4792 308 176 311 1 pfet_01v8 L=1.5e-07 W=1.5e-06 $X=148390 $Y=18430 $dt=16
M4793 308 177 312 1 pfet_01v8 L=1.5e-07 W=1.5e-06 $X=148390 $Y=26710 $dt=16
M4794 308 178 313 1 pfet_01v8 L=1.5e-07 W=1.5e-06 $X=148390 $Y=34990 $dt=16
M4795 308 179 314 1 pfet_01v8 L=1.5e-07 W=1.5e-06 $X=148390 $Y=43270 $dt=16
M4796 308 180 315 1 pfet_01v8 L=1.5e-07 W=1.5e-06 $X=148390 $Y=51550 $dt=16
M4797 308 181 316 1 pfet_01v8 L=1.5e-07 W=1.5e-06 $X=148390 $Y=59830 $dt=16
M4798 308 187 317 1 pfet_01v8 L=1.5e-07 W=1.5e-06 $X=148390 $Y=109510 $dt=16
M4799 308 188 318 1 pfet_01v8 L=1.5e-07 W=1.5e-06 $X=148390 $Y=117790 $dt=16
M4800 308 189 319 1 pfet_01v8 L=1.5e-07 W=1.5e-06 $X=148390 $Y=126070 $dt=16
M4801 308 190 320 1 pfet_01v8 L=1.5e-07 W=1.5e-06 $X=148390 $Y=134350 $dt=16
M4802 308 191 321 1 pfet_01v8 L=1.5e-07 W=1.5e-06 $X=148390 $Y=142630 $dt=16
M4803 308 192 322 1 pfet_01v8 L=1.5e-07 W=1.5e-06 $X=148390 $Y=150910 $dt=16
M4804 308 193 323 1 pfet_01v8 L=1.5e-07 W=1.5e-06 $X=148390 $Y=159190 $dt=16
M4805 289 118 1 1 pfet_01v8 L=1.5e-07 W=1.13e-06 $X=150530 $Y=8870 $dt=16
M4806 290 119 1 1 pfet_01v8 L=1.5e-07 W=1.13e-06 $X=150530 $Y=17150 $dt=16
M4807 291 120 1 1 pfet_01v8 L=1.5e-07 W=1.13e-06 $X=150530 $Y=25430 $dt=16
M4808 292 121 1 1 pfet_01v8 L=1.5e-07 W=1.13e-06 $X=150530 $Y=33710 $dt=16
M4809 293 122 1 1 pfet_01v8 L=1.5e-07 W=1.13e-06 $X=150530 $Y=41990 $dt=16
M4810 294 123 1 1 pfet_01v8 L=1.5e-07 W=1.13e-06 $X=150530 $Y=50270 $dt=16
M4811 295 124 1 1 pfet_01v8 L=1.5e-07 W=1.13e-06 $X=150530 $Y=58550 $dt=16
M4812 296 125 1 1 pfet_01v8 L=1.5e-07 W=1.13e-06 $X=150530 $Y=66830 $dt=16
M4813 297 126 1 1 pfet_01v8 L=1.5e-07 W=1.13e-06 $X=150530 $Y=75110 $dt=16
M4814 298 127 1 1 pfet_01v8 L=1.5e-07 W=1.13e-06 $X=150530 $Y=83390 $dt=16
M4815 299 128 1 1 pfet_01v8 L=1.5e-07 W=1.13e-06 $X=150530 $Y=91670 $dt=16
M4816 300 129 1 1 pfet_01v8 L=1.5e-07 W=1.13e-06 $X=150530 $Y=99950 $dt=16
M4817 301 130 1 1 pfet_01v8 L=1.5e-07 W=1.13e-06 $X=150530 $Y=108230 $dt=16
M4818 302 131 1 1 pfet_01v8 L=1.5e-07 W=1.13e-06 $X=150530 $Y=116510 $dt=16
M4819 303 132 1 1 pfet_01v8 L=1.5e-07 W=1.13e-06 $X=150530 $Y=124790 $dt=16
M4820 304 133 1 1 pfet_01v8 L=1.5e-07 W=1.13e-06 $X=150530 $Y=133070 $dt=16
M4821 305 134 1 1 pfet_01v8 L=1.5e-07 W=1.13e-06 $X=150530 $Y=141350 $dt=16
M4822 306 135 1 1 pfet_01v8 L=1.5e-07 W=1.13e-06 $X=150530 $Y=149630 $dt=16
M4823 307 136 1 1 pfet_01v8 L=1.5e-07 W=1.13e-06 $X=150530 $Y=157910 $dt=16
M4824 270 251 1 1 pfet_01v8 L=1.5e-07 W=1.13e-06 $X=150590 $Y=14840 $dt=16
M4825 271 252 1 1 pfet_01v8 L=1.5e-07 W=1.13e-06 $X=150590 $Y=23120 $dt=16
M4826 272 253 1 1 pfet_01v8 L=1.5e-07 W=1.13e-06 $X=150590 $Y=31400 $dt=16
M4827 273 254 1 1 pfet_01v8 L=1.5e-07 W=1.13e-06 $X=150590 $Y=39680 $dt=16
M4828 274 255 1 1 pfet_01v8 L=1.5e-07 W=1.13e-06 $X=150590 $Y=47960 $dt=16
M4829 275 256 1 1 pfet_01v8 L=1.5e-07 W=1.13e-06 $X=150590 $Y=56240 $dt=16
M4830 276 257 1 1 pfet_01v8 L=1.5e-07 W=1.13e-06 $X=150590 $Y=64520 $dt=16
M4831 277 258 1 1 pfet_01v8 L=1.5e-07 W=1.13e-06 $X=150590 $Y=72800 $dt=16
M4832 278 259 1 1 pfet_01v8 L=1.5e-07 W=1.13e-06 $X=150590 $Y=81080 $dt=16
M4833 279 260 1 1 pfet_01v8 L=1.5e-07 W=1.13e-06 $X=150590 $Y=89360 $dt=16
M4834 280 261 1 1 pfet_01v8 L=1.5e-07 W=1.13e-06 $X=150590 $Y=97640 $dt=16
M4835 281 262 1 1 pfet_01v8 L=1.5e-07 W=1.13e-06 $X=150590 $Y=105920 $dt=16
M4836 282 263 1 1 pfet_01v8 L=1.5e-07 W=1.13e-06 $X=150590 $Y=114200 $dt=16
M4837 283 264 1 1 pfet_01v8 L=1.5e-07 W=1.13e-06 $X=150590 $Y=122480 $dt=16
M4838 284 265 1 1 pfet_01v8 L=1.5e-07 W=1.13e-06 $X=150590 $Y=130760 $dt=16
M4839 285 266 1 1 pfet_01v8 L=1.5e-07 W=1.13e-06 $X=150590 $Y=139040 $dt=16
M4840 286 267 1 1 pfet_01v8 L=1.5e-07 W=1.13e-06 $X=150590 $Y=147320 $dt=16
M4841 287 268 1 1 pfet_01v8 L=1.5e-07 W=1.13e-06 $X=150590 $Y=155600 $dt=16
M4842 288 269 1 1 pfet_01v8 L=1.5e-07 W=1.13e-06 $X=150590 $Y=163880 $dt=16
M4843 1 118 289 1 pfet_01v8 L=1.5e-07 W=1.13e-06 $X=150960 $Y=8870 $dt=16
M4844 1 119 290 1 pfet_01v8 L=1.5e-07 W=1.13e-06 $X=150960 $Y=17150 $dt=16
M4845 1 120 291 1 pfet_01v8 L=1.5e-07 W=1.13e-06 $X=150960 $Y=25430 $dt=16
M4846 1 121 292 1 pfet_01v8 L=1.5e-07 W=1.13e-06 $X=150960 $Y=33710 $dt=16
M4847 1 122 293 1 pfet_01v8 L=1.5e-07 W=1.13e-06 $X=150960 $Y=41990 $dt=16
M4848 1 123 294 1 pfet_01v8 L=1.5e-07 W=1.13e-06 $X=150960 $Y=50270 $dt=16
M4849 1 124 295 1 pfet_01v8 L=1.5e-07 W=1.13e-06 $X=150960 $Y=58550 $dt=16
M4850 1 125 296 1 pfet_01v8 L=1.5e-07 W=1.13e-06 $X=150960 $Y=66830 $dt=16
M4851 1 126 297 1 pfet_01v8 L=1.5e-07 W=1.13e-06 $X=150960 $Y=75110 $dt=16
M4852 1 127 298 1 pfet_01v8 L=1.5e-07 W=1.13e-06 $X=150960 $Y=83390 $dt=16
M4853 1 128 299 1 pfet_01v8 L=1.5e-07 W=1.13e-06 $X=150960 $Y=91670 $dt=16
M4854 1 129 300 1 pfet_01v8 L=1.5e-07 W=1.13e-06 $X=150960 $Y=99950 $dt=16
M4855 1 130 301 1 pfet_01v8 L=1.5e-07 W=1.13e-06 $X=150960 $Y=108230 $dt=16
M4856 1 131 302 1 pfet_01v8 L=1.5e-07 W=1.13e-06 $X=150960 $Y=116510 $dt=16
M4857 1 132 303 1 pfet_01v8 L=1.5e-07 W=1.13e-06 $X=150960 $Y=124790 $dt=16
M4858 1 133 304 1 pfet_01v8 L=1.5e-07 W=1.13e-06 $X=150960 $Y=133070 $dt=16
M4859 1 134 305 1 pfet_01v8 L=1.5e-07 W=1.13e-06 $X=150960 $Y=141350 $dt=16
M4860 1 135 306 1 pfet_01v8 L=1.5e-07 W=1.13e-06 $X=150960 $Y=149630 $dt=16
M4861 1 136 307 1 pfet_01v8 L=1.5e-07 W=1.13e-06 $X=150960 $Y=157910 $dt=16
M4862 1 251 270 1 pfet_01v8 L=1.5e-07 W=1.13e-06 $X=151020 $Y=14840 $dt=16
M4863 1 252 271 1 pfet_01v8 L=1.5e-07 W=1.13e-06 $X=151020 $Y=23120 $dt=16
M4864 1 253 272 1 pfet_01v8 L=1.5e-07 W=1.13e-06 $X=151020 $Y=31400 $dt=16
M4865 1 254 273 1 pfet_01v8 L=1.5e-07 W=1.13e-06 $X=151020 $Y=39680 $dt=16
M4866 1 255 274 1 pfet_01v8 L=1.5e-07 W=1.13e-06 $X=151020 $Y=47960 $dt=16
M4867 1 256 275 1 pfet_01v8 L=1.5e-07 W=1.13e-06 $X=151020 $Y=56240 $dt=16
M4868 1 257 276 1 pfet_01v8 L=1.5e-07 W=1.13e-06 $X=151020 $Y=64520 $dt=16
M4869 1 258 277 1 pfet_01v8 L=1.5e-07 W=1.13e-06 $X=151020 $Y=72800 $dt=16
M4870 1 259 278 1 pfet_01v8 L=1.5e-07 W=1.13e-06 $X=151020 $Y=81080 $dt=16
M4871 1 260 279 1 pfet_01v8 L=1.5e-07 W=1.13e-06 $X=151020 $Y=89360 $dt=16
M4872 1 261 280 1 pfet_01v8 L=1.5e-07 W=1.13e-06 $X=151020 $Y=97640 $dt=16
M4873 1 262 281 1 pfet_01v8 L=1.5e-07 W=1.13e-06 $X=151020 $Y=105920 $dt=16
M4874 1 263 282 1 pfet_01v8 L=1.5e-07 W=1.13e-06 $X=151020 $Y=114200 $dt=16
M4875 1 264 283 1 pfet_01v8 L=1.5e-07 W=1.13e-06 $X=151020 $Y=122480 $dt=16
M4876 1 265 284 1 pfet_01v8 L=1.5e-07 W=1.13e-06 $X=151020 $Y=130760 $dt=16
M4877 1 266 285 1 pfet_01v8 L=1.5e-07 W=1.13e-06 $X=151020 $Y=139040 $dt=16
M4878 1 267 286 1 pfet_01v8 L=1.5e-07 W=1.13e-06 $X=151020 $Y=147320 $dt=16
M4879 1 268 287 1 pfet_01v8 L=1.5e-07 W=1.13e-06 $X=151020 $Y=155600 $dt=16
M4880 1 269 288 1 pfet_01v8 L=1.5e-07 W=1.13e-06 $X=151020 $Y=163880 $dt=16
M4881 289 118 1 1 pfet_01v8 L=1.5e-07 W=1.13e-06 $X=151390 $Y=8870 $dt=16
M4882 290 119 1 1 pfet_01v8 L=1.5e-07 W=1.13e-06 $X=151390 $Y=17150 $dt=16
M4883 291 120 1 1 pfet_01v8 L=1.5e-07 W=1.13e-06 $X=151390 $Y=25430 $dt=16
M4884 292 121 1 1 pfet_01v8 L=1.5e-07 W=1.13e-06 $X=151390 $Y=33710 $dt=16
M4885 293 122 1 1 pfet_01v8 L=1.5e-07 W=1.13e-06 $X=151390 $Y=41990 $dt=16
M4886 294 123 1 1 pfet_01v8 L=1.5e-07 W=1.13e-06 $X=151390 $Y=50270 $dt=16
M4887 295 124 1 1 pfet_01v8 L=1.5e-07 W=1.13e-06 $X=151390 $Y=58550 $dt=16
M4888 296 125 1 1 pfet_01v8 L=1.5e-07 W=1.13e-06 $X=151390 $Y=66830 $dt=16
M4889 297 126 1 1 pfet_01v8 L=1.5e-07 W=1.13e-06 $X=151390 $Y=75110 $dt=16
M4890 298 127 1 1 pfet_01v8 L=1.5e-07 W=1.13e-06 $X=151390 $Y=83390 $dt=16
M4891 299 128 1 1 pfet_01v8 L=1.5e-07 W=1.13e-06 $X=151390 $Y=91670 $dt=16
M4892 300 129 1 1 pfet_01v8 L=1.5e-07 W=1.13e-06 $X=151390 $Y=99950 $dt=16
M4893 301 130 1 1 pfet_01v8 L=1.5e-07 W=1.13e-06 $X=151390 $Y=108230 $dt=16
M4894 302 131 1 1 pfet_01v8 L=1.5e-07 W=1.13e-06 $X=151390 $Y=116510 $dt=16
M4895 303 132 1 1 pfet_01v8 L=1.5e-07 W=1.13e-06 $X=151390 $Y=124790 $dt=16
M4896 304 133 1 1 pfet_01v8 L=1.5e-07 W=1.13e-06 $X=151390 $Y=133070 $dt=16
M4897 305 134 1 1 pfet_01v8 L=1.5e-07 W=1.13e-06 $X=151390 $Y=141350 $dt=16
M4898 306 135 1 1 pfet_01v8 L=1.5e-07 W=1.13e-06 $X=151390 $Y=149630 $dt=16
M4899 307 136 1 1 pfet_01v8 L=1.5e-07 W=1.13e-06 $X=151390 $Y=157910 $dt=16
M4900 270 251 1 1 pfet_01v8 L=1.5e-07 W=1.13e-06 $X=151450 $Y=14840 $dt=16
M4901 271 252 1 1 pfet_01v8 L=1.5e-07 W=1.13e-06 $X=151450 $Y=23120 $dt=16
M4902 272 253 1 1 pfet_01v8 L=1.5e-07 W=1.13e-06 $X=151450 $Y=31400 $dt=16
M4903 273 254 1 1 pfet_01v8 L=1.5e-07 W=1.13e-06 $X=151450 $Y=39680 $dt=16
M4904 274 255 1 1 pfet_01v8 L=1.5e-07 W=1.13e-06 $X=151450 $Y=47960 $dt=16
M4905 275 256 1 1 pfet_01v8 L=1.5e-07 W=1.13e-06 $X=151450 $Y=56240 $dt=16
M4906 276 257 1 1 pfet_01v8 L=1.5e-07 W=1.13e-06 $X=151450 $Y=64520 $dt=16
M4907 277 258 1 1 pfet_01v8 L=1.5e-07 W=1.13e-06 $X=151450 $Y=72800 $dt=16
M4908 278 259 1 1 pfet_01v8 L=1.5e-07 W=1.13e-06 $X=151450 $Y=81080 $dt=16
M4909 279 260 1 1 pfet_01v8 L=1.5e-07 W=1.13e-06 $X=151450 $Y=89360 $dt=16
M4910 280 261 1 1 pfet_01v8 L=1.5e-07 W=1.13e-06 $X=151450 $Y=97640 $dt=16
M4911 281 262 1 1 pfet_01v8 L=1.5e-07 W=1.13e-06 $X=151450 $Y=105920 $dt=16
M4912 282 263 1 1 pfet_01v8 L=1.5e-07 W=1.13e-06 $X=151450 $Y=114200 $dt=16
M4913 283 264 1 1 pfet_01v8 L=1.5e-07 W=1.13e-06 $X=151450 $Y=122480 $dt=16
M4914 284 265 1 1 pfet_01v8 L=1.5e-07 W=1.13e-06 $X=151450 $Y=130760 $dt=16
M4915 285 266 1 1 pfet_01v8 L=1.5e-07 W=1.13e-06 $X=151450 $Y=139040 $dt=16
M4916 286 267 1 1 pfet_01v8 L=1.5e-07 W=1.13e-06 $X=151450 $Y=147320 $dt=16
M4917 287 268 1 1 pfet_01v8 L=1.5e-07 W=1.13e-06 $X=151450 $Y=155600 $dt=16
M4918 288 269 1 1 pfet_01v8 L=1.5e-07 W=1.13e-06 $X=151450 $Y=163880 $dt=16
M4919 1 118 289 1 pfet_01v8 L=1.5e-07 W=1.13e-06 $X=151820 $Y=8870 $dt=16
M4920 1 119 290 1 pfet_01v8 L=1.5e-07 W=1.13e-06 $X=151820 $Y=17150 $dt=16
M4921 1 120 291 1 pfet_01v8 L=1.5e-07 W=1.13e-06 $X=151820 $Y=25430 $dt=16
M4922 1 121 292 1 pfet_01v8 L=1.5e-07 W=1.13e-06 $X=151820 $Y=33710 $dt=16
M4923 1 122 293 1 pfet_01v8 L=1.5e-07 W=1.13e-06 $X=151820 $Y=41990 $dt=16
M4924 1 123 294 1 pfet_01v8 L=1.5e-07 W=1.13e-06 $X=151820 $Y=50270 $dt=16
M4925 1 124 295 1 pfet_01v8 L=1.5e-07 W=1.13e-06 $X=151820 $Y=58550 $dt=16
M4926 1 125 296 1 pfet_01v8 L=1.5e-07 W=1.13e-06 $X=151820 $Y=66830 $dt=16
M4927 1 126 297 1 pfet_01v8 L=1.5e-07 W=1.13e-06 $X=151820 $Y=75110 $dt=16
M4928 1 127 298 1 pfet_01v8 L=1.5e-07 W=1.13e-06 $X=151820 $Y=83390 $dt=16
M4929 1 128 299 1 pfet_01v8 L=1.5e-07 W=1.13e-06 $X=151820 $Y=91670 $dt=16
M4930 1 129 300 1 pfet_01v8 L=1.5e-07 W=1.13e-06 $X=151820 $Y=99950 $dt=16
M4931 1 130 301 1 pfet_01v8 L=1.5e-07 W=1.13e-06 $X=151820 $Y=108230 $dt=16
M4932 1 131 302 1 pfet_01v8 L=1.5e-07 W=1.13e-06 $X=151820 $Y=116510 $dt=16
M4933 1 132 303 1 pfet_01v8 L=1.5e-07 W=1.13e-06 $X=151820 $Y=124790 $dt=16
M4934 1 133 304 1 pfet_01v8 L=1.5e-07 W=1.13e-06 $X=151820 $Y=133070 $dt=16
M4935 1 134 305 1 pfet_01v8 L=1.5e-07 W=1.13e-06 $X=151820 $Y=141350 $dt=16
M4936 1 135 306 1 pfet_01v8 L=1.5e-07 W=1.13e-06 $X=151820 $Y=149630 $dt=16
M4937 1 136 307 1 pfet_01v8 L=1.5e-07 W=1.13e-06 $X=151820 $Y=157910 $dt=16
M4938 1 251 270 1 pfet_01v8 L=1.5e-07 W=1.13e-06 $X=151880 $Y=14840 $dt=16
M4939 1 252 271 1 pfet_01v8 L=1.5e-07 W=1.13e-06 $X=151880 $Y=23120 $dt=16
M4940 1 253 272 1 pfet_01v8 L=1.5e-07 W=1.13e-06 $X=151880 $Y=31400 $dt=16
M4941 1 254 273 1 pfet_01v8 L=1.5e-07 W=1.13e-06 $X=151880 $Y=39680 $dt=16
M4942 1 255 274 1 pfet_01v8 L=1.5e-07 W=1.13e-06 $X=151880 $Y=47960 $dt=16
M4943 1 256 275 1 pfet_01v8 L=1.5e-07 W=1.13e-06 $X=151880 $Y=56240 $dt=16
M4944 1 257 276 1 pfet_01v8 L=1.5e-07 W=1.13e-06 $X=151880 $Y=64520 $dt=16
M4945 1 258 277 1 pfet_01v8 L=1.5e-07 W=1.13e-06 $X=151880 $Y=72800 $dt=16
M4946 1 259 278 1 pfet_01v8 L=1.5e-07 W=1.13e-06 $X=151880 $Y=81080 $dt=16
M4947 1 260 279 1 pfet_01v8 L=1.5e-07 W=1.13e-06 $X=151880 $Y=89360 $dt=16
M4948 1 261 280 1 pfet_01v8 L=1.5e-07 W=1.13e-06 $X=151880 $Y=97640 $dt=16
M4949 1 262 281 1 pfet_01v8 L=1.5e-07 W=1.13e-06 $X=151880 $Y=105920 $dt=16
M4950 1 263 282 1 pfet_01v8 L=1.5e-07 W=1.13e-06 $X=151880 $Y=114200 $dt=16
M4951 1 264 283 1 pfet_01v8 L=1.5e-07 W=1.13e-06 $X=151880 $Y=122480 $dt=16
M4952 1 265 284 1 pfet_01v8 L=1.5e-07 W=1.13e-06 $X=151880 $Y=130760 $dt=16
M4953 1 266 285 1 pfet_01v8 L=1.5e-07 W=1.13e-06 $X=151880 $Y=139040 $dt=16
M4954 1 267 286 1 pfet_01v8 L=1.5e-07 W=1.13e-06 $X=151880 $Y=147320 $dt=16
M4955 1 268 287 1 pfet_01v8 L=1.5e-07 W=1.13e-06 $X=151880 $Y=155600 $dt=16
M4956 1 269 288 1 pfet_01v8 L=1.5e-07 W=1.13e-06 $X=151880 $Y=163880 $dt=16
M4957 289 118 1 1 pfet_01v8 L=1.5e-07 W=1.13e-06 $X=152250 $Y=8870 $dt=16
M4958 290 119 1 1 pfet_01v8 L=1.5e-07 W=1.13e-06 $X=152250 $Y=17150 $dt=16
M4959 291 120 1 1 pfet_01v8 L=1.5e-07 W=1.13e-06 $X=152250 $Y=25430 $dt=16
M4960 292 121 1 1 pfet_01v8 L=1.5e-07 W=1.13e-06 $X=152250 $Y=33710 $dt=16
M4961 293 122 1 1 pfet_01v8 L=1.5e-07 W=1.13e-06 $X=152250 $Y=41990 $dt=16
M4962 294 123 1 1 pfet_01v8 L=1.5e-07 W=1.13e-06 $X=152250 $Y=50270 $dt=16
M4963 295 124 1 1 pfet_01v8 L=1.5e-07 W=1.13e-06 $X=152250 $Y=58550 $dt=16
M4964 296 125 1 1 pfet_01v8 L=1.5e-07 W=1.13e-06 $X=152250 $Y=66830 $dt=16
M4965 297 126 1 1 pfet_01v8 L=1.5e-07 W=1.13e-06 $X=152250 $Y=75110 $dt=16
M4966 298 127 1 1 pfet_01v8 L=1.5e-07 W=1.13e-06 $X=152250 $Y=83390 $dt=16
M4967 299 128 1 1 pfet_01v8 L=1.5e-07 W=1.13e-06 $X=152250 $Y=91670 $dt=16
M4968 300 129 1 1 pfet_01v8 L=1.5e-07 W=1.13e-06 $X=152250 $Y=99950 $dt=16
M4969 301 130 1 1 pfet_01v8 L=1.5e-07 W=1.13e-06 $X=152250 $Y=108230 $dt=16
M4970 302 131 1 1 pfet_01v8 L=1.5e-07 W=1.13e-06 $X=152250 $Y=116510 $dt=16
M4971 303 132 1 1 pfet_01v8 L=1.5e-07 W=1.13e-06 $X=152250 $Y=124790 $dt=16
M4972 304 133 1 1 pfet_01v8 L=1.5e-07 W=1.13e-06 $X=152250 $Y=133070 $dt=16
M4973 305 134 1 1 pfet_01v8 L=1.5e-07 W=1.13e-06 $X=152250 $Y=141350 $dt=16
M4974 306 135 1 1 pfet_01v8 L=1.5e-07 W=1.13e-06 $X=152250 $Y=149630 $dt=16
M4975 307 136 1 1 pfet_01v8 L=1.5e-07 W=1.13e-06 $X=152250 $Y=157910 $dt=16
M4976 270 251 1 1 pfet_01v8 L=1.5e-07 W=1.13e-06 $X=152310 $Y=14840 $dt=16
M4977 271 252 1 1 pfet_01v8 L=1.5e-07 W=1.13e-06 $X=152310 $Y=23120 $dt=16
M4978 272 253 1 1 pfet_01v8 L=1.5e-07 W=1.13e-06 $X=152310 $Y=31400 $dt=16
M4979 273 254 1 1 pfet_01v8 L=1.5e-07 W=1.13e-06 $X=152310 $Y=39680 $dt=16
M4980 274 255 1 1 pfet_01v8 L=1.5e-07 W=1.13e-06 $X=152310 $Y=47960 $dt=16
M4981 275 256 1 1 pfet_01v8 L=1.5e-07 W=1.13e-06 $X=152310 $Y=56240 $dt=16
M4982 276 257 1 1 pfet_01v8 L=1.5e-07 W=1.13e-06 $X=152310 $Y=64520 $dt=16
M4983 277 258 1 1 pfet_01v8 L=1.5e-07 W=1.13e-06 $X=152310 $Y=72800 $dt=16
M4984 278 259 1 1 pfet_01v8 L=1.5e-07 W=1.13e-06 $X=152310 $Y=81080 $dt=16
M4985 279 260 1 1 pfet_01v8 L=1.5e-07 W=1.13e-06 $X=152310 $Y=89360 $dt=16
M4986 280 261 1 1 pfet_01v8 L=1.5e-07 W=1.13e-06 $X=152310 $Y=97640 $dt=16
M4987 281 262 1 1 pfet_01v8 L=1.5e-07 W=1.13e-06 $X=152310 $Y=105920 $dt=16
M4988 282 263 1 1 pfet_01v8 L=1.5e-07 W=1.13e-06 $X=152310 $Y=114200 $dt=16
M4989 283 264 1 1 pfet_01v8 L=1.5e-07 W=1.13e-06 $X=152310 $Y=122480 $dt=16
M4990 284 265 1 1 pfet_01v8 L=1.5e-07 W=1.13e-06 $X=152310 $Y=130760 $dt=16
M4991 285 266 1 1 pfet_01v8 L=1.5e-07 W=1.13e-06 $X=152310 $Y=139040 $dt=16
M4992 286 267 1 1 pfet_01v8 L=1.5e-07 W=1.13e-06 $X=152310 $Y=147320 $dt=16
M4993 287 268 1 1 pfet_01v8 L=1.5e-07 W=1.13e-06 $X=152310 $Y=155600 $dt=16
M4994 288 269 1 1 pfet_01v8 L=1.5e-07 W=1.13e-06 $X=152310 $Y=163880 $dt=16
M4995 1 118 289 1 pfet_01v8 L=1.5e-07 W=1.13e-06 $X=152680 $Y=8870 $dt=16
M4996 1 119 290 1 pfet_01v8 L=1.5e-07 W=1.13e-06 $X=152680 $Y=17150 $dt=16
M4997 1 120 291 1 pfet_01v8 L=1.5e-07 W=1.13e-06 $X=152680 $Y=25430 $dt=16
M4998 1 121 292 1 pfet_01v8 L=1.5e-07 W=1.13e-06 $X=152680 $Y=33710 $dt=16
M4999 1 122 293 1 pfet_01v8 L=1.5e-07 W=1.13e-06 $X=152680 $Y=41990 $dt=16
M5000 1 123 294 1 pfet_01v8 L=1.5e-07 W=1.13e-06 $X=152680 $Y=50270 $dt=16
M5001 1 124 295 1 pfet_01v8 L=1.5e-07 W=1.13e-06 $X=152680 $Y=58550 $dt=16
M5002 1 125 296 1 pfet_01v8 L=1.5e-07 W=1.13e-06 $X=152680 $Y=66830 $dt=16
M5003 1 126 297 1 pfet_01v8 L=1.5e-07 W=1.13e-06 $X=152680 $Y=75110 $dt=16
M5004 1 127 298 1 pfet_01v8 L=1.5e-07 W=1.13e-06 $X=152680 $Y=83390 $dt=16
M5005 1 128 299 1 pfet_01v8 L=1.5e-07 W=1.13e-06 $X=152680 $Y=91670 $dt=16
M5006 1 129 300 1 pfet_01v8 L=1.5e-07 W=1.13e-06 $X=152680 $Y=99950 $dt=16
M5007 1 130 301 1 pfet_01v8 L=1.5e-07 W=1.13e-06 $X=152680 $Y=108230 $dt=16
M5008 1 131 302 1 pfet_01v8 L=1.5e-07 W=1.13e-06 $X=152680 $Y=116510 $dt=16
M5009 1 132 303 1 pfet_01v8 L=1.5e-07 W=1.13e-06 $X=152680 $Y=124790 $dt=16
M5010 1 133 304 1 pfet_01v8 L=1.5e-07 W=1.13e-06 $X=152680 $Y=133070 $dt=16
M5011 1 134 305 1 pfet_01v8 L=1.5e-07 W=1.13e-06 $X=152680 $Y=141350 $dt=16
M5012 1 135 306 1 pfet_01v8 L=1.5e-07 W=1.13e-06 $X=152680 $Y=149630 $dt=16
M5013 1 136 307 1 pfet_01v8 L=1.5e-07 W=1.13e-06 $X=152680 $Y=157910 $dt=16
M5014 1 251 270 1 pfet_01v8 L=1.5e-07 W=1.13e-06 $X=152740 $Y=14840 $dt=16
M5015 1 252 271 1 pfet_01v8 L=1.5e-07 W=1.13e-06 $X=152740 $Y=23120 $dt=16
M5016 1 253 272 1 pfet_01v8 L=1.5e-07 W=1.13e-06 $X=152740 $Y=31400 $dt=16
M5017 1 254 273 1 pfet_01v8 L=1.5e-07 W=1.13e-06 $X=152740 $Y=39680 $dt=16
M5018 1 255 274 1 pfet_01v8 L=1.5e-07 W=1.13e-06 $X=152740 $Y=47960 $dt=16
M5019 1 256 275 1 pfet_01v8 L=1.5e-07 W=1.13e-06 $X=152740 $Y=56240 $dt=16
M5020 1 257 276 1 pfet_01v8 L=1.5e-07 W=1.13e-06 $X=152740 $Y=64520 $dt=16
M5021 1 258 277 1 pfet_01v8 L=1.5e-07 W=1.13e-06 $X=152740 $Y=72800 $dt=16
M5022 1 259 278 1 pfet_01v8 L=1.5e-07 W=1.13e-06 $X=152740 $Y=81080 $dt=16
M5023 1 260 279 1 pfet_01v8 L=1.5e-07 W=1.13e-06 $X=152740 $Y=89360 $dt=16
M5024 1 261 280 1 pfet_01v8 L=1.5e-07 W=1.13e-06 $X=152740 $Y=97640 $dt=16
M5025 1 262 281 1 pfet_01v8 L=1.5e-07 W=1.13e-06 $X=152740 $Y=105920 $dt=16
M5026 1 263 282 1 pfet_01v8 L=1.5e-07 W=1.13e-06 $X=152740 $Y=114200 $dt=16
M5027 1 264 283 1 pfet_01v8 L=1.5e-07 W=1.13e-06 $X=152740 $Y=122480 $dt=16
M5028 1 265 284 1 pfet_01v8 L=1.5e-07 W=1.13e-06 $X=152740 $Y=130760 $dt=16
M5029 1 266 285 1 pfet_01v8 L=1.5e-07 W=1.13e-06 $X=152740 $Y=139040 $dt=16
M5030 1 267 286 1 pfet_01v8 L=1.5e-07 W=1.13e-06 $X=152740 $Y=147320 $dt=16
M5031 1 268 287 1 pfet_01v8 L=1.5e-07 W=1.13e-06 $X=152740 $Y=155600 $dt=16
M5032 1 269 288 1 pfet_01v8 L=1.5e-07 W=1.13e-06 $X=152740 $Y=163880 $dt=16
M5033 289 118 1 1 pfet_01v8 L=1.5e-07 W=1.13e-06 $X=153110 $Y=8870 $dt=16
M5034 290 119 1 1 pfet_01v8 L=1.5e-07 W=1.13e-06 $X=153110 $Y=17150 $dt=16
M5035 291 120 1 1 pfet_01v8 L=1.5e-07 W=1.13e-06 $X=153110 $Y=25430 $dt=16
M5036 292 121 1 1 pfet_01v8 L=1.5e-07 W=1.13e-06 $X=153110 $Y=33710 $dt=16
M5037 293 122 1 1 pfet_01v8 L=1.5e-07 W=1.13e-06 $X=153110 $Y=41990 $dt=16
M5038 294 123 1 1 pfet_01v8 L=1.5e-07 W=1.13e-06 $X=153110 $Y=50270 $dt=16
M5039 295 124 1 1 pfet_01v8 L=1.5e-07 W=1.13e-06 $X=153110 $Y=58550 $dt=16
M5040 296 125 1 1 pfet_01v8 L=1.5e-07 W=1.13e-06 $X=153110 $Y=66830 $dt=16
M5041 297 126 1 1 pfet_01v8 L=1.5e-07 W=1.13e-06 $X=153110 $Y=75110 $dt=16
M5042 298 127 1 1 pfet_01v8 L=1.5e-07 W=1.13e-06 $X=153110 $Y=83390 $dt=16
M5043 299 128 1 1 pfet_01v8 L=1.5e-07 W=1.13e-06 $X=153110 $Y=91670 $dt=16
M5044 300 129 1 1 pfet_01v8 L=1.5e-07 W=1.13e-06 $X=153110 $Y=99950 $dt=16
M5045 301 130 1 1 pfet_01v8 L=1.5e-07 W=1.13e-06 $X=153110 $Y=108230 $dt=16
M5046 302 131 1 1 pfet_01v8 L=1.5e-07 W=1.13e-06 $X=153110 $Y=116510 $dt=16
M5047 303 132 1 1 pfet_01v8 L=1.5e-07 W=1.13e-06 $X=153110 $Y=124790 $dt=16
M5048 304 133 1 1 pfet_01v8 L=1.5e-07 W=1.13e-06 $X=153110 $Y=133070 $dt=16
M5049 305 134 1 1 pfet_01v8 L=1.5e-07 W=1.13e-06 $X=153110 $Y=141350 $dt=16
M5050 306 135 1 1 pfet_01v8 L=1.5e-07 W=1.13e-06 $X=153110 $Y=149630 $dt=16
M5051 307 136 1 1 pfet_01v8 L=1.5e-07 W=1.13e-06 $X=153110 $Y=157910 $dt=16
M5052 270 251 1 1 pfet_01v8 L=1.5e-07 W=1.13e-06 $X=153170 $Y=14840 $dt=16
M5053 271 252 1 1 pfet_01v8 L=1.5e-07 W=1.13e-06 $X=153170 $Y=23120 $dt=16
M5054 272 253 1 1 pfet_01v8 L=1.5e-07 W=1.13e-06 $X=153170 $Y=31400 $dt=16
M5055 273 254 1 1 pfet_01v8 L=1.5e-07 W=1.13e-06 $X=153170 $Y=39680 $dt=16
M5056 274 255 1 1 pfet_01v8 L=1.5e-07 W=1.13e-06 $X=153170 $Y=47960 $dt=16
M5057 275 256 1 1 pfet_01v8 L=1.5e-07 W=1.13e-06 $X=153170 $Y=56240 $dt=16
M5058 276 257 1 1 pfet_01v8 L=1.5e-07 W=1.13e-06 $X=153170 $Y=64520 $dt=16
M5059 277 258 1 1 pfet_01v8 L=1.5e-07 W=1.13e-06 $X=153170 $Y=72800 $dt=16
M5060 278 259 1 1 pfet_01v8 L=1.5e-07 W=1.13e-06 $X=153170 $Y=81080 $dt=16
M5061 279 260 1 1 pfet_01v8 L=1.5e-07 W=1.13e-06 $X=153170 $Y=89360 $dt=16
M5062 280 261 1 1 pfet_01v8 L=1.5e-07 W=1.13e-06 $X=153170 $Y=97640 $dt=16
M5063 281 262 1 1 pfet_01v8 L=1.5e-07 W=1.13e-06 $X=153170 $Y=105920 $dt=16
M5064 282 263 1 1 pfet_01v8 L=1.5e-07 W=1.13e-06 $X=153170 $Y=114200 $dt=16
M5065 283 264 1 1 pfet_01v8 L=1.5e-07 W=1.13e-06 $X=153170 $Y=122480 $dt=16
M5066 284 265 1 1 pfet_01v8 L=1.5e-07 W=1.13e-06 $X=153170 $Y=130760 $dt=16
M5067 285 266 1 1 pfet_01v8 L=1.5e-07 W=1.13e-06 $X=153170 $Y=139040 $dt=16
M5068 286 267 1 1 pfet_01v8 L=1.5e-07 W=1.13e-06 $X=153170 $Y=147320 $dt=16
M5069 287 268 1 1 pfet_01v8 L=1.5e-07 W=1.13e-06 $X=153170 $Y=155600 $dt=16
M5070 288 269 1 1 pfet_01v8 L=1.5e-07 W=1.13e-06 $X=153170 $Y=163880 $dt=16
M5071 1 118 289 1 pfet_01v8 L=1.5e-07 W=1.13e-06 $X=153540 $Y=8870 $dt=16
M5072 1 119 290 1 pfet_01v8 L=1.5e-07 W=1.13e-06 $X=153540 $Y=17150 $dt=16
M5073 1 120 291 1 pfet_01v8 L=1.5e-07 W=1.13e-06 $X=153540 $Y=25430 $dt=16
M5074 1 121 292 1 pfet_01v8 L=1.5e-07 W=1.13e-06 $X=153540 $Y=33710 $dt=16
M5075 1 122 293 1 pfet_01v8 L=1.5e-07 W=1.13e-06 $X=153540 $Y=41990 $dt=16
M5076 1 123 294 1 pfet_01v8 L=1.5e-07 W=1.13e-06 $X=153540 $Y=50270 $dt=16
M5077 1 124 295 1 pfet_01v8 L=1.5e-07 W=1.13e-06 $X=153540 $Y=58550 $dt=16
M5078 1 125 296 1 pfet_01v8 L=1.5e-07 W=1.13e-06 $X=153540 $Y=66830 $dt=16
M5079 1 126 297 1 pfet_01v8 L=1.5e-07 W=1.13e-06 $X=153540 $Y=75110 $dt=16
M5080 1 127 298 1 pfet_01v8 L=1.5e-07 W=1.13e-06 $X=153540 $Y=83390 $dt=16
M5081 1 128 299 1 pfet_01v8 L=1.5e-07 W=1.13e-06 $X=153540 $Y=91670 $dt=16
M5082 1 129 300 1 pfet_01v8 L=1.5e-07 W=1.13e-06 $X=153540 $Y=99950 $dt=16
M5083 1 130 301 1 pfet_01v8 L=1.5e-07 W=1.13e-06 $X=153540 $Y=108230 $dt=16
M5084 1 131 302 1 pfet_01v8 L=1.5e-07 W=1.13e-06 $X=153540 $Y=116510 $dt=16
M5085 1 132 303 1 pfet_01v8 L=1.5e-07 W=1.13e-06 $X=153540 $Y=124790 $dt=16
M5086 1 133 304 1 pfet_01v8 L=1.5e-07 W=1.13e-06 $X=153540 $Y=133070 $dt=16
M5087 1 134 305 1 pfet_01v8 L=1.5e-07 W=1.13e-06 $X=153540 $Y=141350 $dt=16
M5088 1 135 306 1 pfet_01v8 L=1.5e-07 W=1.13e-06 $X=153540 $Y=149630 $dt=16
M5089 1 136 307 1 pfet_01v8 L=1.5e-07 W=1.13e-06 $X=153540 $Y=157910 $dt=16
M5090 1 251 270 1 pfet_01v8 L=1.5e-07 W=1.13e-06 $X=153600 $Y=14840 $dt=16
M5091 1 252 271 1 pfet_01v8 L=1.5e-07 W=1.13e-06 $X=153600 $Y=23120 $dt=16
M5092 1 253 272 1 pfet_01v8 L=1.5e-07 W=1.13e-06 $X=153600 $Y=31400 $dt=16
M5093 1 254 273 1 pfet_01v8 L=1.5e-07 W=1.13e-06 $X=153600 $Y=39680 $dt=16
M5094 1 255 274 1 pfet_01v8 L=1.5e-07 W=1.13e-06 $X=153600 $Y=47960 $dt=16
M5095 1 256 275 1 pfet_01v8 L=1.5e-07 W=1.13e-06 $X=153600 $Y=56240 $dt=16
M5096 1 257 276 1 pfet_01v8 L=1.5e-07 W=1.13e-06 $X=153600 $Y=64520 $dt=16
M5097 1 258 277 1 pfet_01v8 L=1.5e-07 W=1.13e-06 $X=153600 $Y=72800 $dt=16
M5098 1 259 278 1 pfet_01v8 L=1.5e-07 W=1.13e-06 $X=153600 $Y=81080 $dt=16
M5099 1 260 279 1 pfet_01v8 L=1.5e-07 W=1.13e-06 $X=153600 $Y=89360 $dt=16
M5100 1 261 280 1 pfet_01v8 L=1.5e-07 W=1.13e-06 $X=153600 $Y=97640 $dt=16
M5101 1 262 281 1 pfet_01v8 L=1.5e-07 W=1.13e-06 $X=153600 $Y=105920 $dt=16
M5102 1 263 282 1 pfet_01v8 L=1.5e-07 W=1.13e-06 $X=153600 $Y=114200 $dt=16
M5103 1 264 283 1 pfet_01v8 L=1.5e-07 W=1.13e-06 $X=153600 $Y=122480 $dt=16
M5104 1 265 284 1 pfet_01v8 L=1.5e-07 W=1.13e-06 $X=153600 $Y=130760 $dt=16
M5105 1 266 285 1 pfet_01v8 L=1.5e-07 W=1.13e-06 $X=153600 $Y=139040 $dt=16
M5106 1 267 286 1 pfet_01v8 L=1.5e-07 W=1.13e-06 $X=153600 $Y=147320 $dt=16
M5107 1 268 287 1 pfet_01v8 L=1.5e-07 W=1.13e-06 $X=153600 $Y=155600 $dt=16
M5108 1 269 288 1 pfet_01v8 L=1.5e-07 W=1.13e-06 $X=153600 $Y=163880 $dt=16
M5109 251 118 1 1 pfet_01v8 L=1.5e-07 W=1.13e-06 $X=154030 $Y=14840 $dt=16
M5110 252 119 1 1 pfet_01v8 L=1.5e-07 W=1.13e-06 $X=154030 $Y=23120 $dt=16
M5111 253 120 1 1 pfet_01v8 L=1.5e-07 W=1.13e-06 $X=154030 $Y=31400 $dt=16
M5112 254 121 1 1 pfet_01v8 L=1.5e-07 W=1.13e-06 $X=154030 $Y=39680 $dt=16
M5113 255 122 1 1 pfet_01v8 L=1.5e-07 W=1.13e-06 $X=154030 $Y=47960 $dt=16
M5114 256 123 1 1 pfet_01v8 L=1.5e-07 W=1.13e-06 $X=154030 $Y=56240 $dt=16
M5115 257 124 1 1 pfet_01v8 L=1.5e-07 W=1.13e-06 $X=154030 $Y=64520 $dt=16
M5116 258 125 1 1 pfet_01v8 L=1.5e-07 W=1.13e-06 $X=154030 $Y=72800 $dt=16
M5117 259 126 1 1 pfet_01v8 L=1.5e-07 W=1.13e-06 $X=154030 $Y=81080 $dt=16
M5118 260 127 1 1 pfet_01v8 L=1.5e-07 W=1.13e-06 $X=154030 $Y=89360 $dt=16
M5119 261 128 1 1 pfet_01v8 L=1.5e-07 W=1.13e-06 $X=154030 $Y=97640 $dt=16
M5120 262 129 1 1 pfet_01v8 L=1.5e-07 W=1.13e-06 $X=154030 $Y=105920 $dt=16
M5121 263 130 1 1 pfet_01v8 L=1.5e-07 W=1.13e-06 $X=154030 $Y=114200 $dt=16
M5122 264 131 1 1 pfet_01v8 L=1.5e-07 W=1.13e-06 $X=154030 $Y=122480 $dt=16
M5123 265 132 1 1 pfet_01v8 L=1.5e-07 W=1.13e-06 $X=154030 $Y=130760 $dt=16
M5124 266 133 1 1 pfet_01v8 L=1.5e-07 W=1.13e-06 $X=154030 $Y=139040 $dt=16
M5125 267 134 1 1 pfet_01v8 L=1.5e-07 W=1.13e-06 $X=154030 $Y=147320 $dt=16
M5126 268 135 1 1 pfet_01v8 L=1.5e-07 W=1.13e-06 $X=154030 $Y=155600 $dt=16
M5127 269 136 1 1 pfet_01v8 L=1.5e-07 W=1.13e-06 $X=154030 $Y=163880 $dt=16
M5128 1 118 251 1 pfet_01v8 L=1.5e-07 W=1.13e-06 $X=154460 $Y=14840 $dt=16
M5129 1 119 252 1 pfet_01v8 L=1.5e-07 W=1.13e-06 $X=154460 $Y=23120 $dt=16
M5130 1 120 253 1 pfet_01v8 L=1.5e-07 W=1.13e-06 $X=154460 $Y=31400 $dt=16
M5131 1 121 254 1 pfet_01v8 L=1.5e-07 W=1.13e-06 $X=154460 $Y=39680 $dt=16
M5132 1 122 255 1 pfet_01v8 L=1.5e-07 W=1.13e-06 $X=154460 $Y=47960 $dt=16
M5133 1 123 256 1 pfet_01v8 L=1.5e-07 W=1.13e-06 $X=154460 $Y=56240 $dt=16
M5134 1 124 257 1 pfet_01v8 L=1.5e-07 W=1.13e-06 $X=154460 $Y=64520 $dt=16
M5135 1 125 258 1 pfet_01v8 L=1.5e-07 W=1.13e-06 $X=154460 $Y=72800 $dt=16
M5136 1 126 259 1 pfet_01v8 L=1.5e-07 W=1.13e-06 $X=154460 $Y=81080 $dt=16
M5137 1 127 260 1 pfet_01v8 L=1.5e-07 W=1.13e-06 $X=154460 $Y=89360 $dt=16
M5138 1 128 261 1 pfet_01v8 L=1.5e-07 W=1.13e-06 $X=154460 $Y=97640 $dt=16
M5139 1 129 262 1 pfet_01v8 L=1.5e-07 W=1.13e-06 $X=154460 $Y=105920 $dt=16
M5140 1 130 263 1 pfet_01v8 L=1.5e-07 W=1.13e-06 $X=154460 $Y=114200 $dt=16
M5141 1 131 264 1 pfet_01v8 L=1.5e-07 W=1.13e-06 $X=154460 $Y=122480 $dt=16
M5142 1 132 265 1 pfet_01v8 L=1.5e-07 W=1.13e-06 $X=154460 $Y=130760 $dt=16
M5143 1 133 266 1 pfet_01v8 L=1.5e-07 W=1.13e-06 $X=154460 $Y=139040 $dt=16
M5144 1 134 267 1 pfet_01v8 L=1.5e-07 W=1.13e-06 $X=154460 $Y=147320 $dt=16
M5145 1 135 268 1 pfet_01v8 L=1.5e-07 W=1.13e-06 $X=154460 $Y=155600 $dt=16
M5146 1 136 269 1 pfet_01v8 L=1.5e-07 W=1.13e-06 $X=154460 $Y=163880 $dt=16
M5147 232 194 1 1 pfet_01v8 L=1.5e-07 W=1.13e-06 $X=155500 $Y=14840 $dt=16
M5148 233 195 1 1 pfet_01v8 L=1.5e-07 W=1.13e-06 $X=155500 $Y=23120 $dt=16
M5149 234 196 1 1 pfet_01v8 L=1.5e-07 W=1.13e-06 $X=155500 $Y=31400 $dt=16
M5150 235 197 1 1 pfet_01v8 L=1.5e-07 W=1.13e-06 $X=155500 $Y=39680 $dt=16
M5151 236 198 1 1 pfet_01v8 L=1.5e-07 W=1.13e-06 $X=155500 $Y=47960 $dt=16
M5152 237 199 1 1 pfet_01v8 L=1.5e-07 W=1.13e-06 $X=155500 $Y=56240 $dt=16
M5153 238 200 1 1 pfet_01v8 L=1.5e-07 W=1.13e-06 $X=155500 $Y=64520 $dt=16
M5154 239 201 1 1 pfet_01v8 L=1.5e-07 W=1.13e-06 $X=155500 $Y=72800 $dt=16
M5155 240 202 1 1 pfet_01v8 L=1.5e-07 W=1.13e-06 $X=155500 $Y=81080 $dt=16
M5156 241 203 1 1 pfet_01v8 L=1.5e-07 W=1.13e-06 $X=155500 $Y=89360 $dt=16
M5157 242 204 1 1 pfet_01v8 L=1.5e-07 W=1.13e-06 $X=155500 $Y=97640 $dt=16
M5158 243 205 1 1 pfet_01v8 L=1.5e-07 W=1.13e-06 $X=155500 $Y=105920 $dt=16
M5159 244 206 1 1 pfet_01v8 L=1.5e-07 W=1.13e-06 $X=155500 $Y=114200 $dt=16
M5160 245 207 1 1 pfet_01v8 L=1.5e-07 W=1.13e-06 $X=155500 $Y=122480 $dt=16
M5161 246 208 1 1 pfet_01v8 L=1.5e-07 W=1.13e-06 $X=155500 $Y=130760 $dt=16
M5162 247 209 1 1 pfet_01v8 L=1.5e-07 W=1.13e-06 $X=155500 $Y=139040 $dt=16
M5163 248 210 1 1 pfet_01v8 L=1.5e-07 W=1.13e-06 $X=155500 $Y=147320 $dt=16
M5164 249 211 1 1 pfet_01v8 L=1.5e-07 W=1.13e-06 $X=155500 $Y=155600 $dt=16
M5165 250 212 1 1 pfet_01v8 L=1.5e-07 W=1.13e-06 $X=155500 $Y=163880 $dt=16
M5166 213 99 1 1 pfet_01v8 L=1.5e-07 W=1.13e-06 $X=155930 $Y=8870 $dt=16
M5167 1 194 232 1 pfet_01v8 L=1.5e-07 W=1.13e-06 $X=155930 $Y=14840 $dt=16
M5168 214 100 1 1 pfet_01v8 L=1.5e-07 W=1.13e-06 $X=155930 $Y=17150 $dt=16
M5169 1 195 233 1 pfet_01v8 L=1.5e-07 W=1.13e-06 $X=155930 $Y=23120 $dt=16
M5170 215 101 1 1 pfet_01v8 L=1.5e-07 W=1.13e-06 $X=155930 $Y=25430 $dt=16
M5171 1 196 234 1 pfet_01v8 L=1.5e-07 W=1.13e-06 $X=155930 $Y=31400 $dt=16
M5172 216 102 1 1 pfet_01v8 L=1.5e-07 W=1.13e-06 $X=155930 $Y=33710 $dt=16
M5173 1 197 235 1 pfet_01v8 L=1.5e-07 W=1.13e-06 $X=155930 $Y=39680 $dt=16
M5174 217 103 1 1 pfet_01v8 L=1.5e-07 W=1.13e-06 $X=155930 $Y=41990 $dt=16
M5175 1 198 236 1 pfet_01v8 L=1.5e-07 W=1.13e-06 $X=155930 $Y=47960 $dt=16
M5176 218 104 1 1 pfet_01v8 L=1.5e-07 W=1.13e-06 $X=155930 $Y=50270 $dt=16
M5177 1 199 237 1 pfet_01v8 L=1.5e-07 W=1.13e-06 $X=155930 $Y=56240 $dt=16
M5178 219 105 1 1 pfet_01v8 L=1.5e-07 W=1.13e-06 $X=155930 $Y=58550 $dt=16
M5179 1 200 238 1 pfet_01v8 L=1.5e-07 W=1.13e-06 $X=155930 $Y=64520 $dt=16
M5180 220 106 1 1 pfet_01v8 L=1.5e-07 W=1.13e-06 $X=155930 $Y=66830 $dt=16
M5181 1 201 239 1 pfet_01v8 L=1.5e-07 W=1.13e-06 $X=155930 $Y=72800 $dt=16
M5182 221 107 1 1 pfet_01v8 L=1.5e-07 W=1.13e-06 $X=155930 $Y=75110 $dt=16
M5183 1 202 240 1 pfet_01v8 L=1.5e-07 W=1.13e-06 $X=155930 $Y=81080 $dt=16
M5184 222 108 1 1 pfet_01v8 L=1.5e-07 W=1.13e-06 $X=155930 $Y=83390 $dt=16
M5185 1 203 241 1 pfet_01v8 L=1.5e-07 W=1.13e-06 $X=155930 $Y=89360 $dt=16
M5186 223 109 1 1 pfet_01v8 L=1.5e-07 W=1.13e-06 $X=155930 $Y=91670 $dt=16
M5187 1 204 242 1 pfet_01v8 L=1.5e-07 W=1.13e-06 $X=155930 $Y=97640 $dt=16
M5188 224 110 1 1 pfet_01v8 L=1.5e-07 W=1.13e-06 $X=155930 $Y=99950 $dt=16
M5189 1 205 243 1 pfet_01v8 L=1.5e-07 W=1.13e-06 $X=155930 $Y=105920 $dt=16
M5190 225 111 1 1 pfet_01v8 L=1.5e-07 W=1.13e-06 $X=155930 $Y=108230 $dt=16
M5191 1 206 244 1 pfet_01v8 L=1.5e-07 W=1.13e-06 $X=155930 $Y=114200 $dt=16
M5192 226 112 1 1 pfet_01v8 L=1.5e-07 W=1.13e-06 $X=155930 $Y=116510 $dt=16
M5193 1 207 245 1 pfet_01v8 L=1.5e-07 W=1.13e-06 $X=155930 $Y=122480 $dt=16
M5194 227 113 1 1 pfet_01v8 L=1.5e-07 W=1.13e-06 $X=155930 $Y=124790 $dt=16
M5195 1 208 246 1 pfet_01v8 L=1.5e-07 W=1.13e-06 $X=155930 $Y=130760 $dt=16
M5196 228 114 1 1 pfet_01v8 L=1.5e-07 W=1.13e-06 $X=155930 $Y=133070 $dt=16
M5197 1 209 247 1 pfet_01v8 L=1.5e-07 W=1.13e-06 $X=155930 $Y=139040 $dt=16
M5198 229 115 1 1 pfet_01v8 L=1.5e-07 W=1.13e-06 $X=155930 $Y=141350 $dt=16
M5199 1 210 248 1 pfet_01v8 L=1.5e-07 W=1.13e-06 $X=155930 $Y=147320 $dt=16
M5200 230 116 1 1 pfet_01v8 L=1.5e-07 W=1.13e-06 $X=155930 $Y=149630 $dt=16
M5201 1 211 249 1 pfet_01v8 L=1.5e-07 W=1.13e-06 $X=155930 $Y=155600 $dt=16
M5202 231 117 1 1 pfet_01v8 L=1.5e-07 W=1.13e-06 $X=155930 $Y=157910 $dt=16
M5203 1 212 250 1 pfet_01v8 L=1.5e-07 W=1.13e-06 $X=155930 $Y=163880 $dt=16
M5204 1 99 213 1 pfet_01v8 L=1.5e-07 W=1.13e-06 $X=156360 $Y=8870 $dt=16
M5205 232 194 1 1 pfet_01v8 L=1.5e-07 W=1.13e-06 $X=156360 $Y=14840 $dt=16
M5206 1 100 214 1 pfet_01v8 L=1.5e-07 W=1.13e-06 $X=156360 $Y=17150 $dt=16
M5207 233 195 1 1 pfet_01v8 L=1.5e-07 W=1.13e-06 $X=156360 $Y=23120 $dt=16
M5208 1 101 215 1 pfet_01v8 L=1.5e-07 W=1.13e-06 $X=156360 $Y=25430 $dt=16
M5209 234 196 1 1 pfet_01v8 L=1.5e-07 W=1.13e-06 $X=156360 $Y=31400 $dt=16
M5210 1 102 216 1 pfet_01v8 L=1.5e-07 W=1.13e-06 $X=156360 $Y=33710 $dt=16
M5211 235 197 1 1 pfet_01v8 L=1.5e-07 W=1.13e-06 $X=156360 $Y=39680 $dt=16
M5212 1 103 217 1 pfet_01v8 L=1.5e-07 W=1.13e-06 $X=156360 $Y=41990 $dt=16
M5213 236 198 1 1 pfet_01v8 L=1.5e-07 W=1.13e-06 $X=156360 $Y=47960 $dt=16
M5214 1 104 218 1 pfet_01v8 L=1.5e-07 W=1.13e-06 $X=156360 $Y=50270 $dt=16
M5215 237 199 1 1 pfet_01v8 L=1.5e-07 W=1.13e-06 $X=156360 $Y=56240 $dt=16
M5216 1 105 219 1 pfet_01v8 L=1.5e-07 W=1.13e-06 $X=156360 $Y=58550 $dt=16
M5217 238 200 1 1 pfet_01v8 L=1.5e-07 W=1.13e-06 $X=156360 $Y=64520 $dt=16
M5218 1 106 220 1 pfet_01v8 L=1.5e-07 W=1.13e-06 $X=156360 $Y=66830 $dt=16
M5219 239 201 1 1 pfet_01v8 L=1.5e-07 W=1.13e-06 $X=156360 $Y=72800 $dt=16
M5220 1 107 221 1 pfet_01v8 L=1.5e-07 W=1.13e-06 $X=156360 $Y=75110 $dt=16
M5221 240 202 1 1 pfet_01v8 L=1.5e-07 W=1.13e-06 $X=156360 $Y=81080 $dt=16
M5222 1 108 222 1 pfet_01v8 L=1.5e-07 W=1.13e-06 $X=156360 $Y=83390 $dt=16
M5223 241 203 1 1 pfet_01v8 L=1.5e-07 W=1.13e-06 $X=156360 $Y=89360 $dt=16
M5224 1 109 223 1 pfet_01v8 L=1.5e-07 W=1.13e-06 $X=156360 $Y=91670 $dt=16
M5225 242 204 1 1 pfet_01v8 L=1.5e-07 W=1.13e-06 $X=156360 $Y=97640 $dt=16
M5226 1 110 224 1 pfet_01v8 L=1.5e-07 W=1.13e-06 $X=156360 $Y=99950 $dt=16
M5227 243 205 1 1 pfet_01v8 L=1.5e-07 W=1.13e-06 $X=156360 $Y=105920 $dt=16
M5228 1 111 225 1 pfet_01v8 L=1.5e-07 W=1.13e-06 $X=156360 $Y=108230 $dt=16
M5229 244 206 1 1 pfet_01v8 L=1.5e-07 W=1.13e-06 $X=156360 $Y=114200 $dt=16
M5230 1 112 226 1 pfet_01v8 L=1.5e-07 W=1.13e-06 $X=156360 $Y=116510 $dt=16
M5231 245 207 1 1 pfet_01v8 L=1.5e-07 W=1.13e-06 $X=156360 $Y=122480 $dt=16
M5232 1 113 227 1 pfet_01v8 L=1.5e-07 W=1.13e-06 $X=156360 $Y=124790 $dt=16
M5233 246 208 1 1 pfet_01v8 L=1.5e-07 W=1.13e-06 $X=156360 $Y=130760 $dt=16
M5234 1 114 228 1 pfet_01v8 L=1.5e-07 W=1.13e-06 $X=156360 $Y=133070 $dt=16
M5235 247 209 1 1 pfet_01v8 L=1.5e-07 W=1.13e-06 $X=156360 $Y=139040 $dt=16
M5236 1 115 229 1 pfet_01v8 L=1.5e-07 W=1.13e-06 $X=156360 $Y=141350 $dt=16
M5237 248 210 1 1 pfet_01v8 L=1.5e-07 W=1.13e-06 $X=156360 $Y=147320 $dt=16
M5238 1 116 230 1 pfet_01v8 L=1.5e-07 W=1.13e-06 $X=156360 $Y=149630 $dt=16
M5239 249 211 1 1 pfet_01v8 L=1.5e-07 W=1.13e-06 $X=156360 $Y=155600 $dt=16
M5240 1 117 231 1 pfet_01v8 L=1.5e-07 W=1.13e-06 $X=156360 $Y=157910 $dt=16
M5241 250 212 1 1 pfet_01v8 L=1.5e-07 W=1.13e-06 $X=156360 $Y=163880 $dt=16
M5242 213 99 1 1 pfet_01v8 L=1.5e-07 W=1.13e-06 $X=156790 $Y=8870 $dt=16
M5243 1 194 232 1 pfet_01v8 L=1.5e-07 W=1.13e-06 $X=156790 $Y=14840 $dt=16
M5244 214 100 1 1 pfet_01v8 L=1.5e-07 W=1.13e-06 $X=156790 $Y=17150 $dt=16
M5245 1 195 233 1 pfet_01v8 L=1.5e-07 W=1.13e-06 $X=156790 $Y=23120 $dt=16
M5246 215 101 1 1 pfet_01v8 L=1.5e-07 W=1.13e-06 $X=156790 $Y=25430 $dt=16
M5247 1 196 234 1 pfet_01v8 L=1.5e-07 W=1.13e-06 $X=156790 $Y=31400 $dt=16
M5248 216 102 1 1 pfet_01v8 L=1.5e-07 W=1.13e-06 $X=156790 $Y=33710 $dt=16
M5249 1 197 235 1 pfet_01v8 L=1.5e-07 W=1.13e-06 $X=156790 $Y=39680 $dt=16
M5250 217 103 1 1 pfet_01v8 L=1.5e-07 W=1.13e-06 $X=156790 $Y=41990 $dt=16
M5251 1 198 236 1 pfet_01v8 L=1.5e-07 W=1.13e-06 $X=156790 $Y=47960 $dt=16
M5252 218 104 1 1 pfet_01v8 L=1.5e-07 W=1.13e-06 $X=156790 $Y=50270 $dt=16
M5253 1 199 237 1 pfet_01v8 L=1.5e-07 W=1.13e-06 $X=156790 $Y=56240 $dt=16
M5254 219 105 1 1 pfet_01v8 L=1.5e-07 W=1.13e-06 $X=156790 $Y=58550 $dt=16
M5255 1 200 238 1 pfet_01v8 L=1.5e-07 W=1.13e-06 $X=156790 $Y=64520 $dt=16
M5256 220 106 1 1 pfet_01v8 L=1.5e-07 W=1.13e-06 $X=156790 $Y=66830 $dt=16
M5257 1 201 239 1 pfet_01v8 L=1.5e-07 W=1.13e-06 $X=156790 $Y=72800 $dt=16
M5258 221 107 1 1 pfet_01v8 L=1.5e-07 W=1.13e-06 $X=156790 $Y=75110 $dt=16
M5259 1 202 240 1 pfet_01v8 L=1.5e-07 W=1.13e-06 $X=156790 $Y=81080 $dt=16
M5260 222 108 1 1 pfet_01v8 L=1.5e-07 W=1.13e-06 $X=156790 $Y=83390 $dt=16
M5261 1 203 241 1 pfet_01v8 L=1.5e-07 W=1.13e-06 $X=156790 $Y=89360 $dt=16
M5262 223 109 1 1 pfet_01v8 L=1.5e-07 W=1.13e-06 $X=156790 $Y=91670 $dt=16
M5263 1 204 242 1 pfet_01v8 L=1.5e-07 W=1.13e-06 $X=156790 $Y=97640 $dt=16
M5264 224 110 1 1 pfet_01v8 L=1.5e-07 W=1.13e-06 $X=156790 $Y=99950 $dt=16
M5265 1 205 243 1 pfet_01v8 L=1.5e-07 W=1.13e-06 $X=156790 $Y=105920 $dt=16
M5266 225 111 1 1 pfet_01v8 L=1.5e-07 W=1.13e-06 $X=156790 $Y=108230 $dt=16
M5267 1 206 244 1 pfet_01v8 L=1.5e-07 W=1.13e-06 $X=156790 $Y=114200 $dt=16
M5268 226 112 1 1 pfet_01v8 L=1.5e-07 W=1.13e-06 $X=156790 $Y=116510 $dt=16
M5269 1 207 245 1 pfet_01v8 L=1.5e-07 W=1.13e-06 $X=156790 $Y=122480 $dt=16
M5270 227 113 1 1 pfet_01v8 L=1.5e-07 W=1.13e-06 $X=156790 $Y=124790 $dt=16
M5271 1 208 246 1 pfet_01v8 L=1.5e-07 W=1.13e-06 $X=156790 $Y=130760 $dt=16
M5272 228 114 1 1 pfet_01v8 L=1.5e-07 W=1.13e-06 $X=156790 $Y=133070 $dt=16
M5273 1 209 247 1 pfet_01v8 L=1.5e-07 W=1.13e-06 $X=156790 $Y=139040 $dt=16
M5274 229 115 1 1 pfet_01v8 L=1.5e-07 W=1.13e-06 $X=156790 $Y=141350 $dt=16
M5275 1 210 248 1 pfet_01v8 L=1.5e-07 W=1.13e-06 $X=156790 $Y=147320 $dt=16
M5276 230 116 1 1 pfet_01v8 L=1.5e-07 W=1.13e-06 $X=156790 $Y=149630 $dt=16
M5277 1 211 249 1 pfet_01v8 L=1.5e-07 W=1.13e-06 $X=156790 $Y=155600 $dt=16
M5278 231 117 1 1 pfet_01v8 L=1.5e-07 W=1.13e-06 $X=156790 $Y=157910 $dt=16
M5279 1 212 250 1 pfet_01v8 L=1.5e-07 W=1.13e-06 $X=156790 $Y=163880 $dt=16
M5280 1 99 213 1 pfet_01v8 L=1.5e-07 W=1.13e-06 $X=157220 $Y=8870 $dt=16
M5281 194 23 1 1 pfet_01v8 L=1.5e-07 W=1.13e-06 $X=157220 $Y=14840 $dt=16
M5282 1 100 214 1 pfet_01v8 L=1.5e-07 W=1.13e-06 $X=157220 $Y=17150 $dt=16
M5283 195 24 1 1 pfet_01v8 L=1.5e-07 W=1.13e-06 $X=157220 $Y=23120 $dt=16
M5284 1 101 215 1 pfet_01v8 L=1.5e-07 W=1.13e-06 $X=157220 $Y=25430 $dt=16
M5285 196 25 1 1 pfet_01v8 L=1.5e-07 W=1.13e-06 $X=157220 $Y=31400 $dt=16
M5286 1 102 216 1 pfet_01v8 L=1.5e-07 W=1.13e-06 $X=157220 $Y=33710 $dt=16
M5287 197 26 1 1 pfet_01v8 L=1.5e-07 W=1.13e-06 $X=157220 $Y=39680 $dt=16
M5288 1 103 217 1 pfet_01v8 L=1.5e-07 W=1.13e-06 $X=157220 $Y=41990 $dt=16
M5289 198 27 1 1 pfet_01v8 L=1.5e-07 W=1.13e-06 $X=157220 $Y=47960 $dt=16
M5290 1 104 218 1 pfet_01v8 L=1.5e-07 W=1.13e-06 $X=157220 $Y=50270 $dt=16
M5291 199 28 1 1 pfet_01v8 L=1.5e-07 W=1.13e-06 $X=157220 $Y=56240 $dt=16
M5292 1 105 219 1 pfet_01v8 L=1.5e-07 W=1.13e-06 $X=157220 $Y=58550 $dt=16
M5293 200 29 1 1 pfet_01v8 L=1.5e-07 W=1.13e-06 $X=157220 $Y=64520 $dt=16
M5294 1 106 220 1 pfet_01v8 L=1.5e-07 W=1.13e-06 $X=157220 $Y=66830 $dt=16
M5295 201 30 1 1 pfet_01v8 L=1.5e-07 W=1.13e-06 $X=157220 $Y=72800 $dt=16
M5296 1 107 221 1 pfet_01v8 L=1.5e-07 W=1.13e-06 $X=157220 $Y=75110 $dt=16
M5297 202 31 1 1 pfet_01v8 L=1.5e-07 W=1.13e-06 $X=157220 $Y=81080 $dt=16
M5298 1 108 222 1 pfet_01v8 L=1.5e-07 W=1.13e-06 $X=157220 $Y=83390 $dt=16
M5299 203 32 1 1 pfet_01v8 L=1.5e-07 W=1.13e-06 $X=157220 $Y=89360 $dt=16
M5300 1 109 223 1 pfet_01v8 L=1.5e-07 W=1.13e-06 $X=157220 $Y=91670 $dt=16
M5301 204 33 1 1 pfet_01v8 L=1.5e-07 W=1.13e-06 $X=157220 $Y=97640 $dt=16
M5302 1 110 224 1 pfet_01v8 L=1.5e-07 W=1.13e-06 $X=157220 $Y=99950 $dt=16
M5303 205 34 1 1 pfet_01v8 L=1.5e-07 W=1.13e-06 $X=157220 $Y=105920 $dt=16
M5304 1 111 225 1 pfet_01v8 L=1.5e-07 W=1.13e-06 $X=157220 $Y=108230 $dt=16
M5305 206 35 1 1 pfet_01v8 L=1.5e-07 W=1.13e-06 $X=157220 $Y=114200 $dt=16
M5306 1 112 226 1 pfet_01v8 L=1.5e-07 W=1.13e-06 $X=157220 $Y=116510 $dt=16
M5307 207 36 1 1 pfet_01v8 L=1.5e-07 W=1.13e-06 $X=157220 $Y=122480 $dt=16
M5308 1 113 227 1 pfet_01v8 L=1.5e-07 W=1.13e-06 $X=157220 $Y=124790 $dt=16
M5309 208 37 1 1 pfet_01v8 L=1.5e-07 W=1.13e-06 $X=157220 $Y=130760 $dt=16
M5310 1 114 228 1 pfet_01v8 L=1.5e-07 W=1.13e-06 $X=157220 $Y=133070 $dt=16
M5311 209 38 1 1 pfet_01v8 L=1.5e-07 W=1.13e-06 $X=157220 $Y=139040 $dt=16
M5312 1 115 229 1 pfet_01v8 L=1.5e-07 W=1.13e-06 $X=157220 $Y=141350 $dt=16
M5313 210 39 1 1 pfet_01v8 L=1.5e-07 W=1.13e-06 $X=157220 $Y=147320 $dt=16
M5314 1 116 230 1 pfet_01v8 L=1.5e-07 W=1.13e-06 $X=157220 $Y=149630 $dt=16
M5315 211 40 1 1 pfet_01v8 L=1.5e-07 W=1.13e-06 $X=157220 $Y=155600 $dt=16
M5316 1 117 231 1 pfet_01v8 L=1.5e-07 W=1.13e-06 $X=157220 $Y=157910 $dt=16
M5317 212 41 1 1 pfet_01v8 L=1.5e-07 W=1.13e-06 $X=157220 $Y=163880 $dt=16
M5318 175 23 1 1 pfet_01v8 L=1.5e-07 W=1.13e-06 $X=158230 $Y=8870 $dt=16
M5319 176 24 1 1 pfet_01v8 L=1.5e-07 W=1.13e-06 $X=158230 $Y=17150 $dt=16
M5320 177 25 1 1 pfet_01v8 L=1.5e-07 W=1.13e-06 $X=158230 $Y=25430 $dt=16
M5321 178 26 1 1 pfet_01v8 L=1.5e-07 W=1.13e-06 $X=158230 $Y=33710 $dt=16
M5322 179 27 1 1 pfet_01v8 L=1.5e-07 W=1.13e-06 $X=158230 $Y=41990 $dt=16
M5323 180 28 1 1 pfet_01v8 L=1.5e-07 W=1.13e-06 $X=158230 $Y=50270 $dt=16
M5324 181 29 1 1 pfet_01v8 L=1.5e-07 W=1.13e-06 $X=158230 $Y=58550 $dt=16
M5325 182 30 1 1 pfet_01v8 L=1.5e-07 W=1.13e-06 $X=158230 $Y=66830 $dt=16
M5326 183 31 1 1 pfet_01v8 L=1.5e-07 W=1.13e-06 $X=158230 $Y=75110 $dt=16
M5327 184 32 1 1 pfet_01v8 L=1.5e-07 W=1.13e-06 $X=158230 $Y=83390 $dt=16
M5328 185 33 1 1 pfet_01v8 L=1.5e-07 W=1.13e-06 $X=158230 $Y=91670 $dt=16
M5329 186 34 1 1 pfet_01v8 L=1.5e-07 W=1.13e-06 $X=158230 $Y=99950 $dt=16
M5330 187 35 1 1 pfet_01v8 L=1.5e-07 W=1.13e-06 $X=158230 $Y=108230 $dt=16
M5331 188 36 1 1 pfet_01v8 L=1.5e-07 W=1.13e-06 $X=158230 $Y=116510 $dt=16
M5332 189 37 1 1 pfet_01v8 L=1.5e-07 W=1.13e-06 $X=158230 $Y=124790 $dt=16
M5333 190 38 1 1 pfet_01v8 L=1.5e-07 W=1.13e-06 $X=158230 $Y=133070 $dt=16
M5334 191 39 1 1 pfet_01v8 L=1.5e-07 W=1.13e-06 $X=158230 $Y=141350 $dt=16
M5335 192 40 1 1 pfet_01v8 L=1.5e-07 W=1.13e-06 $X=158230 $Y=149630 $dt=16
M5336 193 41 1 1 pfet_01v8 L=1.5e-07 W=1.13e-06 $X=158230 $Y=157910 $dt=16
M5337 156 137 1 1 pfet_01v8 L=1.5e-07 W=1.13e-06 $X=158260 $Y=14840 $dt=16
M5338 157 138 1 1 pfet_01v8 L=1.5e-07 W=1.13e-06 $X=158260 $Y=23120 $dt=16
M5339 158 139 1 1 pfet_01v8 L=1.5e-07 W=1.13e-06 $X=158260 $Y=31400 $dt=16
M5340 159 140 1 1 pfet_01v8 L=1.5e-07 W=1.13e-06 $X=158260 $Y=39680 $dt=16
M5341 160 141 1 1 pfet_01v8 L=1.5e-07 W=1.13e-06 $X=158260 $Y=47960 $dt=16
M5342 161 142 1 1 pfet_01v8 L=1.5e-07 W=1.13e-06 $X=158260 $Y=56240 $dt=16
M5343 162 143 1 1 pfet_01v8 L=1.5e-07 W=1.13e-06 $X=158260 $Y=64520 $dt=16
M5344 163 144 1 1 pfet_01v8 L=1.5e-07 W=1.13e-06 $X=158260 $Y=72800 $dt=16
M5345 164 145 1 1 pfet_01v8 L=1.5e-07 W=1.13e-06 $X=158260 $Y=81080 $dt=16
M5346 165 146 1 1 pfet_01v8 L=1.5e-07 W=1.13e-06 $X=158260 $Y=89360 $dt=16
M5347 166 147 1 1 pfet_01v8 L=1.5e-07 W=1.13e-06 $X=158260 $Y=97640 $dt=16
M5348 167 148 1 1 pfet_01v8 L=1.5e-07 W=1.13e-06 $X=158260 $Y=105920 $dt=16
M5349 168 149 1 1 pfet_01v8 L=1.5e-07 W=1.13e-06 $X=158260 $Y=114200 $dt=16
M5350 169 150 1 1 pfet_01v8 L=1.5e-07 W=1.13e-06 $X=158260 $Y=122480 $dt=16
M5351 170 151 1 1 pfet_01v8 L=1.5e-07 W=1.13e-06 $X=158260 $Y=130760 $dt=16
M5352 171 152 1 1 pfet_01v8 L=1.5e-07 W=1.13e-06 $X=158260 $Y=139040 $dt=16
M5353 172 153 1 1 pfet_01v8 L=1.5e-07 W=1.13e-06 $X=158260 $Y=147320 $dt=16
M5354 173 154 1 1 pfet_01v8 L=1.5e-07 W=1.13e-06 $X=158260 $Y=155600 $dt=16
M5355 174 155 1 1 pfet_01v8 L=1.5e-07 W=1.13e-06 $X=158260 $Y=163880 $dt=16
M5356 1 23 175 1 pfet_01v8 L=1.5e-07 W=1.13e-06 $X=158660 $Y=8870 $dt=16
M5357 1 24 176 1 pfet_01v8 L=1.5e-07 W=1.13e-06 $X=158660 $Y=17150 $dt=16
M5358 1 25 177 1 pfet_01v8 L=1.5e-07 W=1.13e-06 $X=158660 $Y=25430 $dt=16
M5359 1 26 178 1 pfet_01v8 L=1.5e-07 W=1.13e-06 $X=158660 $Y=33710 $dt=16
M5360 1 27 179 1 pfet_01v8 L=1.5e-07 W=1.13e-06 $X=158660 $Y=41990 $dt=16
M5361 1 28 180 1 pfet_01v8 L=1.5e-07 W=1.13e-06 $X=158660 $Y=50270 $dt=16
M5362 1 29 181 1 pfet_01v8 L=1.5e-07 W=1.13e-06 $X=158660 $Y=58550 $dt=16
M5363 1 30 182 1 pfet_01v8 L=1.5e-07 W=1.13e-06 $X=158660 $Y=66830 $dt=16
M5364 1 31 183 1 pfet_01v8 L=1.5e-07 W=1.13e-06 $X=158660 $Y=75110 $dt=16
M5365 1 32 184 1 pfet_01v8 L=1.5e-07 W=1.13e-06 $X=158660 $Y=83390 $dt=16
M5366 1 33 185 1 pfet_01v8 L=1.5e-07 W=1.13e-06 $X=158660 $Y=91670 $dt=16
M5367 1 34 186 1 pfet_01v8 L=1.5e-07 W=1.13e-06 $X=158660 $Y=99950 $dt=16
M5368 1 35 187 1 pfet_01v8 L=1.5e-07 W=1.13e-06 $X=158660 $Y=108230 $dt=16
M5369 1 36 188 1 pfet_01v8 L=1.5e-07 W=1.13e-06 $X=158660 $Y=116510 $dt=16
M5370 1 37 189 1 pfet_01v8 L=1.5e-07 W=1.13e-06 $X=158660 $Y=124790 $dt=16
M5371 1 38 190 1 pfet_01v8 L=1.5e-07 W=1.13e-06 $X=158660 $Y=133070 $dt=16
M5372 1 39 191 1 pfet_01v8 L=1.5e-07 W=1.13e-06 $X=158660 $Y=141350 $dt=16
M5373 1 40 192 1 pfet_01v8 L=1.5e-07 W=1.13e-06 $X=158660 $Y=149630 $dt=16
M5374 1 41 193 1 pfet_01v8 L=1.5e-07 W=1.13e-06 $X=158660 $Y=157910 $dt=16
M5375 1 137 156 1 pfet_01v8 L=1.5e-07 W=1.13e-06 $X=158690 $Y=14840 $dt=16
M5376 1 138 157 1 pfet_01v8 L=1.5e-07 W=1.13e-06 $X=158690 $Y=23120 $dt=16
M5377 1 139 158 1 pfet_01v8 L=1.5e-07 W=1.13e-06 $X=158690 $Y=31400 $dt=16
M5378 1 140 159 1 pfet_01v8 L=1.5e-07 W=1.13e-06 $X=158690 $Y=39680 $dt=16
M5379 1 141 160 1 pfet_01v8 L=1.5e-07 W=1.13e-06 $X=158690 $Y=47960 $dt=16
M5380 1 142 161 1 pfet_01v8 L=1.5e-07 W=1.13e-06 $X=158690 $Y=56240 $dt=16
M5381 1 143 162 1 pfet_01v8 L=1.5e-07 W=1.13e-06 $X=158690 $Y=64520 $dt=16
M5382 1 144 163 1 pfet_01v8 L=1.5e-07 W=1.13e-06 $X=158690 $Y=72800 $dt=16
M5383 1 145 164 1 pfet_01v8 L=1.5e-07 W=1.13e-06 $X=158690 $Y=81080 $dt=16
M5384 1 146 165 1 pfet_01v8 L=1.5e-07 W=1.13e-06 $X=158690 $Y=89360 $dt=16
M5385 1 147 166 1 pfet_01v8 L=1.5e-07 W=1.13e-06 $X=158690 $Y=97640 $dt=16
M5386 1 148 167 1 pfet_01v8 L=1.5e-07 W=1.13e-06 $X=158690 $Y=105920 $dt=16
M5387 1 149 168 1 pfet_01v8 L=1.5e-07 W=1.13e-06 $X=158690 $Y=114200 $dt=16
M5388 1 150 169 1 pfet_01v8 L=1.5e-07 W=1.13e-06 $X=158690 $Y=122480 $dt=16
M5389 1 151 170 1 pfet_01v8 L=1.5e-07 W=1.13e-06 $X=158690 $Y=130760 $dt=16
M5390 1 152 171 1 pfet_01v8 L=1.5e-07 W=1.13e-06 $X=158690 $Y=139040 $dt=16
M5391 1 153 172 1 pfet_01v8 L=1.5e-07 W=1.13e-06 $X=158690 $Y=147320 $dt=16
M5392 1 154 173 1 pfet_01v8 L=1.5e-07 W=1.13e-06 $X=158690 $Y=155600 $dt=16
M5393 1 155 174 1 pfet_01v8 L=1.5e-07 W=1.13e-06 $X=158690 $Y=163880 $dt=16
M5394 175 23 1 1 pfet_01v8 L=1.5e-07 W=1.13e-06 $X=159090 $Y=8870 $dt=16
M5395 176 24 1 1 pfet_01v8 L=1.5e-07 W=1.13e-06 $X=159090 $Y=17150 $dt=16
M5396 177 25 1 1 pfet_01v8 L=1.5e-07 W=1.13e-06 $X=159090 $Y=25430 $dt=16
M5397 178 26 1 1 pfet_01v8 L=1.5e-07 W=1.13e-06 $X=159090 $Y=33710 $dt=16
M5398 179 27 1 1 pfet_01v8 L=1.5e-07 W=1.13e-06 $X=159090 $Y=41990 $dt=16
M5399 180 28 1 1 pfet_01v8 L=1.5e-07 W=1.13e-06 $X=159090 $Y=50270 $dt=16
M5400 181 29 1 1 pfet_01v8 L=1.5e-07 W=1.13e-06 $X=159090 $Y=58550 $dt=16
M5401 182 30 1 1 pfet_01v8 L=1.5e-07 W=1.13e-06 $X=159090 $Y=66830 $dt=16
M5402 183 31 1 1 pfet_01v8 L=1.5e-07 W=1.13e-06 $X=159090 $Y=75110 $dt=16
M5403 184 32 1 1 pfet_01v8 L=1.5e-07 W=1.13e-06 $X=159090 $Y=83390 $dt=16
M5404 185 33 1 1 pfet_01v8 L=1.5e-07 W=1.13e-06 $X=159090 $Y=91670 $dt=16
M5405 186 34 1 1 pfet_01v8 L=1.5e-07 W=1.13e-06 $X=159090 $Y=99950 $dt=16
M5406 187 35 1 1 pfet_01v8 L=1.5e-07 W=1.13e-06 $X=159090 $Y=108230 $dt=16
M5407 188 36 1 1 pfet_01v8 L=1.5e-07 W=1.13e-06 $X=159090 $Y=116510 $dt=16
M5408 189 37 1 1 pfet_01v8 L=1.5e-07 W=1.13e-06 $X=159090 $Y=124790 $dt=16
M5409 190 38 1 1 pfet_01v8 L=1.5e-07 W=1.13e-06 $X=159090 $Y=133070 $dt=16
M5410 191 39 1 1 pfet_01v8 L=1.5e-07 W=1.13e-06 $X=159090 $Y=141350 $dt=16
M5411 192 40 1 1 pfet_01v8 L=1.5e-07 W=1.13e-06 $X=159090 $Y=149630 $dt=16
M5412 193 41 1 1 pfet_01v8 L=1.5e-07 W=1.13e-06 $X=159090 $Y=157910 $dt=16
M5413 156 137 1 1 pfet_01v8 L=1.5e-07 W=1.13e-06 $X=159120 $Y=14840 $dt=16
M5414 157 138 1 1 pfet_01v8 L=1.5e-07 W=1.13e-06 $X=159120 $Y=23120 $dt=16
M5415 158 139 1 1 pfet_01v8 L=1.5e-07 W=1.13e-06 $X=159120 $Y=31400 $dt=16
M5416 159 140 1 1 pfet_01v8 L=1.5e-07 W=1.13e-06 $X=159120 $Y=39680 $dt=16
M5417 160 141 1 1 pfet_01v8 L=1.5e-07 W=1.13e-06 $X=159120 $Y=47960 $dt=16
M5418 161 142 1 1 pfet_01v8 L=1.5e-07 W=1.13e-06 $X=159120 $Y=56240 $dt=16
M5419 162 143 1 1 pfet_01v8 L=1.5e-07 W=1.13e-06 $X=159120 $Y=64520 $dt=16
M5420 163 144 1 1 pfet_01v8 L=1.5e-07 W=1.13e-06 $X=159120 $Y=72800 $dt=16
M5421 164 145 1 1 pfet_01v8 L=1.5e-07 W=1.13e-06 $X=159120 $Y=81080 $dt=16
M5422 165 146 1 1 pfet_01v8 L=1.5e-07 W=1.13e-06 $X=159120 $Y=89360 $dt=16
M5423 166 147 1 1 pfet_01v8 L=1.5e-07 W=1.13e-06 $X=159120 $Y=97640 $dt=16
M5424 167 148 1 1 pfet_01v8 L=1.5e-07 W=1.13e-06 $X=159120 $Y=105920 $dt=16
M5425 168 149 1 1 pfet_01v8 L=1.5e-07 W=1.13e-06 $X=159120 $Y=114200 $dt=16
M5426 169 150 1 1 pfet_01v8 L=1.5e-07 W=1.13e-06 $X=159120 $Y=122480 $dt=16
M5427 170 151 1 1 pfet_01v8 L=1.5e-07 W=1.13e-06 $X=159120 $Y=130760 $dt=16
M5428 171 152 1 1 pfet_01v8 L=1.5e-07 W=1.13e-06 $X=159120 $Y=139040 $dt=16
M5429 172 153 1 1 pfet_01v8 L=1.5e-07 W=1.13e-06 $X=159120 $Y=147320 $dt=16
M5430 173 154 1 1 pfet_01v8 L=1.5e-07 W=1.13e-06 $X=159120 $Y=155600 $dt=16
M5431 174 155 1 1 pfet_01v8 L=1.5e-07 W=1.13e-06 $X=159120 $Y=163880 $dt=16
M5432 1 23 175 1 pfet_01v8 L=1.5e-07 W=1.13e-06 $X=159520 $Y=8870 $dt=16
M5433 1 24 176 1 pfet_01v8 L=1.5e-07 W=1.13e-06 $X=159520 $Y=17150 $dt=16
M5434 1 25 177 1 pfet_01v8 L=1.5e-07 W=1.13e-06 $X=159520 $Y=25430 $dt=16
M5435 1 26 178 1 pfet_01v8 L=1.5e-07 W=1.13e-06 $X=159520 $Y=33710 $dt=16
M5436 1 27 179 1 pfet_01v8 L=1.5e-07 W=1.13e-06 $X=159520 $Y=41990 $dt=16
M5437 1 28 180 1 pfet_01v8 L=1.5e-07 W=1.13e-06 $X=159520 $Y=50270 $dt=16
M5438 1 29 181 1 pfet_01v8 L=1.5e-07 W=1.13e-06 $X=159520 $Y=58550 $dt=16
M5439 1 30 182 1 pfet_01v8 L=1.5e-07 W=1.13e-06 $X=159520 $Y=66830 $dt=16
M5440 1 31 183 1 pfet_01v8 L=1.5e-07 W=1.13e-06 $X=159520 $Y=75110 $dt=16
M5441 1 32 184 1 pfet_01v8 L=1.5e-07 W=1.13e-06 $X=159520 $Y=83390 $dt=16
M5442 1 33 185 1 pfet_01v8 L=1.5e-07 W=1.13e-06 $X=159520 $Y=91670 $dt=16
M5443 1 34 186 1 pfet_01v8 L=1.5e-07 W=1.13e-06 $X=159520 $Y=99950 $dt=16
M5444 1 35 187 1 pfet_01v8 L=1.5e-07 W=1.13e-06 $X=159520 $Y=108230 $dt=16
M5445 1 36 188 1 pfet_01v8 L=1.5e-07 W=1.13e-06 $X=159520 $Y=116510 $dt=16
M5446 1 37 189 1 pfet_01v8 L=1.5e-07 W=1.13e-06 $X=159520 $Y=124790 $dt=16
M5447 1 38 190 1 pfet_01v8 L=1.5e-07 W=1.13e-06 $X=159520 $Y=133070 $dt=16
M5448 1 39 191 1 pfet_01v8 L=1.5e-07 W=1.13e-06 $X=159520 $Y=141350 $dt=16
M5449 1 40 192 1 pfet_01v8 L=1.5e-07 W=1.13e-06 $X=159520 $Y=149630 $dt=16
M5450 1 41 193 1 pfet_01v8 L=1.5e-07 W=1.13e-06 $X=159520 $Y=157910 $dt=16
M5451 1 137 156 1 pfet_01v8 L=1.5e-07 W=1.13e-06 $X=159550 $Y=14840 $dt=16
M5452 1 138 157 1 pfet_01v8 L=1.5e-07 W=1.13e-06 $X=159550 $Y=23120 $dt=16
M5453 1 139 158 1 pfet_01v8 L=1.5e-07 W=1.13e-06 $X=159550 $Y=31400 $dt=16
M5454 1 140 159 1 pfet_01v8 L=1.5e-07 W=1.13e-06 $X=159550 $Y=39680 $dt=16
M5455 1 141 160 1 pfet_01v8 L=1.5e-07 W=1.13e-06 $X=159550 $Y=47960 $dt=16
M5456 1 142 161 1 pfet_01v8 L=1.5e-07 W=1.13e-06 $X=159550 $Y=56240 $dt=16
M5457 1 143 162 1 pfet_01v8 L=1.5e-07 W=1.13e-06 $X=159550 $Y=64520 $dt=16
M5458 1 144 163 1 pfet_01v8 L=1.5e-07 W=1.13e-06 $X=159550 $Y=72800 $dt=16
M5459 1 145 164 1 pfet_01v8 L=1.5e-07 W=1.13e-06 $X=159550 $Y=81080 $dt=16
M5460 1 146 165 1 pfet_01v8 L=1.5e-07 W=1.13e-06 $X=159550 $Y=89360 $dt=16
M5461 1 147 166 1 pfet_01v8 L=1.5e-07 W=1.13e-06 $X=159550 $Y=97640 $dt=16
M5462 1 148 167 1 pfet_01v8 L=1.5e-07 W=1.13e-06 $X=159550 $Y=105920 $dt=16
M5463 1 149 168 1 pfet_01v8 L=1.5e-07 W=1.13e-06 $X=159550 $Y=114200 $dt=16
M5464 1 150 169 1 pfet_01v8 L=1.5e-07 W=1.13e-06 $X=159550 $Y=122480 $dt=16
M5465 1 151 170 1 pfet_01v8 L=1.5e-07 W=1.13e-06 $X=159550 $Y=130760 $dt=16
M5466 1 152 171 1 pfet_01v8 L=1.5e-07 W=1.13e-06 $X=159550 $Y=139040 $dt=16
M5467 1 153 172 1 pfet_01v8 L=1.5e-07 W=1.13e-06 $X=159550 $Y=147320 $dt=16
M5468 1 154 173 1 pfet_01v8 L=1.5e-07 W=1.13e-06 $X=159550 $Y=155600 $dt=16
M5469 1 155 174 1 pfet_01v8 L=1.5e-07 W=1.13e-06 $X=159550 $Y=163880 $dt=16
M5470 137 99 1 1 pfet_01v8 L=1.5e-07 W=1.13e-06 $X=159980 $Y=14840 $dt=16
M5471 138 100 1 1 pfet_01v8 L=1.5e-07 W=1.13e-06 $X=159980 $Y=23120 $dt=16
M5472 139 101 1 1 pfet_01v8 L=1.5e-07 W=1.13e-06 $X=159980 $Y=31400 $dt=16
M5473 140 102 1 1 pfet_01v8 L=1.5e-07 W=1.13e-06 $X=159980 $Y=39680 $dt=16
M5474 141 103 1 1 pfet_01v8 L=1.5e-07 W=1.13e-06 $X=159980 $Y=47960 $dt=16
M5475 142 104 1 1 pfet_01v8 L=1.5e-07 W=1.13e-06 $X=159980 $Y=56240 $dt=16
M5476 143 105 1 1 pfet_01v8 L=1.5e-07 W=1.13e-06 $X=159980 $Y=64520 $dt=16
M5477 144 106 1 1 pfet_01v8 L=1.5e-07 W=1.13e-06 $X=159980 $Y=72800 $dt=16
M5478 145 107 1 1 pfet_01v8 L=1.5e-07 W=1.13e-06 $X=159980 $Y=81080 $dt=16
M5479 146 108 1 1 pfet_01v8 L=1.5e-07 W=1.13e-06 $X=159980 $Y=89360 $dt=16
M5480 147 109 1 1 pfet_01v8 L=1.5e-07 W=1.13e-06 $X=159980 $Y=97640 $dt=16
M5481 148 110 1 1 pfet_01v8 L=1.5e-07 W=1.13e-06 $X=159980 $Y=105920 $dt=16
M5482 149 111 1 1 pfet_01v8 L=1.5e-07 W=1.13e-06 $X=159980 $Y=114200 $dt=16
M5483 150 112 1 1 pfet_01v8 L=1.5e-07 W=1.13e-06 $X=159980 $Y=122480 $dt=16
M5484 151 113 1 1 pfet_01v8 L=1.5e-07 W=1.13e-06 $X=159980 $Y=130760 $dt=16
M5485 152 114 1 1 pfet_01v8 L=1.5e-07 W=1.13e-06 $X=159980 $Y=139040 $dt=16
M5486 153 115 1 1 pfet_01v8 L=1.5e-07 W=1.13e-06 $X=159980 $Y=147320 $dt=16
M5487 154 116 1 1 pfet_01v8 L=1.5e-07 W=1.13e-06 $X=159980 $Y=155600 $dt=16
M5488 155 117 1 1 pfet_01v8 L=1.5e-07 W=1.13e-06 $X=159980 $Y=163880 $dt=16
M5489 1 80 118 1 pfet_01v8 L=1.5e-07 W=1.13e-06 $X=160900 $Y=8870 $dt=16
M5490 1 81 119 1 pfet_01v8 L=1.5e-07 W=1.13e-06 $X=160900 $Y=17150 $dt=16
M5491 1 82 120 1 pfet_01v8 L=1.5e-07 W=1.13e-06 $X=160900 $Y=25430 $dt=16
M5492 1 83 121 1 pfet_01v8 L=1.5e-07 W=1.13e-06 $X=160900 $Y=33710 $dt=16
M5493 1 84 122 1 pfet_01v8 L=1.5e-07 W=1.13e-06 $X=160900 $Y=41990 $dt=16
M5494 1 85 123 1 pfet_01v8 L=1.5e-07 W=1.13e-06 $X=160900 $Y=50270 $dt=16
M5495 1 86 124 1 pfet_01v8 L=1.5e-07 W=1.13e-06 $X=160900 $Y=58550 $dt=16
M5496 1 87 125 1 pfet_01v8 L=1.5e-07 W=1.13e-06 $X=160900 $Y=66830 $dt=16
M5497 1 88 126 1 pfet_01v8 L=1.5e-07 W=1.13e-06 $X=160900 $Y=75110 $dt=16
M5498 1 89 127 1 pfet_01v8 L=1.5e-07 W=1.13e-06 $X=160900 $Y=83390 $dt=16
M5499 1 90 128 1 pfet_01v8 L=1.5e-07 W=1.13e-06 $X=160900 $Y=91670 $dt=16
M5500 1 91 129 1 pfet_01v8 L=1.5e-07 W=1.13e-06 $X=160900 $Y=99950 $dt=16
M5501 1 92 130 1 pfet_01v8 L=1.5e-07 W=1.13e-06 $X=160900 $Y=108230 $dt=16
M5502 1 93 131 1 pfet_01v8 L=1.5e-07 W=1.13e-06 $X=160900 $Y=116510 $dt=16
M5503 1 94 132 1 pfet_01v8 L=1.5e-07 W=1.13e-06 $X=160900 $Y=124790 $dt=16
M5504 1 95 133 1 pfet_01v8 L=1.5e-07 W=1.13e-06 $X=160900 $Y=133070 $dt=16
M5505 1 96 134 1 pfet_01v8 L=1.5e-07 W=1.13e-06 $X=160900 $Y=141350 $dt=16
M5506 1 97 135 1 pfet_01v8 L=1.5e-07 W=1.13e-06 $X=160900 $Y=149630 $dt=16
M5507 1 98 136 1 pfet_01v8 L=1.5e-07 W=1.13e-06 $X=160900 $Y=157910 $dt=16
M5508 1 61 99 1 pfet_01v8 L=1.5e-07 W=1.13e-06 $X=161360 $Y=14840 $dt=16
M5509 1 62 100 1 pfet_01v8 L=1.5e-07 W=1.13e-06 $X=161360 $Y=23120 $dt=16
M5510 1 63 101 1 pfet_01v8 L=1.5e-07 W=1.13e-06 $X=161360 $Y=31400 $dt=16
M5511 1 64 102 1 pfet_01v8 L=1.5e-07 W=1.13e-06 $X=161360 $Y=39680 $dt=16
M5512 1 65 103 1 pfet_01v8 L=1.5e-07 W=1.13e-06 $X=161360 $Y=47960 $dt=16
M5513 1 66 104 1 pfet_01v8 L=1.5e-07 W=1.13e-06 $X=161360 $Y=56240 $dt=16
M5514 1 67 105 1 pfet_01v8 L=1.5e-07 W=1.13e-06 $X=161360 $Y=64520 $dt=16
M5515 1 68 106 1 pfet_01v8 L=1.5e-07 W=1.13e-06 $X=161360 $Y=72800 $dt=16
M5516 1 69 107 1 pfet_01v8 L=1.5e-07 W=1.13e-06 $X=161360 $Y=81080 $dt=16
M5517 1 70 108 1 pfet_01v8 L=1.5e-07 W=1.13e-06 $X=161360 $Y=89360 $dt=16
M5518 1 71 109 1 pfet_01v8 L=1.5e-07 W=1.13e-06 $X=161360 $Y=97640 $dt=16
M5519 1 72 110 1 pfet_01v8 L=1.5e-07 W=1.13e-06 $X=161360 $Y=105920 $dt=16
M5520 1 73 111 1 pfet_01v8 L=1.5e-07 W=1.13e-06 $X=161360 $Y=114200 $dt=16
M5521 1 74 112 1 pfet_01v8 L=1.5e-07 W=1.13e-06 $X=161360 $Y=122480 $dt=16
M5522 1 75 113 1 pfet_01v8 L=1.5e-07 W=1.13e-06 $X=161360 $Y=130760 $dt=16
M5523 1 76 114 1 pfet_01v8 L=1.5e-07 W=1.13e-06 $X=161360 $Y=139040 $dt=16
M5524 1 77 115 1 pfet_01v8 L=1.5e-07 W=1.13e-06 $X=161360 $Y=147320 $dt=16
M5525 1 78 116 1 pfet_01v8 L=1.5e-07 W=1.13e-06 $X=161360 $Y=155600 $dt=16
M5526 1 79 117 1 pfet_01v8 L=1.5e-07 W=1.13e-06 $X=161360 $Y=163880 $dt=16
M5527 80 42 1 1 pfet_01v8 L=1.5e-07 W=6.25e-07 $X=161390 $Y=8870 $dt=16
M5528 81 43 1 1 pfet_01v8 L=1.5e-07 W=6.25e-07 $X=161390 $Y=17150 $dt=16
M5529 82 44 1 1 pfet_01v8 L=1.5e-07 W=6.25e-07 $X=161390 $Y=25430 $dt=16
M5530 83 45 1 1 pfet_01v8 L=1.5e-07 W=6.25e-07 $X=161390 $Y=33710 $dt=16
M5531 84 46 1 1 pfet_01v8 L=1.5e-07 W=6.25e-07 $X=161390 $Y=41990 $dt=16
M5532 85 47 1 1 pfet_01v8 L=1.5e-07 W=6.25e-07 $X=161390 $Y=50270 $dt=16
M5533 86 48 1 1 pfet_01v8 L=1.5e-07 W=6.25e-07 $X=161390 $Y=58550 $dt=16
M5534 87 49 1 1 pfet_01v8 L=1.5e-07 W=6.25e-07 $X=161390 $Y=66830 $dt=16
M5535 88 50 1 1 pfet_01v8 L=1.5e-07 W=6.25e-07 $X=161390 $Y=75110 $dt=16
M5536 89 51 1 1 pfet_01v8 L=1.5e-07 W=6.25e-07 $X=161390 $Y=83390 $dt=16
M5537 90 52 1 1 pfet_01v8 L=1.5e-07 W=6.25e-07 $X=161390 $Y=91670 $dt=16
M5538 91 53 1 1 pfet_01v8 L=1.5e-07 W=6.25e-07 $X=161390 $Y=99950 $dt=16
M5539 92 54 1 1 pfet_01v8 L=1.5e-07 W=6.25e-07 $X=161390 $Y=108230 $dt=16
M5540 93 55 1 1 pfet_01v8 L=1.5e-07 W=6.25e-07 $X=161390 $Y=116510 $dt=16
M5541 94 56 1 1 pfet_01v8 L=1.5e-07 W=6.25e-07 $X=161390 $Y=124790 $dt=16
M5542 95 57 1 1 pfet_01v8 L=1.5e-07 W=6.25e-07 $X=161390 $Y=133070 $dt=16
M5543 96 58 1 1 pfet_01v8 L=1.5e-07 W=6.25e-07 $X=161390 $Y=141350 $dt=16
M5544 97 59 1 1 pfet_01v8 L=1.5e-07 W=6.25e-07 $X=161390 $Y=149630 $dt=16
M5545 98 60 1 1 pfet_01v8 L=1.5e-07 W=6.25e-07 $X=161390 $Y=157910 $dt=16
M5546 1 2 80 1 pfet_01v8 L=1.5e-07 W=6.25e-07 $X=161820 $Y=8870 $dt=16
M5547 1 2 81 1 pfet_01v8 L=1.5e-07 W=6.25e-07 $X=161820 $Y=17150 $dt=16
M5548 1 2 82 1 pfet_01v8 L=1.5e-07 W=6.25e-07 $X=161820 $Y=25430 $dt=16
M5549 1 2 83 1 pfet_01v8 L=1.5e-07 W=6.25e-07 $X=161820 $Y=33710 $dt=16
M5550 1 2 84 1 pfet_01v8 L=1.5e-07 W=6.25e-07 $X=161820 $Y=41990 $dt=16
M5551 1 2 85 1 pfet_01v8 L=1.5e-07 W=6.25e-07 $X=161820 $Y=50270 $dt=16
M5552 1 2 86 1 pfet_01v8 L=1.5e-07 W=6.25e-07 $X=161820 $Y=58550 $dt=16
M5553 1 2 87 1 pfet_01v8 L=1.5e-07 W=6.25e-07 $X=161820 $Y=66830 $dt=16
M5554 1 2 88 1 pfet_01v8 L=1.5e-07 W=6.25e-07 $X=161820 $Y=75110 $dt=16
M5555 1 2 89 1 pfet_01v8 L=1.5e-07 W=6.25e-07 $X=161820 $Y=83390 $dt=16
M5556 1 2 90 1 pfet_01v8 L=1.5e-07 W=6.25e-07 $X=161820 $Y=91670 $dt=16
M5557 1 2 91 1 pfet_01v8 L=1.5e-07 W=6.25e-07 $X=161820 $Y=99950 $dt=16
M5558 1 2 92 1 pfet_01v8 L=1.5e-07 W=6.25e-07 $X=161820 $Y=108230 $dt=16
M5559 1 2 93 1 pfet_01v8 L=1.5e-07 W=6.25e-07 $X=161820 $Y=116510 $dt=16
M5560 1 2 94 1 pfet_01v8 L=1.5e-07 W=6.25e-07 $X=161820 $Y=124790 $dt=16
M5561 1 2 95 1 pfet_01v8 L=1.5e-07 W=6.25e-07 $X=161820 $Y=133070 $dt=16
M5562 1 2 96 1 pfet_01v8 L=1.5e-07 W=6.25e-07 $X=161820 $Y=141350 $dt=16
M5563 1 2 97 1 pfet_01v8 L=1.5e-07 W=6.25e-07 $X=161820 $Y=149630 $dt=16
M5564 1 2 98 1 pfet_01v8 L=1.5e-07 W=6.25e-07 $X=161820 $Y=157910 $dt=16
M5565 61 42 1 1 pfet_01v8 L=1.5e-07 W=6.25e-07 $X=161850 $Y=15345 $dt=16
M5566 62 43 1 1 pfet_01v8 L=1.5e-07 W=6.25e-07 $X=161850 $Y=23625 $dt=16
M5567 63 44 1 1 pfet_01v8 L=1.5e-07 W=6.25e-07 $X=161850 $Y=31905 $dt=16
M5568 64 45 1 1 pfet_01v8 L=1.5e-07 W=6.25e-07 $X=161850 $Y=40185 $dt=16
M5569 65 46 1 1 pfet_01v8 L=1.5e-07 W=6.25e-07 $X=161850 $Y=48465 $dt=16
M5570 66 47 1 1 pfet_01v8 L=1.5e-07 W=6.25e-07 $X=161850 $Y=56745 $dt=16
M5571 67 48 1 1 pfet_01v8 L=1.5e-07 W=6.25e-07 $X=161850 $Y=65025 $dt=16
M5572 68 49 1 1 pfet_01v8 L=1.5e-07 W=6.25e-07 $X=161850 $Y=73305 $dt=16
M5573 69 50 1 1 pfet_01v8 L=1.5e-07 W=6.25e-07 $X=161850 $Y=81585 $dt=16
M5574 70 51 1 1 pfet_01v8 L=1.5e-07 W=6.25e-07 $X=161850 $Y=89865 $dt=16
M5575 71 52 1 1 pfet_01v8 L=1.5e-07 W=6.25e-07 $X=161850 $Y=98145 $dt=16
M5576 72 53 1 1 pfet_01v8 L=1.5e-07 W=6.25e-07 $X=161850 $Y=106425 $dt=16
M5577 73 54 1 1 pfet_01v8 L=1.5e-07 W=6.25e-07 $X=161850 $Y=114705 $dt=16
M5578 74 55 1 1 pfet_01v8 L=1.5e-07 W=6.25e-07 $X=161850 $Y=122985 $dt=16
M5579 75 56 1 1 pfet_01v8 L=1.5e-07 W=6.25e-07 $X=161850 $Y=131265 $dt=16
M5580 76 57 1 1 pfet_01v8 L=1.5e-07 W=6.25e-07 $X=161850 $Y=139545 $dt=16
M5581 77 58 1 1 pfet_01v8 L=1.5e-07 W=6.25e-07 $X=161850 $Y=147825 $dt=16
M5582 78 59 1 1 pfet_01v8 L=1.5e-07 W=6.25e-07 $X=161850 $Y=156105 $dt=16
M5583 79 60 1 1 pfet_01v8 L=1.5e-07 W=6.25e-07 $X=161850 $Y=164385 $dt=16
M5584 1 4 61 1 pfet_01v8 L=1.5e-07 W=6.25e-07 $X=162280 $Y=15345 $dt=16
M5585 1 5 62 1 pfet_01v8 L=1.5e-07 W=6.25e-07 $X=162280 $Y=23625 $dt=16
M5586 1 6 63 1 pfet_01v8 L=1.5e-07 W=6.25e-07 $X=162280 $Y=31905 $dt=16
M5587 1 7 64 1 pfet_01v8 L=1.5e-07 W=6.25e-07 $X=162280 $Y=40185 $dt=16
M5588 1 8 65 1 pfet_01v8 L=1.5e-07 W=6.25e-07 $X=162280 $Y=48465 $dt=16
M5589 1 9 66 1 pfet_01v8 L=1.5e-07 W=6.25e-07 $X=162280 $Y=56745 $dt=16
M5590 1 10 67 1 pfet_01v8 L=1.5e-07 W=6.25e-07 $X=162280 $Y=65025 $dt=16
M5591 1 11 68 1 pfet_01v8 L=1.5e-07 W=6.25e-07 $X=162280 $Y=73305 $dt=16
M5592 1 12 69 1 pfet_01v8 L=1.5e-07 W=6.25e-07 $X=162280 $Y=81585 $dt=16
M5593 1 13 70 1 pfet_01v8 L=1.5e-07 W=6.25e-07 $X=162280 $Y=89865 $dt=16
M5594 1 14 71 1 pfet_01v8 L=1.5e-07 W=6.25e-07 $X=162280 $Y=98145 $dt=16
M5595 1 15 72 1 pfet_01v8 L=1.5e-07 W=6.25e-07 $X=162280 $Y=106425 $dt=16
M5596 1 16 73 1 pfet_01v8 L=1.5e-07 W=6.25e-07 $X=162280 $Y=114705 $dt=16
M5597 1 17 74 1 pfet_01v8 L=1.5e-07 W=6.25e-07 $X=162280 $Y=122985 $dt=16
M5598 1 18 75 1 pfet_01v8 L=1.5e-07 W=6.25e-07 $X=162280 $Y=131265 $dt=16
M5599 1 19 76 1 pfet_01v8 L=1.5e-07 W=6.25e-07 $X=162280 $Y=139545 $dt=16
M5600 1 20 77 1 pfet_01v8 L=1.5e-07 W=6.25e-07 $X=162280 $Y=147825 $dt=16
M5601 1 21 78 1 pfet_01v8 L=1.5e-07 W=6.25e-07 $X=162280 $Y=156105 $dt=16
M5602 1 22 79 1 pfet_01v8 L=1.5e-07 W=6.25e-07 $X=162280 $Y=164385 $dt=16
M5603 872 42 23 1 pfet_01v8 L=1.5e-07 W=1.13e-06 $X=163150 $Y=8870 $dt=16
M5604 873 43 24 1 pfet_01v8 L=1.5e-07 W=1.13e-06 $X=163150 $Y=17150 $dt=16
M5605 874 44 25 1 pfet_01v8 L=1.5e-07 W=1.13e-06 $X=163150 $Y=25430 $dt=16
M5606 875 45 26 1 pfet_01v8 L=1.5e-07 W=1.13e-06 $X=163150 $Y=33710 $dt=16
M5607 876 46 27 1 pfet_01v8 L=1.5e-07 W=1.13e-06 $X=163150 $Y=41990 $dt=16
M5608 877 47 28 1 pfet_01v8 L=1.5e-07 W=1.13e-06 $X=163150 $Y=50270 $dt=16
M5609 878 48 29 1 pfet_01v8 L=1.5e-07 W=1.13e-06 $X=163150 $Y=58550 $dt=16
M5610 879 49 30 1 pfet_01v8 L=1.5e-07 W=1.13e-06 $X=163150 $Y=66830 $dt=16
M5611 880 50 31 1 pfet_01v8 L=1.5e-07 W=1.13e-06 $X=163150 $Y=75110 $dt=16
M5612 881 51 32 1 pfet_01v8 L=1.5e-07 W=1.13e-06 $X=163150 $Y=83390 $dt=16
M5613 882 52 33 1 pfet_01v8 L=1.5e-07 W=1.13e-06 $X=163150 $Y=91670 $dt=16
M5614 883 53 34 1 pfet_01v8 L=1.5e-07 W=1.13e-06 $X=163150 $Y=99950 $dt=16
M5615 884 54 35 1 pfet_01v8 L=1.5e-07 W=1.13e-06 $X=163150 $Y=108230 $dt=16
M5616 885 55 36 1 pfet_01v8 L=1.5e-07 W=1.13e-06 $X=163150 $Y=116510 $dt=16
M5617 886 56 37 1 pfet_01v8 L=1.5e-07 W=1.13e-06 $X=163150 $Y=124790 $dt=16
M5618 887 57 38 1 pfet_01v8 L=1.5e-07 W=1.13e-06 $X=163150 $Y=133070 $dt=16
M5619 888 58 39 1 pfet_01v8 L=1.5e-07 W=1.13e-06 $X=163150 $Y=141350 $dt=16
M5620 889 59 40 1 pfet_01v8 L=1.5e-07 W=1.13e-06 $X=163150 $Y=149630 $dt=16
M5621 890 60 41 1 pfet_01v8 L=1.5e-07 W=1.13e-06 $X=163150 $Y=157910 $dt=16
M5622 1 2 872 1 pfet_01v8 L=1.5e-07 W=1.13e-06 $X=163620 $Y=8870 $dt=16
M5623 1 2 873 1 pfet_01v8 L=1.5e-07 W=1.13e-06 $X=163620 $Y=17150 $dt=16
M5624 1 2 874 1 pfet_01v8 L=1.5e-07 W=1.13e-06 $X=163620 $Y=25430 $dt=16
M5625 1 2 875 1 pfet_01v8 L=1.5e-07 W=1.13e-06 $X=163620 $Y=33710 $dt=16
M5626 1 2 876 1 pfet_01v8 L=1.5e-07 W=1.13e-06 $X=163620 $Y=41990 $dt=16
M5627 1 2 877 1 pfet_01v8 L=1.5e-07 W=1.13e-06 $X=163620 $Y=50270 $dt=16
M5628 1 2 878 1 pfet_01v8 L=1.5e-07 W=1.13e-06 $X=163620 $Y=58550 $dt=16
M5629 1 2 879 1 pfet_01v8 L=1.5e-07 W=1.13e-06 $X=163620 $Y=66830 $dt=16
M5630 1 2 880 1 pfet_01v8 L=1.5e-07 W=1.13e-06 $X=163620 $Y=75110 $dt=16
M5631 1 2 881 1 pfet_01v8 L=1.5e-07 W=1.13e-06 $X=163620 $Y=83390 $dt=16
M5632 1 2 882 1 pfet_01v8 L=1.5e-07 W=1.13e-06 $X=163620 $Y=91670 $dt=16
M5633 1 2 883 1 pfet_01v8 L=1.5e-07 W=1.13e-06 $X=163620 $Y=99950 $dt=16
M5634 1 2 884 1 pfet_01v8 L=1.5e-07 W=1.13e-06 $X=163620 $Y=108230 $dt=16
M5635 1 2 885 1 pfet_01v8 L=1.5e-07 W=1.13e-06 $X=163620 $Y=116510 $dt=16
M5636 1 2 886 1 pfet_01v8 L=1.5e-07 W=1.13e-06 $X=163620 $Y=124790 $dt=16
M5637 1 2 887 1 pfet_01v8 L=1.5e-07 W=1.13e-06 $X=163620 $Y=133070 $dt=16
M5638 1 2 888 1 pfet_01v8 L=1.5e-07 W=1.13e-06 $X=163620 $Y=141350 $dt=16
M5639 1 2 889 1 pfet_01v8 L=1.5e-07 W=1.13e-06 $X=163620 $Y=149630 $dt=16
M5640 1 2 890 1 pfet_01v8 L=1.5e-07 W=1.13e-06 $X=163620 $Y=157910 $dt=16
M5641 1 2 4 1 pfet_01v8 L=1.5e-07 W=1.13e-06 $X=163660 $Y=14840 $dt=16
M5642 1 2 5 1 pfet_01v8 L=1.5e-07 W=1.13e-06 $X=163660 $Y=23120 $dt=16
M5643 1 2 6 1 pfet_01v8 L=1.5e-07 W=1.13e-06 $X=163660 $Y=31400 $dt=16
M5644 1 2 7 1 pfet_01v8 L=1.5e-07 W=1.13e-06 $X=163660 $Y=39680 $dt=16
M5645 1 2 8 1 pfet_01v8 L=1.5e-07 W=1.13e-06 $X=163660 $Y=47960 $dt=16
M5646 1 2 9 1 pfet_01v8 L=1.5e-07 W=1.13e-06 $X=163660 $Y=56240 $dt=16
M5647 1 2 10 1 pfet_01v8 L=1.5e-07 W=1.13e-06 $X=163660 $Y=64520 $dt=16
M5648 1 2 11 1 pfet_01v8 L=1.5e-07 W=1.13e-06 $X=163660 $Y=72800 $dt=16
M5649 1 2 12 1 pfet_01v8 L=1.5e-07 W=1.13e-06 $X=163660 $Y=81080 $dt=16
M5650 1 2 13 1 pfet_01v8 L=1.5e-07 W=1.13e-06 $X=163660 $Y=89360 $dt=16
M5651 1 2 14 1 pfet_01v8 L=1.5e-07 W=1.13e-06 $X=163660 $Y=97640 $dt=16
M5652 1 2 15 1 pfet_01v8 L=1.5e-07 W=1.13e-06 $X=163660 $Y=105920 $dt=16
M5653 1 2 16 1 pfet_01v8 L=1.5e-07 W=1.13e-06 $X=163660 $Y=114200 $dt=16
M5654 1 2 17 1 pfet_01v8 L=1.5e-07 W=1.13e-06 $X=163660 $Y=122480 $dt=16
M5655 1 2 18 1 pfet_01v8 L=1.5e-07 W=1.13e-06 $X=163660 $Y=130760 $dt=16
M5656 1 2 19 1 pfet_01v8 L=1.5e-07 W=1.13e-06 $X=163660 $Y=139040 $dt=16
M5657 1 2 20 1 pfet_01v8 L=1.5e-07 W=1.13e-06 $X=163660 $Y=147320 $dt=16
M5658 1 2 21 1 pfet_01v8 L=1.5e-07 W=1.13e-06 $X=163660 $Y=155600 $dt=16
M5659 1 2 22 1 pfet_01v8 L=1.5e-07 W=1.13e-06 $X=163660 $Y=163880 $dt=16
C5660 1 3 L=4e-06 W=4e-06 $[cap_mim_m3__base] $X=10705 $Y=2140 $dt=40
C5661 1 3 L=4e-06 W=4e-06 $[cap_mim_m3__base] $X=10705 $Y=10420 $dt=40
C5662 1 3 L=4e-06 W=4e-06 $[cap_mim_m3__base] $X=10705 $Y=18700 $dt=40
C5663 1 3 L=4e-06 W=4e-06 $[cap_mim_m3__base] $X=10705 $Y=26980 $dt=40
C5664 1 3 L=4e-06 W=4e-06 $[cap_mim_m3__base] $X=10705 $Y=35260 $dt=40
C5665 1 3 L=4e-06 W=4e-06 $[cap_mim_m3__base] $X=10705 $Y=43540 $dt=40
C5666 1 3 L=4e-06 W=4e-06 $[cap_mim_m3__base] $X=10705 $Y=51820 $dt=40
C5667 1 3 L=4e-06 W=4e-06 $[cap_mim_m3__base] $X=10705 $Y=60100 $dt=40
C5668 1 3 L=4e-06 W=4e-06 $[cap_mim_m3__base] $X=10705 $Y=68380 $dt=40
C5669 1 3 L=4e-06 W=4e-06 $[cap_mim_m3__base] $X=10705 $Y=76660 $dt=40
C5670 1 3 L=4e-06 W=4e-06 $[cap_mim_m3__base] $X=10705 $Y=84940 $dt=40
C5671 1 3 L=4e-06 W=4e-06 $[cap_mim_m3__base] $X=10705 $Y=93220 $dt=40
C5672 1 3 L=4e-06 W=4e-06 $[cap_mim_m3__base] $X=10705 $Y=101500 $dt=40
C5673 1 3 L=4e-06 W=4e-06 $[cap_mim_m3__base] $X=10705 $Y=109780 $dt=40
C5674 1 3 L=4e-06 W=4e-06 $[cap_mim_m3__base] $X=10705 $Y=118060 $dt=40
C5675 1 3 L=4e-06 W=4e-06 $[cap_mim_m3__base] $X=10705 $Y=126340 $dt=40
C5676 1 3 L=4e-06 W=4e-06 $[cap_mim_m3__base] $X=10705 $Y=134620 $dt=40
C5677 1 3 L=4e-06 W=4e-06 $[cap_mim_m3__base] $X=10705 $Y=142900 $dt=40
C5678 1 3 L=4e-06 W=4e-06 $[cap_mim_m3__base] $X=10705 $Y=151180 $dt=40
C5679 1 3 L=4e-06 W=4e-06 $[cap_mim_m3__base] $X=10705 $Y=159460 $dt=40
C5680 1 3 L=4e-06 W=4e-06 $[cap_mim_m3__base] $X=10705 $Y=167740 $dt=40
C5681 308 3 L=4e-06 W=4e-06 $[cap_mim_m3__base] $X=18985 $Y=2140 $dt=40
C5682 871 667 L=4e-06 W=4e-06 $[cap_mim_m3__base] $X=18985 $Y=10420 $dt=40
C5683 871 668 L=4e-06 W=4e-06 $[cap_mim_m3__base] $X=18985 $Y=18700 $dt=40
C5684 871 669 L=4e-06 W=4e-06 $[cap_mim_m3__base] $X=18985 $Y=26980 $dt=40
C5685 871 670 L=4e-06 W=4e-06 $[cap_mim_m3__base] $X=18985 $Y=35260 $dt=40
C5686 871 671 L=4e-06 W=4e-06 $[cap_mim_m3__base] $X=18985 $Y=43540 $dt=40
C5687 871 672 L=4e-06 W=4e-06 $[cap_mim_m3__base] $X=18985 $Y=51820 $dt=40
C5688 871 673 L=4e-06 W=4e-06 $[cap_mim_m3__base] $X=18985 $Y=60100 $dt=40
C5689 324 308 L=4e-06 W=4e-06 $[cap_mim_m3__base] $X=18985 $Y=68380 $dt=40
C5690 308 324 L=4e-06 W=4e-06 $[cap_mim_m3__base] $X=18985 $Y=76660 $dt=40
C5691 324 308 L=4e-06 W=4e-06 $[cap_mim_m3__base] $X=18985 $Y=84940 $dt=40
C5692 308 324 L=4e-06 W=4e-06 $[cap_mim_m3__base] $X=18985 $Y=93220 $dt=40
C5693 324 308 L=4e-06 W=4e-06 $[cap_mim_m3__base] $X=18985 $Y=101500 $dt=40
C5694 871 674 L=4e-06 W=4e-06 $[cap_mim_m3__base] $X=18985 $Y=109780 $dt=40
C5695 871 675 L=4e-06 W=4e-06 $[cap_mim_m3__base] $X=18985 $Y=118060 $dt=40
C5696 871 676 L=4e-06 W=4e-06 $[cap_mim_m3__base] $X=18985 $Y=126340 $dt=40
C5697 871 677 L=4e-06 W=4e-06 $[cap_mim_m3__base] $X=18985 $Y=134620 $dt=40
C5698 871 678 L=4e-06 W=4e-06 $[cap_mim_m3__base] $X=18985 $Y=142900 $dt=40
C5699 871 679 L=4e-06 W=4e-06 $[cap_mim_m3__base] $X=18985 $Y=151180 $dt=40
C5700 871 680 L=4e-06 W=4e-06 $[cap_mim_m3__base] $X=18985 $Y=159460 $dt=40
C5701 324 3 L=4e-06 W=4e-06 $[cap_mim_m3__base] $X=18985 $Y=167740 $dt=40
C5702 324 3 L=4e-06 W=4e-06 $[cap_mim_m3__base] $X=27265 $Y=2140 $dt=40
C5703 871 653 L=4e-06 W=4e-06 $[cap_mim_m3__base] $X=27265 $Y=10420 $dt=40
C5704 871 654 L=4e-06 W=4e-06 $[cap_mim_m3__base] $X=27265 $Y=18700 $dt=40
C5705 871 655 L=4e-06 W=4e-06 $[cap_mim_m3__base] $X=27265 $Y=26980 $dt=40
C5706 871 656 L=4e-06 W=4e-06 $[cap_mim_m3__base] $X=27265 $Y=35260 $dt=40
C5707 871 657 L=4e-06 W=4e-06 $[cap_mim_m3__base] $X=27265 $Y=43540 $dt=40
C5708 871 658 L=4e-06 W=4e-06 $[cap_mim_m3__base] $X=27265 $Y=51820 $dt=40
C5709 871 659 L=4e-06 W=4e-06 $[cap_mim_m3__base] $X=27265 $Y=60100 $dt=40
C5710 308 324 L=4e-06 W=4e-06 $[cap_mim_m3__base] $X=27265 $Y=68380 $dt=40
C5711 324 308 L=4e-06 W=4e-06 $[cap_mim_m3__base] $X=27265 $Y=76660 $dt=40
C5712 308 324 L=4e-06 W=4e-06 $[cap_mim_m3__base] $X=27265 $Y=84940 $dt=40
C5713 324 308 L=4e-06 W=4e-06 $[cap_mim_m3__base] $X=27265 $Y=93220 $dt=40
C5714 308 324 L=4e-06 W=4e-06 $[cap_mim_m3__base] $X=27265 $Y=101500 $dt=40
C5715 871 660 L=4e-06 W=4e-06 $[cap_mim_m3__base] $X=27265 $Y=109780 $dt=40
C5716 871 661 L=4e-06 W=4e-06 $[cap_mim_m3__base] $X=27265 $Y=118060 $dt=40
C5717 871 662 L=4e-06 W=4e-06 $[cap_mim_m3__base] $X=27265 $Y=126340 $dt=40
C5718 871 663 L=4e-06 W=4e-06 $[cap_mim_m3__base] $X=27265 $Y=134620 $dt=40
C5719 871 664 L=4e-06 W=4e-06 $[cap_mim_m3__base] $X=27265 $Y=142900 $dt=40
C5720 871 665 L=4e-06 W=4e-06 $[cap_mim_m3__base] $X=27265 $Y=151180 $dt=40
C5721 871 666 L=4e-06 W=4e-06 $[cap_mim_m3__base] $X=27265 $Y=159460 $dt=40
C5722 308 3 L=4e-06 W=4e-06 $[cap_mim_m3__base] $X=27265 $Y=167740 $dt=40
C5723 308 3 L=4e-06 W=4e-06 $[cap_mim_m3__base] $X=35545 $Y=2140 $dt=40
C5724 871 639 L=4e-06 W=4e-06 $[cap_mim_m3__base] $X=35545 $Y=10420 $dt=40
C5725 871 640 L=4e-06 W=4e-06 $[cap_mim_m3__base] $X=35545 $Y=18700 $dt=40
C5726 871 641 L=4e-06 W=4e-06 $[cap_mim_m3__base] $X=35545 $Y=26980 $dt=40
C5727 871 642 L=4e-06 W=4e-06 $[cap_mim_m3__base] $X=35545 $Y=35260 $dt=40
C5728 871 643 L=4e-06 W=4e-06 $[cap_mim_m3__base] $X=35545 $Y=43540 $dt=40
C5729 871 644 L=4e-06 W=4e-06 $[cap_mim_m3__base] $X=35545 $Y=51820 $dt=40
C5730 871 645 L=4e-06 W=4e-06 $[cap_mim_m3__base] $X=35545 $Y=60100 $dt=40
C5731 324 308 L=4e-06 W=4e-06 $[cap_mim_m3__base] $X=35545 $Y=68380 $dt=40
C5732 308 324 L=4e-06 W=4e-06 $[cap_mim_m3__base] $X=35545 $Y=76660 $dt=40
C5733 324 308 L=4e-06 W=4e-06 $[cap_mim_m3__base] $X=35545 $Y=84940 $dt=40
C5734 308 324 L=4e-06 W=4e-06 $[cap_mim_m3__base] $X=35545 $Y=93220 $dt=40
C5735 324 308 L=4e-06 W=4e-06 $[cap_mim_m3__base] $X=35545 $Y=101500 $dt=40
C5736 871 646 L=4e-06 W=4e-06 $[cap_mim_m3__base] $X=35545 $Y=109780 $dt=40
C5737 871 647 L=4e-06 W=4e-06 $[cap_mim_m3__base] $X=35545 $Y=118060 $dt=40
C5738 871 648 L=4e-06 W=4e-06 $[cap_mim_m3__base] $X=35545 $Y=126340 $dt=40
C5739 871 649 L=4e-06 W=4e-06 $[cap_mim_m3__base] $X=35545 $Y=134620 $dt=40
C5740 871 650 L=4e-06 W=4e-06 $[cap_mim_m3__base] $X=35545 $Y=142900 $dt=40
C5741 871 651 L=4e-06 W=4e-06 $[cap_mim_m3__base] $X=35545 $Y=151180 $dt=40
C5742 871 652 L=4e-06 W=4e-06 $[cap_mim_m3__base] $X=35545 $Y=159460 $dt=40
C5743 324 3 L=4e-06 W=4e-06 $[cap_mim_m3__base] $X=35545 $Y=167740 $dt=40
C5744 324 3 L=4e-06 W=4e-06 $[cap_mim_m3__base] $X=43825 $Y=2140 $dt=40
C5745 871 625 L=4e-06 W=4e-06 $[cap_mim_m3__base] $X=43825 $Y=10420 $dt=40
C5746 871 626 L=4e-06 W=4e-06 $[cap_mim_m3__base] $X=43825 $Y=18700 $dt=40
C5747 871 627 L=4e-06 W=4e-06 $[cap_mim_m3__base] $X=43825 $Y=26980 $dt=40
C5748 871 628 L=4e-06 W=4e-06 $[cap_mim_m3__base] $X=43825 $Y=35260 $dt=40
C5749 871 629 L=4e-06 W=4e-06 $[cap_mim_m3__base] $X=43825 $Y=43540 $dt=40
C5750 871 630 L=4e-06 W=4e-06 $[cap_mim_m3__base] $X=43825 $Y=51820 $dt=40
C5751 871 631 L=4e-06 W=4e-06 $[cap_mim_m3__base] $X=43825 $Y=60100 $dt=40
C5752 308 324 L=4e-06 W=4e-06 $[cap_mim_m3__base] $X=43825 $Y=68380 $dt=40
C5753 324 308 L=4e-06 W=4e-06 $[cap_mim_m3__base] $X=43825 $Y=76660 $dt=40
C5754 308 324 L=4e-06 W=4e-06 $[cap_mim_m3__base] $X=43825 $Y=84940 $dt=40
C5755 324 308 L=4e-06 W=4e-06 $[cap_mim_m3__base] $X=43825 $Y=93220 $dt=40
C5756 308 324 L=4e-06 W=4e-06 $[cap_mim_m3__base] $X=43825 $Y=101500 $dt=40
C5757 871 632 L=4e-06 W=4e-06 $[cap_mim_m3__base] $X=43825 $Y=109780 $dt=40
C5758 871 633 L=4e-06 W=4e-06 $[cap_mim_m3__base] $X=43825 $Y=118060 $dt=40
C5759 871 634 L=4e-06 W=4e-06 $[cap_mim_m3__base] $X=43825 $Y=126340 $dt=40
C5760 871 635 L=4e-06 W=4e-06 $[cap_mim_m3__base] $X=43825 $Y=134620 $dt=40
C5761 871 636 L=4e-06 W=4e-06 $[cap_mim_m3__base] $X=43825 $Y=142900 $dt=40
C5762 871 637 L=4e-06 W=4e-06 $[cap_mim_m3__base] $X=43825 $Y=151180 $dt=40
C5763 871 638 L=4e-06 W=4e-06 $[cap_mim_m3__base] $X=43825 $Y=159460 $dt=40
C5764 308 3 L=4e-06 W=4e-06 $[cap_mim_m3__base] $X=43825 $Y=167740 $dt=40
C5765 308 3 L=4e-06 W=4e-06 $[cap_mim_m3__base] $X=52105 $Y=2140 $dt=40
C5766 871 607 L=4e-06 W=4e-06 $[cap_mim_m3__base] $X=52105 $Y=10420 $dt=40
C5767 871 608 L=4e-06 W=4e-06 $[cap_mim_m3__base] $X=52105 $Y=18700 $dt=40
C5768 871 609 L=4e-06 W=4e-06 $[cap_mim_m3__base] $X=52105 $Y=26980 $dt=40
C5769 871 610 L=4e-06 W=4e-06 $[cap_mim_m3__base] $X=52105 $Y=35260 $dt=40
C5770 871 611 L=4e-06 W=4e-06 $[cap_mim_m3__base] $X=52105 $Y=43540 $dt=40
C5771 871 612 L=4e-06 W=4e-06 $[cap_mim_m3__base] $X=52105 $Y=51820 $dt=40
C5772 871 613 L=4e-06 W=4e-06 $[cap_mim_m3__base] $X=52105 $Y=60100 $dt=40
C5773 871 614 L=4e-06 W=4e-06 $[cap_mim_m3__base] $X=52105 $Y=68380 $dt=40
C5774 871 615 L=4e-06 W=4e-06 $[cap_mim_m3__base] $X=52105 $Y=76660 $dt=40
C5775 324 308 L=4e-06 W=4e-06 $[cap_mim_m3__base] $X=52105 $Y=84940 $dt=40
C5776 871 616 L=4e-06 W=4e-06 $[cap_mim_m3__base] $X=52105 $Y=93220 $dt=40
C5777 871 617 L=4e-06 W=4e-06 $[cap_mim_m3__base] $X=52105 $Y=101500 $dt=40
C5778 871 618 L=4e-06 W=4e-06 $[cap_mim_m3__base] $X=52105 $Y=109780 $dt=40
C5779 871 619 L=4e-06 W=4e-06 $[cap_mim_m3__base] $X=52105 $Y=118060 $dt=40
C5780 871 620 L=4e-06 W=4e-06 $[cap_mim_m3__base] $X=52105 $Y=126340 $dt=40
C5781 871 621 L=4e-06 W=4e-06 $[cap_mim_m3__base] $X=52105 $Y=134620 $dt=40
C5782 871 622 L=4e-06 W=4e-06 $[cap_mim_m3__base] $X=52105 $Y=142900 $dt=40
C5783 871 623 L=4e-06 W=4e-06 $[cap_mim_m3__base] $X=52105 $Y=151180 $dt=40
C5784 871 624 L=4e-06 W=4e-06 $[cap_mim_m3__base] $X=52105 $Y=159460 $dt=40
C5785 324 3 L=4e-06 W=4e-06 $[cap_mim_m3__base] $X=52105 $Y=167740 $dt=40
C5786 324 3 L=4e-06 W=4e-06 $[cap_mim_m3__base] $X=60385 $Y=2140 $dt=40
C5787 871 589 L=4e-06 W=4e-06 $[cap_mim_m3__base] $X=60385 $Y=10420 $dt=40
C5788 871 590 L=4e-06 W=4e-06 $[cap_mim_m3__base] $X=60385 $Y=18700 $dt=40
C5789 871 591 L=4e-06 W=4e-06 $[cap_mim_m3__base] $X=60385 $Y=26980 $dt=40
C5790 871 592 L=4e-06 W=4e-06 $[cap_mim_m3__base] $X=60385 $Y=35260 $dt=40
C5791 871 593 L=4e-06 W=4e-06 $[cap_mim_m3__base] $X=60385 $Y=43540 $dt=40
C5792 871 594 L=4e-06 W=4e-06 $[cap_mim_m3__base] $X=60385 $Y=51820 $dt=40
C5793 871 595 L=4e-06 W=4e-06 $[cap_mim_m3__base] $X=60385 $Y=60100 $dt=40
C5794 871 596 L=4e-06 W=4e-06 $[cap_mim_m3__base] $X=60385 $Y=68380 $dt=40
C5795 871 597 L=4e-06 W=4e-06 $[cap_mim_m3__base] $X=60385 $Y=76660 $dt=40
C5796 308 324 L=4e-06 W=4e-06 $[cap_mim_m3__base] $X=60385 $Y=84940 $dt=40
C5797 871 598 L=4e-06 W=4e-06 $[cap_mim_m3__base] $X=60385 $Y=93220 $dt=40
C5798 871 599 L=4e-06 W=4e-06 $[cap_mim_m3__base] $X=60385 $Y=101500 $dt=40
C5799 871 600 L=4e-06 W=4e-06 $[cap_mim_m3__base] $X=60385 $Y=109780 $dt=40
C5800 871 601 L=4e-06 W=4e-06 $[cap_mim_m3__base] $X=60385 $Y=118060 $dt=40
C5801 871 602 L=4e-06 W=4e-06 $[cap_mim_m3__base] $X=60385 $Y=126340 $dt=40
C5802 871 603 L=4e-06 W=4e-06 $[cap_mim_m3__base] $X=60385 $Y=134620 $dt=40
C5803 871 604 L=4e-06 W=4e-06 $[cap_mim_m3__base] $X=60385 $Y=142900 $dt=40
C5804 871 605 L=4e-06 W=4e-06 $[cap_mim_m3__base] $X=60385 $Y=151180 $dt=40
C5805 871 606 L=4e-06 W=4e-06 $[cap_mim_m3__base] $X=60385 $Y=159460 $dt=40
C5806 308 3 L=4e-06 W=4e-06 $[cap_mim_m3__base] $X=60385 $Y=167740 $dt=40
C5807 308 3 L=4e-06 W=4e-06 $[cap_mim_m3__base] $X=68665 $Y=2140 $dt=40
C5808 871 571 L=4e-06 W=4e-06 $[cap_mim_m3__base] $X=68665 $Y=10420 $dt=40
C5809 871 572 L=4e-06 W=4e-06 $[cap_mim_m3__base] $X=68665 $Y=18700 $dt=40
C5810 871 573 L=4e-06 W=4e-06 $[cap_mim_m3__base] $X=68665 $Y=26980 $dt=40
C5811 871 574 L=4e-06 W=4e-06 $[cap_mim_m3__base] $X=68665 $Y=35260 $dt=40
C5812 871 575 L=4e-06 W=4e-06 $[cap_mim_m3__base] $X=68665 $Y=43540 $dt=40
C5813 871 576 L=4e-06 W=4e-06 $[cap_mim_m3__base] $X=68665 $Y=51820 $dt=40
C5814 871 577 L=4e-06 W=4e-06 $[cap_mim_m3__base] $X=68665 $Y=60100 $dt=40
C5815 871 578 L=4e-06 W=4e-06 $[cap_mim_m3__base] $X=68665 $Y=68380 $dt=40
C5816 871 579 L=4e-06 W=4e-06 $[cap_mim_m3__base] $X=68665 $Y=76660 $dt=40
C5817 324 308 L=4e-06 W=4e-06 $[cap_mim_m3__base] $X=68665 $Y=84940 $dt=40
C5818 871 580 L=4e-06 W=4e-06 $[cap_mim_m3__base] $X=68665 $Y=93220 $dt=40
C5819 871 581 L=4e-06 W=4e-06 $[cap_mim_m3__base] $X=68665 $Y=101500 $dt=40
C5820 871 582 L=4e-06 W=4e-06 $[cap_mim_m3__base] $X=68665 $Y=109780 $dt=40
C5821 871 583 L=4e-06 W=4e-06 $[cap_mim_m3__base] $X=68665 $Y=118060 $dt=40
C5822 871 584 L=4e-06 W=4e-06 $[cap_mim_m3__base] $X=68665 $Y=126340 $dt=40
C5823 871 585 L=4e-06 W=4e-06 $[cap_mim_m3__base] $X=68665 $Y=134620 $dt=40
C5824 871 586 L=4e-06 W=4e-06 $[cap_mim_m3__base] $X=68665 $Y=142900 $dt=40
C5825 871 587 L=4e-06 W=4e-06 $[cap_mim_m3__base] $X=68665 $Y=151180 $dt=40
C5826 871 588 L=4e-06 W=4e-06 $[cap_mim_m3__base] $X=68665 $Y=159460 $dt=40
C5827 324 3 L=4e-06 W=4e-06 $[cap_mim_m3__base] $X=68665 $Y=167740 $dt=40
C5828 324 3 L=4e-06 W=4e-06 $[cap_mim_m3__base] $X=76945 $Y=2140 $dt=40
C5829 871 438 L=4e-06 W=4e-06 $[cap_mim_m3__base] $X=76945 $Y=10420 $dt=40
C5830 871 439 L=4e-06 W=4e-06 $[cap_mim_m3__base] $X=76945 $Y=18700 $dt=40
C5831 871 440 L=4e-06 W=4e-06 $[cap_mim_m3__base] $X=76945 $Y=26980 $dt=40
C5832 871 441 L=4e-06 W=4e-06 $[cap_mim_m3__base] $X=76945 $Y=35260 $dt=40
C5833 871 442 L=4e-06 W=4e-06 $[cap_mim_m3__base] $X=76945 $Y=43540 $dt=40
C5834 871 443 L=4e-06 W=4e-06 $[cap_mim_m3__base] $X=76945 $Y=51820 $dt=40
C5835 871 444 L=4e-06 W=4e-06 $[cap_mim_m3__base] $X=76945 $Y=60100 $dt=40
C5836 871 445 L=4e-06 W=4e-06 $[cap_mim_m3__base] $X=76945 $Y=68380 $dt=40
C5837 871 446 L=4e-06 W=4e-06 $[cap_mim_m3__base] $X=76945 $Y=76660 $dt=40
C5838 871 447 L=4e-06 W=4e-06 $[cap_mim_m3__base] $X=76945 $Y=84940 $dt=40
C5839 871 448 L=4e-06 W=4e-06 $[cap_mim_m3__base] $X=76945 $Y=93220 $dt=40
C5840 871 449 L=4e-06 W=4e-06 $[cap_mim_m3__base] $X=76945 $Y=101500 $dt=40
C5841 871 450 L=4e-06 W=4e-06 $[cap_mim_m3__base] $X=76945 $Y=109780 $dt=40
C5842 871 451 L=4e-06 W=4e-06 $[cap_mim_m3__base] $X=76945 $Y=118060 $dt=40
C5843 871 452 L=4e-06 W=4e-06 $[cap_mim_m3__base] $X=76945 $Y=126340 $dt=40
C5844 871 453 L=4e-06 W=4e-06 $[cap_mim_m3__base] $X=76945 $Y=134620 $dt=40
C5845 871 454 L=4e-06 W=4e-06 $[cap_mim_m3__base] $X=76945 $Y=142900 $dt=40
C5846 871 455 L=4e-06 W=4e-06 $[cap_mim_m3__base] $X=76945 $Y=151180 $dt=40
C5847 871 456 L=4e-06 W=4e-06 $[cap_mim_m3__base] $X=76945 $Y=159460 $dt=40
C5848 308 3 L=4e-06 W=4e-06 $[cap_mim_m3__base] $X=76945 $Y=167740 $dt=40
C5849 308 3 L=4e-06 W=4e-06 $[cap_mim_m3__base] $X=85225 $Y=2140 $dt=40
C5850 871 419 L=4e-06 W=4e-06 $[cap_mim_m3__base] $X=85225 $Y=10420 $dt=40
C5851 871 420 L=4e-06 W=4e-06 $[cap_mim_m3__base] $X=85225 $Y=18700 $dt=40
C5852 871 421 L=4e-06 W=4e-06 $[cap_mim_m3__base] $X=85225 $Y=26980 $dt=40
C5853 871 422 L=4e-06 W=4e-06 $[cap_mim_m3__base] $X=85225 $Y=35260 $dt=40
C5854 871 423 L=4e-06 W=4e-06 $[cap_mim_m3__base] $X=85225 $Y=43540 $dt=40
C5855 871 424 L=4e-06 W=4e-06 $[cap_mim_m3__base] $X=85225 $Y=51820 $dt=40
C5856 871 425 L=4e-06 W=4e-06 $[cap_mim_m3__base] $X=85225 $Y=60100 $dt=40
C5857 871 426 L=4e-06 W=4e-06 $[cap_mim_m3__base] $X=85225 $Y=68380 $dt=40
C5858 871 427 L=4e-06 W=4e-06 $[cap_mim_m3__base] $X=85225 $Y=76660 $dt=40
C5859 871 428 L=4e-06 W=4e-06 $[cap_mim_m3__base] $X=85225 $Y=84940 $dt=40
C5860 871 429 L=4e-06 W=4e-06 $[cap_mim_m3__base] $X=85225 $Y=93220 $dt=40
C5861 871 430 L=4e-06 W=4e-06 $[cap_mim_m3__base] $X=85225 $Y=101500 $dt=40
C5862 871 431 L=4e-06 W=4e-06 $[cap_mim_m3__base] $X=85225 $Y=109780 $dt=40
C5863 871 432 L=4e-06 W=4e-06 $[cap_mim_m3__base] $X=85225 $Y=118060 $dt=40
C5864 871 433 L=4e-06 W=4e-06 $[cap_mim_m3__base] $X=85225 $Y=126340 $dt=40
C5865 871 434 L=4e-06 W=4e-06 $[cap_mim_m3__base] $X=85225 $Y=134620 $dt=40
C5866 871 435 L=4e-06 W=4e-06 $[cap_mim_m3__base] $X=85225 $Y=142900 $dt=40
C5867 871 436 L=4e-06 W=4e-06 $[cap_mim_m3__base] $X=85225 $Y=151180 $dt=40
C5868 871 437 L=4e-06 W=4e-06 $[cap_mim_m3__base] $X=85225 $Y=159460 $dt=40
C5869 324 3 L=4e-06 W=4e-06 $[cap_mim_m3__base] $X=85225 $Y=167740 $dt=40
C5870 324 3 L=4e-06 W=4e-06 $[cap_mim_m3__base] $X=93505 $Y=2140 $dt=40
C5871 871 401 L=4e-06 W=4e-06 $[cap_mim_m3__base] $X=93505 $Y=10420 $dt=40
C5872 871 402 L=4e-06 W=4e-06 $[cap_mim_m3__base] $X=93505 $Y=18700 $dt=40
C5873 871 403 L=4e-06 W=4e-06 $[cap_mim_m3__base] $X=93505 $Y=26980 $dt=40
C5874 871 404 L=4e-06 W=4e-06 $[cap_mim_m3__base] $X=93505 $Y=35260 $dt=40
C5875 871 405 L=4e-06 W=4e-06 $[cap_mim_m3__base] $X=93505 $Y=43540 $dt=40
C5876 871 406 L=4e-06 W=4e-06 $[cap_mim_m3__base] $X=93505 $Y=51820 $dt=40
C5877 871 407 L=4e-06 W=4e-06 $[cap_mim_m3__base] $X=93505 $Y=60100 $dt=40
C5878 871 408 L=4e-06 W=4e-06 $[cap_mim_m3__base] $X=93505 $Y=68380 $dt=40
C5879 871 409 L=4e-06 W=4e-06 $[cap_mim_m3__base] $X=93505 $Y=76660 $dt=40
C5880 308 324 L=4e-06 W=4e-06 $[cap_mim_m3__base] $X=93505 $Y=84940 $dt=40
C5881 871 410 L=4e-06 W=4e-06 $[cap_mim_m3__base] $X=93505 $Y=93220 $dt=40
C5882 871 411 L=4e-06 W=4e-06 $[cap_mim_m3__base] $X=93505 $Y=101500 $dt=40
C5883 871 412 L=4e-06 W=4e-06 $[cap_mim_m3__base] $X=93505 $Y=109780 $dt=40
C5884 871 413 L=4e-06 W=4e-06 $[cap_mim_m3__base] $X=93505 $Y=118060 $dt=40
C5885 871 414 L=4e-06 W=4e-06 $[cap_mim_m3__base] $X=93505 $Y=126340 $dt=40
C5886 871 415 L=4e-06 W=4e-06 $[cap_mim_m3__base] $X=93505 $Y=134620 $dt=40
C5887 871 416 L=4e-06 W=4e-06 $[cap_mim_m3__base] $X=93505 $Y=142900 $dt=40
C5888 871 417 L=4e-06 W=4e-06 $[cap_mim_m3__base] $X=93505 $Y=151180 $dt=40
C5889 871 418 L=4e-06 W=4e-06 $[cap_mim_m3__base] $X=93505 $Y=159460 $dt=40
C5890 308 3 L=4e-06 W=4e-06 $[cap_mim_m3__base] $X=93505 $Y=167740 $dt=40
C5891 308 3 L=4e-06 W=4e-06 $[cap_mim_m3__base] $X=101785 $Y=2140 $dt=40
C5892 871 384 L=4e-06 W=4e-06 $[cap_mim_m3__base] $X=101785 $Y=10420 $dt=40
C5893 871 385 L=4e-06 W=4e-06 $[cap_mim_m3__base] $X=101785 $Y=18700 $dt=40
C5894 871 386 L=4e-06 W=4e-06 $[cap_mim_m3__base] $X=101785 $Y=26980 $dt=40
C5895 871 387 L=4e-06 W=4e-06 $[cap_mim_m3__base] $X=101785 $Y=35260 $dt=40
C5896 871 388 L=4e-06 W=4e-06 $[cap_mim_m3__base] $X=101785 $Y=43540 $dt=40
C5897 871 389 L=4e-06 W=4e-06 $[cap_mim_m3__base] $X=101785 $Y=51820 $dt=40
C5898 871 390 L=4e-06 W=4e-06 $[cap_mim_m3__base] $X=101785 $Y=60100 $dt=40
C5899 871 391 L=4e-06 W=4e-06 $[cap_mim_m3__base] $X=101785 $Y=68380 $dt=40
C5900 871 392 L=4e-06 W=4e-06 $[cap_mim_m3__base] $X=101785 $Y=76660 $dt=40
C5901 308 324 L=4e-06 W=4e-06 $[cap_mim_m3__base] $X=101785 $Y=84940 $dt=40
C5902 324 308 L=4e-06 W=4e-06 $[cap_mim_m3__base] $X=101785 $Y=93220 $dt=40
C5903 871 393 L=4e-06 W=4e-06 $[cap_mim_m3__base] $X=101785 $Y=101500 $dt=40
C5904 871 394 L=4e-06 W=4e-06 $[cap_mim_m3__base] $X=101785 $Y=109780 $dt=40
C5905 871 395 L=4e-06 W=4e-06 $[cap_mim_m3__base] $X=101785 $Y=118060 $dt=40
C5906 871 396 L=4e-06 W=4e-06 $[cap_mim_m3__base] $X=101785 $Y=126340 $dt=40
C5907 871 397 L=4e-06 W=4e-06 $[cap_mim_m3__base] $X=101785 $Y=134620 $dt=40
C5908 871 398 L=4e-06 W=4e-06 $[cap_mim_m3__base] $X=101785 $Y=142900 $dt=40
C5909 871 399 L=4e-06 W=4e-06 $[cap_mim_m3__base] $X=101785 $Y=151180 $dt=40
C5910 871 400 L=4e-06 W=4e-06 $[cap_mim_m3__base] $X=101785 $Y=159460 $dt=40
C5911 324 3 L=4e-06 W=4e-06 $[cap_mim_m3__base] $X=101785 $Y=167740 $dt=40
C5912 324 3 L=4e-06 W=4e-06 $[cap_mim_m3__base] $X=110065 $Y=2140 $dt=40
C5913 871 367 L=4e-06 W=4e-06 $[cap_mim_m3__base] $X=110065 $Y=10420 $dt=40
C5914 871 368 L=4e-06 W=4e-06 $[cap_mim_m3__base] $X=110065 $Y=18700 $dt=40
C5915 871 369 L=4e-06 W=4e-06 $[cap_mim_m3__base] $X=110065 $Y=26980 $dt=40
C5916 871 370 L=4e-06 W=4e-06 $[cap_mim_m3__base] $X=110065 $Y=35260 $dt=40
C5917 871 371 L=4e-06 W=4e-06 $[cap_mim_m3__base] $X=110065 $Y=43540 $dt=40
C5918 871 372 L=4e-06 W=4e-06 $[cap_mim_m3__base] $X=110065 $Y=51820 $dt=40
C5919 871 373 L=4e-06 W=4e-06 $[cap_mim_m3__base] $X=110065 $Y=60100 $dt=40
C5920 871 374 L=4e-06 W=4e-06 $[cap_mim_m3__base] $X=110065 $Y=68380 $dt=40
C5921 871 375 L=4e-06 W=4e-06 $[cap_mim_m3__base] $X=110065 $Y=76660 $dt=40
C5922 324 308 L=4e-06 W=4e-06 $[cap_mim_m3__base] $X=110065 $Y=84940 $dt=40
C5923 308 324 L=4e-06 W=4e-06 $[cap_mim_m3__base] $X=110065 $Y=93220 $dt=40
C5924 871 376 L=4e-06 W=4e-06 $[cap_mim_m3__base] $X=110065 $Y=101500 $dt=40
C5925 871 377 L=4e-06 W=4e-06 $[cap_mim_m3__base] $X=110065 $Y=109780 $dt=40
C5926 871 378 L=4e-06 W=4e-06 $[cap_mim_m3__base] $X=110065 $Y=118060 $dt=40
C5927 871 379 L=4e-06 W=4e-06 $[cap_mim_m3__base] $X=110065 $Y=126340 $dt=40
C5928 871 380 L=4e-06 W=4e-06 $[cap_mim_m3__base] $X=110065 $Y=134620 $dt=40
C5929 871 381 L=4e-06 W=4e-06 $[cap_mim_m3__base] $X=110065 $Y=142900 $dt=40
C5930 871 382 L=4e-06 W=4e-06 $[cap_mim_m3__base] $X=110065 $Y=151180 $dt=40
C5931 871 383 L=4e-06 W=4e-06 $[cap_mim_m3__base] $X=110065 $Y=159460 $dt=40
C5932 308 3 L=4e-06 W=4e-06 $[cap_mim_m3__base] $X=110065 $Y=167740 $dt=40
C5933 308 3 L=4e-06 W=4e-06 $[cap_mim_m3__base] $X=118345 $Y=2140 $dt=40
C5934 871 353 L=4e-06 W=4e-06 $[cap_mim_m3__base] $X=118345 $Y=10420 $dt=40
C5935 871 354 L=4e-06 W=4e-06 $[cap_mim_m3__base] $X=118345 $Y=18700 $dt=40
C5936 871 355 L=4e-06 W=4e-06 $[cap_mim_m3__base] $X=118345 $Y=26980 $dt=40
C5937 871 356 L=4e-06 W=4e-06 $[cap_mim_m3__base] $X=118345 $Y=35260 $dt=40
C5938 871 357 L=4e-06 W=4e-06 $[cap_mim_m3__base] $X=118345 $Y=43540 $dt=40
C5939 871 358 L=4e-06 W=4e-06 $[cap_mim_m3__base] $X=118345 $Y=51820 $dt=40
C5940 871 359 L=4e-06 W=4e-06 $[cap_mim_m3__base] $X=118345 $Y=60100 $dt=40
C5941 308 324 L=4e-06 W=4e-06 $[cap_mim_m3__base] $X=118345 $Y=68380 $dt=40
C5942 324 308 L=4e-06 W=4e-06 $[cap_mim_m3__base] $X=118345 $Y=76660 $dt=40
C5943 308 324 L=4e-06 W=4e-06 $[cap_mim_m3__base] $X=118345 $Y=84940 $dt=40
C5944 324 308 L=4e-06 W=4e-06 $[cap_mim_m3__base] $X=118345 $Y=93220 $dt=40
C5945 308 324 L=4e-06 W=4e-06 $[cap_mim_m3__base] $X=118345 $Y=101500 $dt=40
C5946 871 360 L=4e-06 W=4e-06 $[cap_mim_m3__base] $X=118345 $Y=109780 $dt=40
C5947 871 361 L=4e-06 W=4e-06 $[cap_mim_m3__base] $X=118345 $Y=118060 $dt=40
C5948 871 362 L=4e-06 W=4e-06 $[cap_mim_m3__base] $X=118345 $Y=126340 $dt=40
C5949 871 363 L=4e-06 W=4e-06 $[cap_mim_m3__base] $X=118345 $Y=134620 $dt=40
C5950 871 364 L=4e-06 W=4e-06 $[cap_mim_m3__base] $X=118345 $Y=142900 $dt=40
C5951 871 365 L=4e-06 W=4e-06 $[cap_mim_m3__base] $X=118345 $Y=151180 $dt=40
C5952 871 366 L=4e-06 W=4e-06 $[cap_mim_m3__base] $X=118345 $Y=159460 $dt=40
C5953 324 3 L=4e-06 W=4e-06 $[cap_mim_m3__base] $X=118345 $Y=167740 $dt=40
C5954 324 3 L=4e-06 W=4e-06 $[cap_mim_m3__base] $X=126625 $Y=2140 $dt=40
C5955 871 339 L=4e-06 W=4e-06 $[cap_mim_m3__base] $X=126625 $Y=10420 $dt=40
C5956 871 340 L=4e-06 W=4e-06 $[cap_mim_m3__base] $X=126625 $Y=18700 $dt=40
C5957 871 341 L=4e-06 W=4e-06 $[cap_mim_m3__base] $X=126625 $Y=26980 $dt=40
C5958 871 342 L=4e-06 W=4e-06 $[cap_mim_m3__base] $X=126625 $Y=35260 $dt=40
C5959 871 343 L=4e-06 W=4e-06 $[cap_mim_m3__base] $X=126625 $Y=43540 $dt=40
C5960 871 344 L=4e-06 W=4e-06 $[cap_mim_m3__base] $X=126625 $Y=51820 $dt=40
C5961 871 345 L=4e-06 W=4e-06 $[cap_mim_m3__base] $X=126625 $Y=60100 $dt=40
C5962 324 308 L=4e-06 W=4e-06 $[cap_mim_m3__base] $X=126625 $Y=68380 $dt=40
C5963 308 324 L=4e-06 W=4e-06 $[cap_mim_m3__base] $X=126625 $Y=76660 $dt=40
C5964 324 308 L=4e-06 W=4e-06 $[cap_mim_m3__base] $X=126625 $Y=84940 $dt=40
C5965 308 324 L=4e-06 W=4e-06 $[cap_mim_m3__base] $X=126625 $Y=93220 $dt=40
C5966 324 308 L=4e-06 W=4e-06 $[cap_mim_m3__base] $X=126625 $Y=101500 $dt=40
C5967 871 346 L=4e-06 W=4e-06 $[cap_mim_m3__base] $X=126625 $Y=109780 $dt=40
C5968 871 347 L=4e-06 W=4e-06 $[cap_mim_m3__base] $X=126625 $Y=118060 $dt=40
C5969 871 348 L=4e-06 W=4e-06 $[cap_mim_m3__base] $X=126625 $Y=126340 $dt=40
C5970 871 349 L=4e-06 W=4e-06 $[cap_mim_m3__base] $X=126625 $Y=134620 $dt=40
C5971 871 350 L=4e-06 W=4e-06 $[cap_mim_m3__base] $X=126625 $Y=142900 $dt=40
C5972 871 351 L=4e-06 W=4e-06 $[cap_mim_m3__base] $X=126625 $Y=151180 $dt=40
C5973 871 352 L=4e-06 W=4e-06 $[cap_mim_m3__base] $X=126625 $Y=159460 $dt=40
C5974 308 3 L=4e-06 W=4e-06 $[cap_mim_m3__base] $X=126625 $Y=167740 $dt=40
C5975 308 3 L=4e-06 W=4e-06 $[cap_mim_m3__base] $X=134905 $Y=2140 $dt=40
C5976 871 325 L=4e-06 W=4e-06 $[cap_mim_m3__base] $X=134905 $Y=10420 $dt=40
C5977 871 326 L=4e-06 W=4e-06 $[cap_mim_m3__base] $X=134905 $Y=18700 $dt=40
C5978 871 327 L=4e-06 W=4e-06 $[cap_mim_m3__base] $X=134905 $Y=26980 $dt=40
C5979 871 328 L=4e-06 W=4e-06 $[cap_mim_m3__base] $X=134905 $Y=35260 $dt=40
C5980 871 329 L=4e-06 W=4e-06 $[cap_mim_m3__base] $X=134905 $Y=43540 $dt=40
C5981 871 330 L=4e-06 W=4e-06 $[cap_mim_m3__base] $X=134905 $Y=51820 $dt=40
C5982 871 331 L=4e-06 W=4e-06 $[cap_mim_m3__base] $X=134905 $Y=60100 $dt=40
C5983 308 324 L=4e-06 W=4e-06 $[cap_mim_m3__base] $X=134905 $Y=68380 $dt=40
C5984 324 308 L=4e-06 W=4e-06 $[cap_mim_m3__base] $X=134905 $Y=76660 $dt=40
C5985 308 324 L=4e-06 W=4e-06 $[cap_mim_m3__base] $X=134905 $Y=84940 $dt=40
C5986 324 308 L=4e-06 W=4e-06 $[cap_mim_m3__base] $X=134905 $Y=93220 $dt=40
C5987 308 324 L=4e-06 W=4e-06 $[cap_mim_m3__base] $X=134905 $Y=101500 $dt=40
C5988 871 332 L=4e-06 W=4e-06 $[cap_mim_m3__base] $X=134905 $Y=109780 $dt=40
C5989 871 333 L=4e-06 W=4e-06 $[cap_mim_m3__base] $X=134905 $Y=118060 $dt=40
C5990 871 334 L=4e-06 W=4e-06 $[cap_mim_m3__base] $X=134905 $Y=126340 $dt=40
C5991 871 335 L=4e-06 W=4e-06 $[cap_mim_m3__base] $X=134905 $Y=134620 $dt=40
C5992 871 336 L=4e-06 W=4e-06 $[cap_mim_m3__base] $X=134905 $Y=142900 $dt=40
C5993 871 337 L=4e-06 W=4e-06 $[cap_mim_m3__base] $X=134905 $Y=151180 $dt=40
C5994 871 338 L=4e-06 W=4e-06 $[cap_mim_m3__base] $X=134905 $Y=159460 $dt=40
C5995 324 3 L=4e-06 W=4e-06 $[cap_mim_m3__base] $X=134905 $Y=167740 $dt=40
C5996 324 3 L=4e-06 W=4e-06 $[cap_mim_m3__base] $X=143185 $Y=2140 $dt=40
C5997 871 310 L=4e-06 W=4e-06 $[cap_mim_m3__base] $X=143185 $Y=10420 $dt=40
C5998 871 311 L=4e-06 W=4e-06 $[cap_mim_m3__base] $X=143185 $Y=18700 $dt=40
C5999 871 312 L=4e-06 W=4e-06 $[cap_mim_m3__base] $X=143185 $Y=26980 $dt=40
C6000 871 313 L=4e-06 W=4e-06 $[cap_mim_m3__base] $X=143185 $Y=35260 $dt=40
C6001 871 314 L=4e-06 W=4e-06 $[cap_mim_m3__base] $X=143185 $Y=43540 $dt=40
C6002 871 315 L=4e-06 W=4e-06 $[cap_mim_m3__base] $X=143185 $Y=51820 $dt=40
C6003 871 316 L=4e-06 W=4e-06 $[cap_mim_m3__base] $X=143185 $Y=60100 $dt=40
C6004 324 308 L=4e-06 W=4e-06 $[cap_mim_m3__base] $X=143185 $Y=68380 $dt=40
C6005 308 324 L=4e-06 W=4e-06 $[cap_mim_m3__base] $X=143185 $Y=76660 $dt=40
C6006 324 308 L=4e-06 W=4e-06 $[cap_mim_m3__base] $X=143185 $Y=84940 $dt=40
C6007 308 324 L=4e-06 W=4e-06 $[cap_mim_m3__base] $X=143185 $Y=93220 $dt=40
C6008 324 308 L=4e-06 W=4e-06 $[cap_mim_m3__base] $X=143185 $Y=101500 $dt=40
C6009 871 317 L=4e-06 W=4e-06 $[cap_mim_m3__base] $X=143185 $Y=109780 $dt=40
C6010 871 318 L=4e-06 W=4e-06 $[cap_mim_m3__base] $X=143185 $Y=118060 $dt=40
C6011 871 319 L=4e-06 W=4e-06 $[cap_mim_m3__base] $X=143185 $Y=126340 $dt=40
C6012 871 320 L=4e-06 W=4e-06 $[cap_mim_m3__base] $X=143185 $Y=134620 $dt=40
C6013 871 321 L=4e-06 W=4e-06 $[cap_mim_m3__base] $X=143185 $Y=142900 $dt=40
C6014 871 322 L=4e-06 W=4e-06 $[cap_mim_m3__base] $X=143185 $Y=151180 $dt=40
C6015 871 323 L=4e-06 W=4e-06 $[cap_mim_m3__base] $X=143185 $Y=159460 $dt=40
C6016 308 3 L=4e-06 W=4e-06 $[cap_mim_m3__base] $X=143185 $Y=167740 $dt=40
C6017 1 3 L=4e-06 W=4e-06 $[cap_mim_m3__base] $X=151465 $Y=10420 $dt=40
C6018 1 3 L=4e-06 W=4e-06 $[cap_mim_m3__base] $X=151465 $Y=18700 $dt=40
C6019 1 3 L=4e-06 W=4e-06 $[cap_mim_m3__base] $X=151465 $Y=26980 $dt=40
C6020 1 3 L=4e-06 W=4e-06 $[cap_mim_m3__base] $X=151465 $Y=35260 $dt=40
C6021 1 3 L=4e-06 W=4e-06 $[cap_mim_m3__base] $X=151465 $Y=43540 $dt=40
C6022 1 3 L=4e-06 W=4e-06 $[cap_mim_m3__base] $X=151465 $Y=51820 $dt=40
C6023 1 3 L=4e-06 W=4e-06 $[cap_mim_m3__base] $X=151465 $Y=60100 $dt=40
C6024 1 3 L=4e-06 W=4e-06 $[cap_mim_m3__base] $X=151465 $Y=68380 $dt=40
C6025 1 3 L=4e-06 W=4e-06 $[cap_mim_m3__base] $X=151465 $Y=76660 $dt=40
C6026 1 3 L=4e-06 W=4e-06 $[cap_mim_m3__base] $X=151465 $Y=84940 $dt=40
C6027 1 3 L=4e-06 W=4e-06 $[cap_mim_m3__base] $X=151465 $Y=93220 $dt=40
C6028 1 3 L=4e-06 W=4e-06 $[cap_mim_m3__base] $X=151465 $Y=101500 $dt=40
C6029 1 3 L=4e-06 W=4e-06 $[cap_mim_m3__base] $X=151465 $Y=109780 $dt=40
C6030 1 3 L=4e-06 W=4e-06 $[cap_mim_m3__base] $X=151465 $Y=118060 $dt=40
C6031 1 3 L=4e-06 W=4e-06 $[cap_mim_m3__base] $X=151465 $Y=126340 $dt=40
C6032 1 3 L=4e-06 W=4e-06 $[cap_mim_m3__base] $X=151465 $Y=134620 $dt=40
C6033 1 3 L=4e-06 W=4e-06 $[cap_mim_m3__base] $X=151465 $Y=142900 $dt=40
C6034 1 3 L=4e-06 W=4e-06 $[cap_mim_m3__base] $X=151465 $Y=151180 $dt=40
C6035 1 3 L=4e-06 W=4e-06 $[cap_mim_m3__base] $X=151465 $Y=159460 $dt=40
.ends CDAC_DEM
