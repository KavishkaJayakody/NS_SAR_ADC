* +++++++++++++++++++++++++++++++++++++++++++++++++++++ *
* CDL Netlist:                                          *
*                                                       *
* Cell Name  : unit_capacitor                           *
* Netlisted  : Wed Jul 15 21:54:36 2026                 *
* PVS Version: 16.10-p006 Thu Jul 27 18:05:02 PDT 2017 *
* +++++++++++++++++++++++++++++++++++++++++++++++++++++ *
*.LDD
*.DEVTMPLT 0 R(res_generic_m1) met1_res met1(P) met1(N)
*.DEVTMPLT 1 R(res_generic_m2) met2_res met2(P) met2(N)
*.DEVTMPLT 2 R(res_generic_m3) met3_res met3(P) met3(N)
*.DEVTMPLT 3 R(res_generic_m4) met4_res met4(P) met4(N)
*.DEVTMPLT 4 R(res_generic_m5) met5_res met5(P) met5(N)
*.DEVTMPLT 5 D(diode_pd2nw_05v5) diode_pd2nw_05v5_rec psd(PLUS) nwell(MINUS)
*.DEVTMPLT 6 D(diode_pd2nw_05v5_hvt) diode_pd2nw_05v5_hvt_rec psd(PLUS) nwell(MINUS)
*.DEVTMPLT 7 D(diode_pd2nw_05v5_lvt) diode_pd2nw_05v5_lvt_rec psd(PLUS) nwell(MINUS)
*.DEVTMPLT 8 D(diode_pd2nw_11v0) diode_pd2nw_11v0_rec psd(PLUS) nwell(MINUS)
*.DEVTMPLT 9 D(diode_pw2nd_05v5) diode_pw2nd_05v5_rec pwell_all(PLUS) nsd(MINUS)
*.DEVTMPLT 10 D(diode_pw2nd_05v5_lvt) diode_pw2nd_05v5_lvt_rec pwell_all(PLUS) nsd(MINUS)
*.DEVTMPLT 11 D(diode_pw2nd_05v5_nvt) diode_pw2nd_05v5_nvt_rec pwell_all(PLUS) nsd(MINUS)
*.DEVTMPLT 12 D(diode_pw2nd_11v0) diode_pw2nd_11v0_rec pwell_all(PLUS) nsd(MINUS)
*.DEVTMPLT 13 R(RES_GENERIC_ND) diff_res np_term(P) np_term(N)
*.DEVTMPLT 14 R(RES_GENERIC_PD) diff_res pp_term(P) pp_term(N)
*.DEVTMPLT 15 MN(nfet_01v8) nfet_01v8_rec nSourceDrain(D) nfet(G) nSourceDrain(S) pwell_all(B)
*.DEVTMPLT 16 MP(pfet_01v8) pfet_01v8_rec pSourceDrain(D) pfet(G) pSourceDrain(S) nwell(B)
*.DEVTMPLT 17 MP(pfet_01v8_lvt) lvtpfet_01v8_rec pSourceDrain(D) lvtpfet(G) pSourceDrain(S) nwell(B)
*.DEVTMPLT 18 MN(nfet_01v8_lvt) lvtnfet_01v8_rec nSourceDrain(D) lvtnfet(G) nSourceDrain(S) pwell_all(B)
*.DEVTMPLT 19 MP(pfet_01v8_hvt) hvtpfet_01v8_rec pSourceDrain(D) hvtpfet(G) pSourceDrain(S) nwell(B)
*.DEVTMPLT 20 MN(nfet_03v3_nvt) HV_ngate_3v3 HV_source_drain(D) HV_FET_gate(G) HV_source_drain(S) pwell_all(B)
*.DEVTMPLT 21 MN(nfet_05v0_nvt) HV_ngate_5v0 HV_source_drain(D) HV_FET_gate(G) HV_source_drain(S) pwell_all(B)
*.DEVTMPLT 22 MN(nfet_g5v0d10v5) HV_ngate_5v10v HV_source_drain(D) HV_FET_gate(G) HV_source_drain(S) pwell_all(B)
*.DEVTMPLT 23 MP(pfet_g5v0d10v5) HV_pgate_5v10v HV_source_drain(D) HV_FET_gate(G) HV_source_drain(S) nwell(B)
*.DEVTMPLT 24 MN(nfet_20v0) nfet_v20_rec nfet_v20_drain(D) nfet_v20_gate(G) nfet_v20_source(S) pwell_all(B)
*.DEVTMPLT 25 MN(nfet_20v0_zvt) nfet_v20_zvt_rec nfet_v20_drain(D) nfet_v20_gate(G) nfet_v20_source(S) pwell_all(B)
*.DEVTMPLT 26 MP(pfet_20v0) pfet_v20_rec pfet_v20_drain(D) pfet_v20_gate(G) pfet_v20_source(S) nwell(B)
*.DEVTMPLT 27 Q(npn_05v5) npn_rec npnC(C) npnB(B) npnE(E) pwell_all(BN)
*.DEVTMPLT 28 Q(npn_11v0) hvnpn_rec npnC(C) npnB(B) hvnpnE(E) pwell_all(BN)
*.DEVTMPLT 29 Q(pnp_05v5) pnp_rec pnpC(C) pnpB(B) pnpE(E) pwell_all(BN)
*.DEVTMPLT 30 R(res_high_po_0p35) res_high_po_0p35_rec prec_resistor_term(PLUS) prec_resistor_term(MINUS) pwell_all(B)
*.DEVTMPLT 31 R(res_high_po_0p69) res_high_po_0p69_rec prec_resistor_term(PLUS) prec_resistor_term(MINUS) pwell_all(B)
*.DEVTMPLT 32 R(res_high_po_1p41) res_high_po_1p41_rec prec_resistor_term(PLUS) prec_resistor_term(MINUS) pwell_all(B)
*.DEVTMPLT 33 R(res_high_po_2p85) res_high_po_2p85_rec prec_resistor_term(PLUS) prec_resistor_term(MINUS) pwell_all(B)
*.DEVTMPLT 34 R(res_high_po_5p73) res_high_po_5p73_rec prec_resistor_term(PLUS) prec_resistor_term(MINUS) pwell_all(B)
*.DEVTMPLT 35 R(res_xhigh_po_0p35) res_xhigh_po_0p35_rec prec_resistor_term(PLUS) prec_resistor_term(MINUS) pwell_all(B)
*.DEVTMPLT 36 R(res_xhigh_po_0p69) res_xhigh_po_0p69_rec prec_resistor_term(PLUS) prec_resistor_term(MINUS) pwell_all(B)
*.DEVTMPLT 37 R(res_xhigh_po_1p41) res_xhigh_po_1p41_rec prec_resistor_term(PLUS) prec_resistor_term(MINUS) pwell_all(B)
*.DEVTMPLT 38 R(res_xhigh_po_2p85) res_xhigh_po_2p85_rec prec_resistor_term(PLUS) prec_resistor_term(MINUS) pwell_all(B)
*.DEVTMPLT 39 R(res_xhigh_po_5p73) res_xhigh_po_5p73_rec prec_resistor_term(PLUS) prec_resistor_term(MINUS) pwell_all(B)
*.DEVTMPLT 40 C(cap_mim_m3__base) capacitor top_plate(PLUS) bottom_plate(MINUS)

* +++++++++++++++++++++++++++++++++++++++++++++++++++++ *
* Sub cell: cap_mim_m3__base$$9                         *
* +++++++++++++++++++++++++++++++++++++++++++++++++++++ *
.subckt cap_mim_m3__base$$9
** N=2 EP=0 FDC=1
C0 2 1 L=4e-06 W=4e-06 $[cap_mim_m3__base] $X=0 $Y=0 $dt=40
.ends cap_mim_m3__base$$9

* +++++++++++++++++++++++++++++++++++++++++++++++++++++ *
* Sub cell: pfet_01v8$$10                               *
* +++++++++++++++++++++++++++++++++++++++++++++++++++++ *
.subckt pfet_01v8$$10 1 2 3 5
** N=9 EP=4 FDC=1
M0 3 1 2 5 pfet_01v8 L=1.5e-07 W=1.5e-06 $X=0 $Y=0 $dt=16
.ends pfet_01v8$$10

* +++++++++++++++++++++++++++++++++++++++++++++++++++++ *
* Sub cell: nfet_01v8$$11                               *
* +++++++++++++++++++++++++++++++++++++++++++++++++++++ *
.subckt nfet_01v8$$11 1 2 3 4
** N=8 EP=4 FDC=1
M0 2 1 3 4 nfet_01v8 L=1.5e-07 W=1.5e-06 $X=0 $Y=0 $dt=15
.ends nfet_01v8$$11

* +++++++++++++++++++++++++++++++++++++++++++++++++++++ *
* Sub cell: pfet_01v8$$12                               *
* +++++++++++++++++++++++++++++++++++++++++++++++++++++ *
.subckt pfet_01v8$$12 1 2 3 5
** N=13 EP=4 FDC=1
M0 3 1 2 5 pfet_01v8 L=1.5e-07 W=1.5e-06 $X=0 $Y=0 $dt=16
.ends pfet_01v8$$12

* +++++++++++++++++++++++++++++++++++++++++++++++++++++ *
* Sub cell: nfet_01v8$$13                               *
* +++++++++++++++++++++++++++++++++++++++++++++++++++++ *
.subckt nfet_01v8$$13 1 2 3 4
** N=12 EP=4 FDC=1
M0 3 1 2 4 nfet_01v8 L=1.5e-07 W=1.5e-06 $X=0 $Y=0 $dt=15
.ends nfet_01v8$$13

* +++++++++++++++++++++++++++++++++++++++++++++++++++++ *
* Sub cell: unit_capacitor                              *
* +++++++++++++++++++++++++++++++++++++++++++++++++++++ *
.subckt unit_capacitor SEL_VIN SEL_VIN_N SEL_VREF_N SEL_VREF_N_N SEL_VREF_P SEL_VREF_P_N VDD VIN VREF_N VREF_P
+ VSS top_plate
** N=14 EP=12 FDC=9
X22 cap_mim_m3__base$$9 $T=10500 1200 0 0 $X=10100 $Y=800
X23 SEL_VIN_N VIN 11 VDD pfet_01v8$$10 $T=1645 275 1 180 $X=1260 $Y=95
X24 SEL_VIN 10 10 VDD pfet_01v8$$10 $T=6495 275 0 0 $X=6050 $Y=95
X25 SEL_VIN_N 11 11 VSS nfet_01v8$$11 $T=1495 4625 0 0 $X=1430 $Y=4475
X26 SEL_VIN VIN 10 VSS nfet_01v8$$11 $T=6645 4625 1 180 $X=6090 $Y=4475
X27 SEL_VREF_P_N 11 VREF_P VDD pfet_01v8$$12 $T=1215 275 1 180 $X=620 $Y=95
X28 SEL_VREF_N_N 10 VREF_N VDD pfet_01v8$$12 $T=6925 275 0 0 $X=6520 $Y=95
X29 SEL_VREF_P VREF_P 11 VSS nfet_01v8$$13 $T=1065 4625 0 0 $X=660 $Y=4475
X30 SEL_VREF_N VREF_N 10 VSS nfet_01v8$$13 $T=7075 4625 1 180 $X=6670 $Y=4475
.ends unit_capacitor
