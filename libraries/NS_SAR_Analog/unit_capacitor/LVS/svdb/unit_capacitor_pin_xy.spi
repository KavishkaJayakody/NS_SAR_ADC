* +++++++++++++++++++++++++++++++++++++++++++++++++++++ *
* CDL Netlist:                                          *
*                                                       *
* Cell Name  : unit_capacitor                           *
* Netlisted  : Tue Jul 14 01:11:58 2026                 *
* PVS Version: 16.10-p006 Thu Jul 27 18:05:02 PDT 2017 *
* +++++++++++++++++++++++++++++++++++++++++++++++++++++ *
*.LDD
*.DEVTMPLT 0 R(res_generic_m1) met1_res met1(P) met1(N)
*.DEVTMPLT 1 R(res_generic_m2) met2_res met2(P) met2(N)
*.DEVTMPLT 2 R(res_generic_m3) met3_res met3(P) met3(N)
*.DEVTMPLT 3 R(res_generic_m4) met4_res met4(P) met4(N)
*.DEVTMPLT 4 R(res_generic_m5) met5_res met5(P) met5(N)
*.DEVTMPLT 5 D(diode_pd2nw_05v5) diode_pd2nw_05v5_rec psd(PLUS) nwell(MINUS)
*.DEVTMPLT 6 D(diode_pd2nw_05v5_hvt) diode_pd2nw_05v5_hvt_rec psd(PLUS) nwell(MINUS)
*.DEVTMPLT 7 D(diode_pd2nw_05v5_lvt) diode_pd2nw_05v5_lvt_rec psd(PLUS) nwell(MINUS)
*.DEVTMPLT 8 D(diode_pd2nw_11v0) diode_pd2nw_11v0_rec psd(PLUS) nwell(MINUS)
*.DEVTMPLT 9 D(diode_pw2nd_05v5) diode_pw2nd_05v5_rec pwell_all(PLUS) nsd(MINUS)
*.DEVTMPLT 10 D(diode_pw2nd_05v5_lvt) diode_pw2nd_05v5_lvt_rec pwell_all(PLUS) nsd(MINUS)
*.DEVTMPLT 11 D(diode_pw2nd_05v5_nvt) diode_pw2nd_05v5_nvt_rec pwell_all(PLUS) nsd(MINUS)
*.DEVTMPLT 12 D(diode_pw2nd_11v0) diode_pw2nd_11v0_rec pwell_all(PLUS) nsd(MINUS)
*.DEVTMPLT 13 R(RES_GENERIC_ND) diff_res np_term(P) np_term(N)
*.DEVTMPLT 14 R(RES_GENERIC_PD) diff_res pp_term(P) pp_term(N)
*.DEVTMPLT 15 MN(nfet_01v8) nfet_01v8_rec nSourceDrain(D) nfet(G) nSourceDrain(S) pwell_all(B)
*.DEVTMPLT 16 MP(pfet_01v8) pfet_01v8_rec pSourceDrain(D) pfet(G) pSourceDrain(S) nwell(B)
*.DEVTMPLT 17 MP(pfet_01v8_lvt) lvtpfet_01v8_rec pSourceDrain(D) lvtpfet(G) pSourceDrain(S) nwell(B)
*.DEVTMPLT 18 MN(nfet_01v8_lvt) lvtnfet_01v8_rec nSourceDrain(D) lvtnfet(G) nSourceDrain(S) pwell_all(B)
*.DEVTMPLT 19 MP(pfet_01v8_hvt) hvtpfet_01v8_rec pSourceDrain(D) hvtpfet(G) pSourceDrain(S) nwell(B)
*.DEVTMPLT 20 MN(nfet_03v3_nvt) HV_ngate_3v3 HV_source_drain(D) HV_FET_gate(G) HV_source_drain(S) pwell_all(B)
*.DEVTMPLT 21 MN(nfet_05v0_nvt) HV_ngate_5v0 HV_source_drain(D) HV_FET_gate(G) HV_source_drain(S) pwell_all(B)
*.DEVTMPLT 22 MN(nfet_g5v0d10v5) HV_ngate_5v10v HV_source_drain(D) HV_FET_gate(G) HV_source_drain(S) pwell_all(B)
*.DEVTMPLT 23 MP(pfet_g5v0d10v5) HV_pgate_5v10v HV_source_drain(D) HV_FET_gate(G) HV_source_drain(S) nwell(B)
*.DEVTMPLT 24 MN(nfet_20v0) nfet_v20_rec nfet_v20_drain(D) nfet_v20_gate(G) nfet_v20_source(S) pwell_all(B)
*.DEVTMPLT 25 MN(nfet_20v0_zvt) nfet_v20_zvt_rec nfet_v20_drain(D) nfet_v20_gate(G) nfet_v20_source(S) pwell_all(B)
*.DEVTMPLT 26 MP(pfet_20v0) pfet_v20_rec pfet_v20_drain(D) pfet_v20_gate(G) pfet_v20_source(S) nwell(B)
*.DEVTMPLT 27 Q(npn_05v5) npn_rec npnC(C) npnB(B) npnE(E) pwell_all(BN)
*.DEVTMPLT 28 Q(npn_11v0) hvnpn_rec npnC(C) npnB(B) hvnpnE(E) pwell_all(BN)
*.DEVTMPLT 29 Q(pnp_05v5) pnp_rec pnpC(C) pnpB(B) pnpE(E) pwell_all(BN)
*.DEVTMPLT 30 R(res_high_po_0p35) res_high_po_0p35_rec prec_resistor_term(PLUS) prec_resistor_term(MINUS) pwell_all(B)
*.DEVTMPLT 31 R(res_high_po_0p69) res_high_po_0p69_rec prec_resistor_term(PLUS) prec_resistor_term(MINUS) pwell_all(B)
*.DEVTMPLT 32 R(res_high_po_1p41) res_high_po_1p41_rec prec_resistor_term(PLUS) prec_resistor_term(MINUS) pwell_all(B)
*.DEVTMPLT 33 R(res_high_po_2p85) res_high_po_2p85_rec prec_resistor_term(PLUS) prec_resistor_term(MINUS) pwell_all(B)
*.DEVTMPLT 34 R(res_high_po_5p73) res_high_po_5p73_rec prec_resistor_term(PLUS) prec_resistor_term(MINUS) pwell_all(B)
*.DEVTMPLT 35 R(res_xhigh_po_0p35) res_xhigh_po_0p35_rec prec_resistor_term(PLUS) prec_resistor_term(MINUS) pwell_all(B)
*.DEVTMPLT 36 R(res_xhigh_po_0p69) res_xhigh_po_0p69_rec prec_resistor_term(PLUS) prec_resistor_term(MINUS) pwell_all(B)
*.DEVTMPLT 37 R(res_xhigh_po_1p41) res_xhigh_po_1p41_rec prec_resistor_term(PLUS) prec_resistor_term(MINUS) pwell_all(B)
*.DEVTMPLT 38 R(res_xhigh_po_2p85) res_xhigh_po_2p85_rec prec_resistor_term(PLUS) prec_resistor_term(MINUS) pwell_all(B)
*.DEVTMPLT 39 R(res_xhigh_po_5p73) res_xhigh_po_5p73_rec prec_resistor_term(PLUS) prec_resistor_term(MINUS) pwell_all(B)
*.DEVTMPLT 40 C(cap_mim_m3__base) capacitor top_plate(PLUS) bottom_plate(MINUS)

* +++++++++++++++++++++++++++++++++++++++++++++++++++++ *
* Sub cell: polyConn$$1                                 *
* +++++++++++++++++++++++++++++++++++++++++++++++++++++ *
.subckt polyConn$$1 1
** N=2 EP=1 FDC=0
.ends polyConn$$1

* +++++++++++++++++++++++++++++++++++++++++++++++++++++ *
* Sub cell: M1M2_C$$2                                   *
* +++++++++++++++++++++++++++++++++++++++++++++++++++++ *
.subckt M1M2_C$$2 1
** N=1 EP=1 FDC=0
.ends M1M2_C$$2

* +++++++++++++++++++++++++++++++++++++++++++++++++++++ *
* Sub cell: L1M1_C$$3                                   *
* +++++++++++++++++++++++++++++++++++++++++++++++++++++ *
.subckt L1M1_C$$3 1
** N=1 EP=1 FDC=0
.ends L1M1_C$$3

* +++++++++++++++++++++++++++++++++++++++++++++++++++++ *
* Sub cell: L1M1_C$$4                                   *
* +++++++++++++++++++++++++++++++++++++++++++++++++++++ *
.subckt L1M1_C$$4 1
** N=1 EP=1 FDC=0
.ends L1M1_C$$4

* +++++++++++++++++++++++++++++++++++++++++++++++++++++ *
* Sub cell: nwellTap$$5                                 *
* +++++++++++++++++++++++++++++++++++++++++++++++++++++ *
.subckt nwellTap$$5 1 2
** N=6 EP=2 FDC=0
.ends nwellTap$$5

* +++++++++++++++++++++++++++++++++++++++++++++++++++++ *
* Sub cell: subTap$$6                                   *
* +++++++++++++++++++++++++++++++++++++++++++++++++++++ *
.subckt subTap$$6 1
** N=5 EP=1 FDC=0
.ends subTap$$6

* +++++++++++++++++++++++++++++++++++++++++++++++++++++ *
* Sub cell: M1M2_C$$7                                   *
* +++++++++++++++++++++++++++++++++++++++++++++++++++++ *
.subckt M1M2_C$$7 1
** N=1 EP=1 FDC=0
.ends M1M2_C$$7

* +++++++++++++++++++++++++++++++++++++++++++++++++++++ *
* Sub cell: M2M3_C$$8                                   *
* +++++++++++++++++++++++++++++++++++++++++++++++++++++ *
.subckt M2M3_C$$8 1
** N=1 EP=1 FDC=0
.ends M2M3_C$$8

* +++++++++++++++++++++++++++++++++++++++++++++++++++++ *
* Sub cell: nfet_01v8$$10                               *
* +++++++++++++++++++++++++++++++++++++++++++++++++++++ *
.subckt nfet_01v8$$10 1 2 3 4
** N=12 EP=4 FDC=1
M0 3 1 2 4 nfet_01v8 L=1.5e-07 W=1.5e-06 $X=0 $Y=0 $dt=15
.ends nfet_01v8$$10

* +++++++++++++++++++++++++++++++++++++++++++++++++++++ *
* Sub cell: pfet_01v8$$11                               *
* +++++++++++++++++++++++++++++++++++++++++++++++++++++ *
.subckt pfet_01v8$$11 1 2 3 4 5
** N=13 EP=5 FDC=1
M0 3 1 2 5 pfet_01v8 L=1.5e-07 W=1.5e-06 $X=0 $Y=0 $dt=16
.ends pfet_01v8$$11

* +++++++++++++++++++++++++++++++++++++++++++++++++++++ *
* Sub cell: unit_capacitor                              *
* +++++++++++++++++++++++++++++++++++++++++++++++++++++ *
.subckt unit_capacitor 13 1 2 3 4 5 6 7 8 9
+ 11 12
** N=13 EP=12 FDC=9
X0 1 polyConn$$1 $T=1380 925 0 90 $X=1195 $Y=740
X1 2 polyConn$$1 $T=1380 6215 0 90 $X=1195 $Y=6030
X2 3 polyConn$$1 $T=2240 555 0 90 $X=2055 $Y=370
X3 4 polyConn$$1 $T=4160 5845 0 90 $X=3975 $Y=5660
X4 5 polyConn$$1 $T=5020 200 0 90 $X=4835 $Y=15
X5 6 polyConn$$1 $T=5020 5475 0 90 $X=4835 $Y=5290
X6 1 M1M2_C$$2 $T=1380 925 0 90 $X=1220 $Y=795
X7 2 M1M2_C$$2 $T=1380 6215 0 90 $X=1220 $Y=6085
X8 3 M1M2_C$$2 $T=2240 555 0 90 $X=2080 $Y=425
X9 4 M1M2_C$$2 $T=4160 5845 0 90 $X=4000 $Y=5715
X10 5 M1M2_C$$2 $T=5020 200 0 90 $X=4860 $Y=70
X11 6 M1M2_C$$2 $T=5020 5475 0 90 $X=4860 $Y=5345
X12 7 L1M1_C$$3 $T=555 185 0 0 $X=440 $Y=40
X13 7 L1M1_C$$3 $T=5845 6215 0 0 $X=5730 $Y=6070
X14 7 L1M1_C$$4 $T=1310 185 0 0 $X=1165 $Y=70
X15 7 L1M1_C$$4 $T=5090 6215 0 0 $X=4945 $Y=6100
X16 8 9 nwellTap$$5 $T=185 2075 0 0 $X=-80 $Y=1150
X17 9 subTap$$6 $T=6215 4315 0 0 $X=6005 $Y=3445
X18 10 M1M2_C$$7 $T=1355 3200 0 0 $X=1225 $Y=2880
X19 10 M1M2_C$$7 $T=2265 3200 0 0 $X=2135 $Y=2880
X20 10 M1M2_C$$7 $T=4135 3200 0 0 $X=4005 $Y=2880
X21 10 M1M2_C$$7 $T=5045 3200 0 0 $X=4915 $Y=2880
X22 10 M2M3_C$$8 $T=710 3200 0 0 $X=545 $Y=2815
X23 10 M2M3_C$$8 $T=5690 3200 0 0 $X=5525 $Y=2815
X24 2 11 10 9 nfet_01v8$$10 $T=1065 3575 0 0 $X=660 $Y=3425
X25 3 10 10 9 nfet_01v8$$10 $T=2405 3575 0 0 $X=2000 $Y=3425
X26 4 10 7 9 nfet_01v8$$10 $T=3995 3575 1 180 $X=3440 $Y=3425
X27 6 12 10 9 nfet_01v8$$10 $T=5335 3575 1 180 $X=4780 $Y=3425
X28 1 10 11 9 8 pfet_01v8$$11 $T=1215 1325 1 180 $X=620 $Y=1145
X29 3 7 10 9 8 pfet_01v8$$11 $T=2555 1325 1 180 $X=1960 $Y=1145
X30 4 10 10 9 8 pfet_01v8$$11 $T=3845 1325 0 0 $X=3400 $Y=1145
X31 5 10 12 9 8 pfet_01v8$$11 $T=5185 1325 0 0 $X=4740 $Y=1145
C0 13 10 L=4.5e-06 W=4.5e-06 $[cap_mim_m3__base] $X=950 $Y=950 $dt=40
.ends unit_capacitor
