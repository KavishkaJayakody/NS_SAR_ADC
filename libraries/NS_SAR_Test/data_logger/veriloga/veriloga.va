`include "constants.vams"
`include "disciplines.vams"

module adc_csv_logger(eoc, din);
    // Hardcode the port width to bypass the Virtuoso TE-4309 extraction error
    input eoc; electrical eoc;
    input [9:0] din; electrical [9:0] din;

    parameter real vth = 0.9;
    parameter string filename = "/home/user22/NS_SAR_ADC/simulation/adc_output.csv";

    integer fd;
    genvar i;
    integer decimal_val;

    analog begin
        // 1. Open the file when simulation starts
        @(initial_step) begin
            fd = $fopen(filename, "w");
            if (fd == 0) begin
                $strobe("ERROR: Could not open file %s", filename);
            end else begin
                $fstrobe(fd, "Time,DecimalCode");
            end
        end

        // 2. Trigger exactly on the EOC rising edge
        @(cross(V(eoc) - vth, +1)) begin
            decimal_val = 0;

            // Hardcode the loop limit (10) to match the fixed bus width
            for (i = 0; i < 10; i = i + 1) begin
                if (V(din[i]) > vth) begin
                    decimal_val = decimal_val + (1 << i);
                end
            end

            // 3. Write data to CSV
            if (fd != 0) begin
                $fstrobe(fd, "%e,%d", $abstime, decimal_val);
            end
        end

        // 4. Close the file when simulation ends
        @(final_step) begin
            if (fd != 0) begin
                $fclose(fd);
            end
        end
    end
endmodule
