// ============================================================================
// 10-bit Digital-to-Analog Converter (Behavioral)
// Converts a 10-bit digital bus to a differential analog output voltage
//
// BUS MAPPING:
//   din[9:0] = {d9(MSB), d8, d7, d6, d5, d4, d3, d2, d1, d0(LSB)}
//
// Transfer function:
//   dac_out = vrefn + (code / n_levels) * (vrefp - vrefn)
//   n_levels = 2^N  (set to 8 for 3-bit SAR, 1024 for 10-bit)
// ============================================================================
`include "constants.vams"
`include "disciplines.vams"

module dac_10bit(din, dac_out);

    input  [9:0] din;              // 10-bit digital input bus
    output dac_out;                // Analog output voltage

    electrical [9:0] din;
    electrical dac_out;

    parameter real vrefp    = 1.8;      // Positive reference voltage (supply rail)
    parameter real vrefn    = 0.0;      // Negative reference voltage (ground)
    parameter real vth      = 0.9;      // Logic threshold for input bits (Vref/2)
    parameter real n_levels = 8.0;      // 2^N: 8 for 3-bit SAR, 1024 for 10-bit
    parameter real trise    = 50e-12;   // Output transition time

    integer code;
    real vout;

    analog begin

        @(initial_step) begin
            code = 0;
            vout = vrefn;
        end

        // Re-sample all bits atomically on any bit edge crossing vth.
        // Using a delay equal to trise on the output means the output only
        // updates after the entire bus has settled past its transition window,
        // suppressing intermediate glitch codes.
        @(cross(V(din[9]) - vth, 0) or cross(V(din[8]) - vth, 0) or
          cross(V(din[7]) - vth, 0) or cross(V(din[6]) - vth, 0) or
          cross(V(din[5]) - vth, 0) or cross(V(din[4]) - vth, 0) or
          cross(V(din[3]) - vth, 0) or cross(V(din[2]) - vth, 0) or
          cross(V(din[1]) - vth, 0) or cross(V(din[0]) - vth, 0)) begin

            code = 0;
            if (V(din[9]) > vth) code = code + 512;
            if (V(din[8]) > vth) code = code + 256;
            if (V(din[7]) > vth) code = code + 128;
            if (V(din[6]) > vth) code = code + 64;
            if (V(din[5]) > vth) code = code + 32;
            if (V(din[4]) > vth) code = code + 16;
            if (V(din[3]) > vth) code = code + 8;
            if (V(din[2]) > vth) code = code + 4;
            if (V(din[1]) > vth) code = code + 2;
            if (V(din[0]) > vth) code = code + 1;

            vout = vrefn + (1.0 * code / n_levels) * (vrefp - vrefn);
        end

        // delay=trise: output starts updating only after inputs have settled
        V(dac_out) <+ transition(vout, trise, trise, trise);

    end

endmodule
