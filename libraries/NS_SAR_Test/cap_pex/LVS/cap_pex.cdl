***********************************************************
* CDL produced by pvsBuildNetlist on Jun 23 18:46:12 2026 *
***********************************************************

*pvsViewList = auCdl schematic
*pvsStopList = ("auCdl")
*pvsSimName  = auCdl

*.EXPAND_ON_M_FACTOR
*.MEGA

.subckt cap_pex bottom_plate top_plate
*PVSCELL netlisted from NS_SAR_Test cap_pex schematic
  CC0 top_plate bottom_plate cap_mim_m3__base l=4u w=4u m=1
.ends cap_pex

***********************************************************
*             Completed at Jun 23 18:46:12 2026           *
***********************************************************
