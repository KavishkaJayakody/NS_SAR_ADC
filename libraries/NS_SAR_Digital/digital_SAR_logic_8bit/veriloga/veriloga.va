// VerilogA for NS_SAR_Digital, digital_SAR_logic_8bit, veriloga

`include "constants.vams"
`include "disciplines.vams"

// Logic Levels
`define LOGIC_VIN        1.8
`define LOGIC_HIGH_Z_S   1.8
`define LOGIC_HIGH_Z_C   0.0
`define LOGIC_VREF_P     1.8
`define LOGIC_VREF_N     0.0
`define LOGIC_SAMPLE     1.8
`define LOGIC_HOLD       0.0
`define HIGH             1.8
`define LOW              0.0

module digital_SAR_logic_8bit(CLK1, CLK2, CLK3, COMP, C_COMP, B0, B1, B2, B3, B4, B5, B6, B7, CPC, CP0, CP1, CP2, CP3, CP4, CP5, CP6, CP7, CNC, CN0, CN1, CN2, CN3, CN4, CN5, CN6, CN7, SP, SN, VCM_CON, VCM_CON_N, PA_EN, PA_EN_N, EOC);
    input CLK1, CLK2, CLK3, COMP;
    output B0, B1, B2, B3, B4, B5, B6, B7;
    output VCM_CON, VCM_CON_N, PA_EN, PA_EN_N;
    output CPC, CP0, CP1, CP2, CP3, CP4, CP5, CP6, CP7;
    output CNC, CN0, CN1, CN2, CN3, CN4, CN5, CN6, CN7;
    output C_COMP, SP, SN, EOC;

    electrical CLK1, CLK2, CLK3, COMP, C_COMP, EOC, B0, B1, B2, B3, B4, B5, B6, B7, CPC, CP0, CP1, CP2, CP3, CP4, CP5, CP6, CP7, CNC, CN0, CN1, CN2, CN3, CN4, CN5, CN6, CN7, SP, SN, VCM_CON, VCM_CON_N, PA_EN, PA_EN_N;

    // Registers
    real regvcm, regpa;
    real regn0, regn1, regn2, regn3, regn4, regn5, regn6, regn7;
    real regp0, regp1, regp2, regp3, regp4, regp5, regp6, regp7;
    real dat0, dat1, dat2, dat3, dat4, dat5, dat6, dat7;
    real out0, out1, out2, out3, out4, out5, out6, out7, eoc;
    real regnc, regpc, regns, regps, comp_en;

    // Parameters
    parameter real Vth    = 0.9;
    parameter real td     = 1n;
    parameter real tr     = 1n;

    // FSM States
    integer state, next_state;
    parameter SAMPLE  = 0;
    parameter TRIAL_7 = 1;
    parameter STEP_6  = 2; parameter STEP_5 = 3; parameter STEP_4 = 4;
    parameter STEP_3  = 5; parameter STEP_2 = 6; parameter STEP_1 = 7;
    parameter STEP_0  = 8;
    parameter NS1     = 9;
    parameter NS2     = 10;
    parameter DONE    = 11;

    analog begin
        @(initial_step) begin
            state = SAMPLE;
            next_state = SAMPLE;
            comp_en = `LOW;
            regvcm = 0;
            regpa = 0;
            regn7=0; regn6=0; regn5=0; regn4=0; regn3=0; regn2=0; regn1=0; regn0=0;
            regp7=0; regp6=0; regp5=0; regp4=0; regp3=0; regp2=0; regp1=0; regp0=0;
            dat7=0;  dat6=0;  dat5=0;  dat4=0;  dat3=0;  dat2=0;  dat1=0;  dat0=0;
            out7=0;  out6=0;  out5=0;  out4=0;  out3=0;  out2=0;  out1=0;  out0=0;
            regnc=0; regpc=0; regns=0; regps=0; eoc=0;
        end

        // -------------------------------------------------------------
        // Continuous Multi-Phase Clock Combinational Gating
        // Evaluates dynamically across the transient simulation timeline
        // -------------------------------------------------------------
		// Only allow PA and Latch between TRIAL_7 and STEP_0
        regpa   = ((state >= TRIAL_7 && state <= STEP_0) && (V(CLK2) > Vth) && (V(CLK1) < Vth)) ? `HIGH : `LOW;
        comp_en = ((state >= TRIAL_7 && state <= STEP_0) && (V(CLK2) > Vth) && (V(CLK1) < Vth) && (V(CLK3) > Vth)) ? `HIGH : `LOW;

        // -------------------------------------------------------------
        // FSM Synchronous Strobe (Triggered on CLK1 Rising Edge)
        // -------------------------------------------------------------
        @(cross(V(CLK1) - Vth, +1)) begin
            state = next_state;

            if (state == SAMPLE) begin
                regvcm = `LOGIC_SAMPLE;
                regns  = `LOGIC_SAMPLE; regps = `LOGIC_SAMPLE;
                regnc  = `LOGIC_VIN;    regpc = `LOGIC_VIN;
                regn7  = `LOGIC_VIN; regn6 = `LOGIC_VIN; regn5 = `LOGIC_VIN; regn4 = `LOGIC_VIN;
                regn3  = `LOGIC_VIN; regn2 = `LOGIC_VIN; regn1 = `LOGIC_VIN; regn0 = `LOGIC_VIN;
                regp7  = `LOGIC_VIN; regp6 = `LOGIC_VIN; regp5 = `LOGIC_VIN; regp4 = `LOGIC_VIN;
                regp3  = `LOGIC_VIN; regp2 = `LOGIC_VIN; regp1 = `LOGIC_VIN; regp0 = `LOGIC_VIN;
                eoc    = `LOW;

                next_state = TRIAL_7;
            end
            else if (state == TRIAL_7) begin
                regvcm = `LOGIC_HOLD;
                regns  = `LOGIC_HOLD; regps = `LOGIC_HOLD;
                regn7  = `LOGIC_VREF_N; regp7 = `LOGIC_VREF_P;

                regn6 = `LOGIC_VREF_P; regn5 = `LOGIC_VREF_P; regn4 = `LOGIC_VREF_P;
                regn3 = `LOGIC_VREF_P; regn2 = `LOGIC_VREF_P; regn1 = `LOGIC_VREF_P; regn0 = `LOGIC_VREF_P; regnc = `LOGIC_VREF_P;

                regp6 = `LOGIC_VREF_N; regp5 = `LOGIC_VREF_N; regp4 = `LOGIC_VREF_N;
                regp3 = `LOGIC_VREF_N; regp2 = `LOGIC_VREF_N; regp1 = `LOGIC_VREF_N; regp0 = `LOGIC_VREF_N; regpc = `LOGIC_VREF_N;

                next_state = STEP_6;
            end
            else if (state == STEP_6) begin
                if (V(COMP) > Vth) begin dat7=`HIGH; regn7=`LOGIC_VREF_N; regp7=`LOGIC_VREF_P; end
                else               begin dat7=`LOW;  regn7=`LOGIC_VREF_P; regp7=`LOGIC_VREF_N; end
                regn6 = `LOGIC_VREF_N; regp6 = `LOGIC_VREF_P;
                next_state = STEP_5;
            end
            else if (state == STEP_5) begin
                if (V(COMP) > Vth) begin dat6=`HIGH; regn6=`LOGIC_VREF_N; regp6=`LOGIC_VREF_P; end
                else               begin dat6=`LOW;  regn6=`LOGIC_VREF_P; regp6=`LOGIC_VREF_N; end
                regn5 = `LOGIC_VREF_N; regp5 = `LOGIC_VREF_P;
                next_state = STEP_4;
            end
            else if (state == STEP_4) begin
                if (V(COMP) > Vth) begin dat5=`HIGH; regn5=`LOGIC_VREF_N; regp5=`LOGIC_VREF_P; end
                else               begin dat5=`LOW;  regn5=`LOGIC_VREF_P; regp5=`LOGIC_VREF_N; end
                regn4 = `LOGIC_VREF_N; regp4 = `LOGIC_VREF_P;
                next_state = STEP_3;
            end
            else if (state == STEP_3) begin
                if (V(COMP) > Vth) begin dat4=`HIGH; regn4=`LOGIC_VREF_N; regp4=`LOGIC_VREF_P; end
                else               begin dat4=`LOW;  regn4=`LOGIC_VREF_P; regp4=`LOGIC_VREF_N; end
                regn3 = `LOGIC_VREF_N; regp3 = `LOGIC_VREF_P;
                next_state = STEP_2;
            end
            else if (state == STEP_2) begin
                if (V(COMP) > Vth) begin dat3=`HIGH; regn3=`LOGIC_VREF_N; regp3=`LOGIC_VREF_P; end
                else               begin dat3=`LOW;  regn3=`LOGIC_VREF_P; regp3=`LOGIC_VREF_N; end
                regn2 = `LOGIC_VREF_N; regp2 = `LOGIC_VREF_P;
                next_state = STEP_1;
            end
            else if (state == STEP_1) begin
                if (V(COMP) > Vth) begin dat2=`HIGH; regn2=`LOGIC_VREF_N; regp2=`LOGIC_VREF_P; end
                else               begin dat2=`LOW;  regn2=`LOGIC_VREF_P; regp2=`LOGIC_VREF_N; end
                regn1 = `LOGIC_VREF_N; regp1 = `LOGIC_VREF_P;
                next_state = STEP_0;
            end
            else if (state == STEP_0) begin
                if (V(COMP) > Vth) begin dat1=`HIGH; regn1=`LOGIC_VREF_N; regp1=`LOGIC_VREF_P; end
                else               begin dat1=`LOW;  regn1=`LOGIC_VREF_P; regp1=`LOGIC_VREF_N; end
                regn0 = `LOGIC_VREF_N; regp0 = `LOGIC_VREF_P;
                next_state = NS1;
            end
            else if (state == NS1) begin
                if (V(COMP) > Vth) begin dat0=`HIGH; regn0=`LOGIC_VREF_N; regp0=`LOGIC_VREF_P; end
                else               begin dat0=`LOW;  regn0=`LOGIC_VREF_P; regp0=`LOGIC_VREF_N; end
                regnc = `LOGIC_VREF_N; regpc = `LOGIC_VREF_P;
                next_state = NS2;
            end
            else if (state == NS2) begin
                // Noise-shaping integration / residue hold phase
                next_state = DONE;
            end
            else if (state == DONE) begin
                out7=dat7; out6=dat6; out5=dat5; out4=dat4; out3=dat3; out2=dat2; out1=dat1; out0=dat0;
                eoc = `HIGH;
                next_state = SAMPLE;
            end
        end

        // -------------------------------------------------------------
        // Continuous Output Drivers
        // -------------------------------------------------------------
        V(B7) <+ transition(out7, td, tr); V(B6) <+ transition(out6, td, tr); V(B5) <+ transition(out5, td, tr);
        V(B4) <+ transition(out4, td, tr); V(B3) <+ transition(out3, td, tr); V(B2) <+ transition(out2, td, tr);
        V(B1) <+ transition(out1, td, tr); V(B0) <+ transition(out0, td, tr);

        V(CP7) <+ transition(regn7, td, tr); V(CP6) <+ transition(regn6, td, tr);
        V(CP5) <+ transition(regn5, td, tr); V(CP4) <+ transition(regn4, td, tr); V(CP3) <+ transition(regn3, td, tr);
        V(CP2) <+ transition(regn2, td, tr); V(CP1) <+ transition(regn1, td, tr); V(CP0) <+ transition(regn0, td, tr);

        V(CN7) <+ transition(regp7, td, tr); V(CN6) <+ transition(regp6, td, tr);
        V(CN5) <+ transition(regp5, td, tr); V(CN4) <+ transition(regp4, td, tr); V(CN3) <+ transition(regp3, td, tr);
        V(CN2) <+ transition(regp2, td, tr); V(CN1) <+ transition(regp1, td, tr); V(CN0) <+ transition(regp0, td, tr);

        V(CPC)       <+ transition(regnc, td, tr);
        V(CNC)       <+ transition(regpc, td, tr);
        V(SP)        <+ transition(regns, td, tr);
        V(SN)        <+ transition(regps, td, tr);
        V(VCM_CON)   <+ transition(regvcm, td, tr);
        V(VCM_CON_N) <+ transition((regvcm > Vth) ? `LOW : `HIGH, td, tr);
        V(PA_EN)     <+ transition(regpa, td, tr);
        V(PA_EN_N)   <+ transition((regpa > Vth) ? `LOW : `HIGH, td, tr);
        V(C_COMP)    <+ transition(comp_en, td, tr);
        V(EOC)       <+ transition(eoc, td, tr);
    end
endmodule
