// VerilogA for NS_SAR_analog, analog_comparator_latch, veriloga

`include "constants.vams"
`include "disciplines.vams"

module analog_comparator_latch (VIP, VIN, VDD, VSS, CLK, VOUT);

    // Pin Definitions
    input VIP, VIN, VDD, VSS, CLK;
    output VOUT;
    electrical VIP, VIN, VDD, VSS, CLK, VOUT;

    // Parameters
    parameter real td = 1p;         // Propagation delay
    parameter real tr = 1p;         // Rise/Fall time

    // Internal state variable
    real out_val;

    analog begin

        // Continuous comparison with Hysteresis
        // Logic: Only change state if the difference exceeds the hysteresis threshold
        if (V(VIP) > V(VIN)) begin
            out_val = V(VSS);
        end else begin
            out_val = V(VDD);
        end

        // Assign output with transition filter
        V(VOUT) <+ transition(out_val, td, tr);

    end

endmodule
