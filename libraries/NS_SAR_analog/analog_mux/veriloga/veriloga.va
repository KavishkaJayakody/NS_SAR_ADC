// VerilogA for FYP_22, analog_mux, veriloga

`include "constants.vams"
`include "disciplines.vams"

module analog_mux(OUT, VDD, VSS, CTRL, IN0, IN1);
    output OUT;
    input VDD, VSS, CTRL, IN0, IN1;
    electrical OUT, VDD, VSS, CTRL, IN0, IN1;

    // Parameters
    parameter real ron  = 0.001;     // On-resistance in Ohms
    parameter real roff = 1e12;     // Off-resistance (Giga-Ohms)
    parameter real vth  = 0.9;     // Threshold (e.g., VDD/2 for 3.3V logic)

    real r0, r1;

    analog begin
        // Multiplexer Logic
        if (V(CTRL) > vth) begin
            r0 = roff;
            r1 = ron;
        end else begin
            r0 = ron;
            r1 = roff;
        end

        // Contribution statements for the two internal switch paths
        I(IN0, OUT) <+ V(IN0, OUT) / r0;
        I(IN1, OUT) <+ V(IN1, OUT) / r1;

        // Static current for power rails (usually zero for ideal models)
        I(VDD, VSS) <+ 0;
    end

endmodule
