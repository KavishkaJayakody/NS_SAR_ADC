// VerilogA for FYP_22, analog_switch, veriloga

`include "constants.vams"
`include "disciplines.vams"

module analog_switch(INPUT, OUTPUT, VDD, VSS, CONTROL);
    inout INPUT, OUTPUT, VDD, VSS;
    input CONTROL;
    electrical INPUT, OUTPUT, VDD, VSS, CONTROL;

    // Parameters for tuning the switch behavior
    parameter real ron = 0.001;       // Resistance when switch is ON (Ohms)
    parameter real roff = 1e9;       // Resistance when switch is OFF (Ohms)
    parameter real vth = 0.9;        // Control voltage threshold (Volts)

    real r_eff;                      // Effective resistance

    analog begin
        // Determine the effective resistance based on CONTROL voltage
        // If V(CONTROL) > vth, switch is ON; else, it is OFF.
        if (V(CONTROL) > vth) begin
            r_eff = ron;
        end else begin
            r_eff = roff;
        end

        // Implementation of the branch contribution using Ohm's Law
        // I = V / R
        I(INPUT, OUTPUT) <+ V(INPUT, OUTPUT) / r_eff;

        // Optional: Ensure no current flows to VDD/VSS if they are just refs
        I(VDD) <+ 0;
        I(VSS) <+ 0;
    end

endmodule
